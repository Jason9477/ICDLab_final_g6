* SPICE NETLIST
***************************************

.SUBCKT L POS NEG SUB
.ENDS
***************************************
.SUBCKT XMD I SMT PU PD O
** N=6 EP=5 IP=0 FDC=0
.ENDS
***************************************
.SUBCKT ICV_1 1 11 12 13 14 15 16 17 18 19 20 21 22 23 24 25 26 27 57
** N=82 EP=19 IP=42 FDC=0
X0 13 1 1 1 14 XMD $T=229400 1200080 0 180 $X=169630 $Y=1060580
X1 15 1 1 1 16 XMD $T=318680 1200080 0 180 $X=258910 $Y=1060580
X2 17 18 18 18 19 XMD $T=675800 1200080 0 180 $X=616030 $Y=1060580
X3 20 18 18 18 21 XMD $T=765080 1200080 0 180 $X=705310 $Y=1060580
X4 22 11 11 11 23 XMD $T=854360 1200080 0 180 $X=794590 $Y=1060580
X5 24 12 11 11 25 XMD $T=943640 1200080 0 180 $X=883870 $Y=1060580
X6 26 12 12 12 27 XMD $T=1032920 1200080 0 180 $X=973150 $Y=1060580
.ENDS
***************************************
.SUBCKT YA2GSD O E2 E8 E4 I SR E
** N=8 EP=7 IP=0 FDC=0
.ENDS
***************************************
.SUBCKT TIE1 O VCC GND
** N=4 EP=3 IP=0 FDC=0
.ENDS
***************************************
.SUBCKT BUF1 I VCC GND O
** N=5 EP=4 IP=0 FDC=0
.ENDS
***************************************
.SUBCKT QDFFRBN D CK RB VCC GND Q
** N=7 EP=6 IP=0 FDC=0
.ENDS
***************************************
.SUBCKT INV3 I O GND VCC
** N=5 EP=4 IP=0 FDC=0
.ENDS
***************************************
.SUBCKT INV1S I VCC O GND
** N=5 EP=4 IP=0 FDC=0
.ENDS
***************************************
.SUBCKT FA1 S B VCC A CI GND CO
** N=8 EP=7 IP=0 FDC=0
.ENDS
***************************************
.SUBCKT FA1S CO VCC A B CI GND S
** N=8 EP=7 IP=0 FDC=0
.ENDS
***************************************
.SUBCKT NR2 I1 VCC O I2 GND
** N=6 EP=5 IP=0 FDC=0
.ENDS
***************************************
.SUBCKT OR2 I2 I1 VCC GND O
** N=6 EP=5 IP=0 FDC=0
.ENDS
***************************************
.SUBCKT ND2S I1 O I2 VCC GND
** N=6 EP=5 IP=0 FDC=0
.ENDS
***************************************
.SUBCKT OAI12H B2 B1 GND A1 O VCC
** N=7 EP=6 IP=0 FDC=0
.ENDS
***************************************
.SUBCKT AOI12H B2 B1 VCC O A1 GND
** N=7 EP=6 IP=0 FDC=0
.ENDS
***************************************
.SUBCKT XOR2HS I1 I2 O VCC GND
** N=6 EP=5 IP=0 FDC=0
.ENDS
***************************************
.SUBCKT XNR2HS I1 I2 O VCC GND
** N=6 EP=5 IP=0 FDC=0
.ENDS
***************************************
.SUBCKT MUX2 B S VCC GND O A
** N=7 EP=6 IP=0 FDC=0
.ENDS
***************************************
.SUBCKT DELB I GND VCC O
** N=5 EP=4 IP=0 FDC=0
.ENDS
***************************************
.SUBCKT AN2 I1 I2 GND VCC O
** N=6 EP=5 IP=0 FDC=0
.ENDS
***************************************
.SUBCKT AOI12HS B2 B1 VCC A1 GND O
** N=7 EP=6 IP=0 FDC=0
.ENDS
***************************************
.SUBCKT OA12 B2 B1 A1 GND VCC O
** N=7 EP=6 IP=0 FDC=0
.ENDS
***************************************
.SUBCKT QDFFRBS D CK RB VCC GND Q
** N=7 EP=6 IP=0 FDC=0
.ENDS
***************************************
.SUBCKT BUF1CK I GND VCC O
** N=5 EP=4 IP=0 FDC=0
.ENDS
***************************************
.SUBCKT FACS1S CO1 CI1 S CS CI0 CO0 GND A VCC B
** N=11 EP=10 IP=0 FDC=0
.ENDS
***************************************
.SUBCKT INV6CK I O GND VCC
** N=5 EP=4 IP=0 FDC=0
.ENDS
***************************************
.SUBCKT INV12CK I O GND VCC
** N=5 EP=4 IP=0 FDC=0
.ENDS
***************************************
.SUBCKT ICV_2 1 2 3 4 5 6 8 9 10 11 12 13 14 15 16 17 18 19 20 21
+ 22 24 25 26 28 29 31 32 33 34 35 36 38 39 41 42 43 45 46 47
+ 48 49 50 51 52 54 55 56 57 58 59 61 62 63 64 65 66 68 69 70
+ 71 72 73 74 75 76 77 78 79 80 81 82 83 84 85 86 87 88 89 90
+ 91 92 93 94 95 96 97 98 99 100 101 102 103 104 105 106 107 137
** N=191 EP=98 IP=525 FDC=0
X0 106 104 104 104 107 103 105 YA2GSD $T=1199700 970640 0 90 $X=1060200 $Y=973490
X1 105 2 1 TIE1 $T=975260 961080 0 0 $X=975260 $Y=960700
X2 8 2 1 3 BUF1 $T=230020 971160 0 0 $X=230020 $Y=970780
X3 34 2 1 38 BUF1 $T=438340 961080 0 0 $X=438340 $Y=960700
X4 73 2 1 75 BUF1 $T=607600 971160 1 0 $X=607600 $Y=965740
X5 99 2 1 98 BUF1 $T=819020 971160 1 180 $X=816540 $Y=970780
X6 73 2 1 100 BUF1 $T=841960 961080 0 0 $X=841960 $Y=960700
X7 103 2 1 99 BUF1 $T=916980 971160 1 180 $X=914500 $Y=970780
X8 104 2 1 103 BUF1 $T=970920 971160 1 180 $X=968440 $Y=970780
X9 21 22 19 2 1 140 QDFFRBN $T=330460 961080 0 0 $X=330460 $Y=960700
X10 25 22 24 2 1 139 QDFFRBN $T=361460 971160 0 180 $X=349680 $Y=965740
X11 144 22 34 2 1 36 QDFFRBN $T=417880 961080 0 0 $X=417880 $Y=960700
X12 35 22 38 2 1 145 QDFFRBN $T=430900 971160 0 0 $X=430900 $Y=970780
X13 39 22 38 2 1 146 QDFFRBN $T=440820 971160 1 0 $X=440820 $Y=965740
X14 51 50 48 2 1 152 QDFFRBN $T=510880 961080 1 180 $X=499100 $Y=960700
X15 156 50 49 2 1 155 QDFFRBN $T=513360 971160 1 180 $X=501580 $Y=970780
X16 56 50 49 2 1 52 QDFFRBN $T=525140 961080 1 180 $X=513360 $Y=960700
X17 159 50 49 2 1 157 QDFFRBN $T=533200 971160 1 180 $X=521420 $Y=970780
X18 171 74 73 2 1 170 QDFFRBN $T=607600 971160 1 180 $X=595820 $Y=970780
X19 173 74 75 2 1 172 QDFFRBN $T=623720 971160 0 180 $X=611940 $Y=965740
X20 178 74 80 2 1 175 QDFFRBN $T=659060 971160 1 180 $X=647280 $Y=970780
X21 179 74 80 2 1 81 QDFFRBN $T=664640 961080 1 180 $X=652860 $Y=960700
X22 181 74 80 2 1 78 QDFFRBN $T=677660 971160 1 180 $X=665880 $Y=970780
X23 97 96 73 2 1 190 QDFFRBN $T=806000 971160 0 180 $X=794220 $Y=965740
X24 102 96 100 2 1 101 QDFFRBN $T=884740 961080 1 180 $X=872960 $Y=960700
X25 139 20 1 2 INV3 $T=331700 971160 0 180 $X=329220 $Y=965740
X26 190 95 1 2 INV3 $T=779960 961080 1 180 $X=777480 $Y=960700
X27 138 2 16 1 INV1S $T=291400 971160 0 0 $X=291400 $Y=970780
X28 17 2 18 1 INV1S $T=311240 971160 0 0 $X=311240 $Y=970780
X29 18 2 19 1 INV1S $T=323020 961080 0 0 $X=323020 $Y=960700
X30 18 2 34 1 INV1S $T=422220 971160 0 0 $X=422220 $Y=970780
X31 146 2 147 1 INV1S $T=453840 971160 1 0 $X=453840 $Y=965740
X32 145 2 148 1 INV1S $T=453840 971160 0 0 $X=453840 $Y=970780
X33 62 2 160 1 INV1S $T=543740 961080 1 180 $X=542500 $Y=960700
X34 166 2 165 1 INV1S $T=567920 971160 1 180 $X=566680 $Y=970780
X35 69 2 169 1 INV1S $T=581560 971160 0 0 $X=581560 $Y=970780
X36 172 2 65 1 INV1S $T=591480 961080 1 180 $X=590240 $Y=960700
X37 170 2 168 1 INV1S $T=591480 971160 1 180 $X=590240 $Y=970780
X38 76 2 174 1 INV1S $T=626200 971160 1 0 $X=626200 $Y=965740
X39 175 2 177 1 INV1S $T=642320 971160 1 180 $X=641080 $Y=970780
X40 87 2 182 1 INV1S $T=707420 961080 1 180 $X=706180 $Y=960700
X41 84 2 85 1 INV1S $T=709280 971160 1 0 $X=709280 $Y=965740
X42 88 2 185 1 INV1S $T=716100 971160 0 180 $X=714860 $Y=965740
X43 186 2 184 1 INV1S $T=726640 971160 1 180 $X=725400 $Y=970780
X44 187 2 189 1 INV1S $T=739040 961080 0 0 $X=739040 $Y=960700
X45 91 2 188 1 INV1S $T=750820 961080 0 0 $X=750820 $Y=960700
X46 93 2 94 1 INV1S $T=761360 961080 0 0 $X=761360 $Y=960700
X47 171 175 2 174 176 1 77 FA1 $T=622480 971160 0 0 $X=622480 $Y=970780
X48 173 78 2 177 79 1 176 FA1 $T=649140 961080 1 180 $X=633640 $Y=960700
X49 179 189 2 188 92 1 183 FA1 $T=754540 971160 1 180 $X=739040 $Y=970780
X50 141 2 140 28 26 1 142 FA1S $T=358980 961080 0 0 $X=358980 $Y=960700
X51 83 2 182 82 180 1 178 FA1S $T=693780 971160 0 180 $X=682000 $Y=965740
X52 180 2 184 185 183 1 181 FA1S $T=708660 971160 1 180 $X=696880 $Y=970780
X53 186 2 86 90 89 1 187 FA1S $T=721680 961080 0 0 $X=721680 $Y=960700
X54 153 2 45 154 1 NR2 $T=479880 971160 0 0 $X=479880 $Y=970780
X55 71 2 70 72 1 NR2 $T=584040 961080 0 0 $X=584040 $Y=960700
X56 169 2 167 170 1 NR2 $T=585280 971160 1 0 $X=585280 $Y=965740
X57 149 41 2 1 150 OR2 $T=460040 971160 1 0 $X=460040 $Y=965740
X58 148 152 2 1 153 OR2 $T=479880 961080 0 0 $X=479880 $Y=960700
X59 147 155 2 1 47 OR2 $T=493520 961080 0 0 $X=493520 $Y=960700
X60 168 69 2 1 164 OR2 $T=580320 971160 0 180 $X=577840 $Y=965740
X61 141 33 32 2 1 ND2S $T=404860 961080 0 0 $X=404860 $Y=960700
X62 154 46 153 2 1 ND2S $T=487320 961080 0 0 $X=487320 $Y=960700
X63 160 158 61 2 1 ND2S $T=542500 971160 1 0 $X=542500 $Y=965740
X64 65 61 64 2 1 ND2S $T=557380 971160 1 0 $X=557380 $Y=965740
X65 164 163 166 2 1 ND2S $T=561100 971160 0 0 $X=561100 $Y=970780
X66 168 166 69 2 1 ND2S $T=574740 971160 0 0 $X=574740 $Y=970780
X67 62 58 1 61 162 2 OAI12H $T=548080 971160 1 0 $X=548080 $Y=965740
X68 167 63 1 164 68 2 OAI12H $T=574740 971160 0 180 $X=568540 $Y=965740
X69 164 162 2 66 165 1 AOI12H $T=561720 961080 0 0 $X=561720 $Y=960700
X70 158 58 56 2 1 XOR2HS $T=540020 961080 1 180 $X=534440 $Y=960700
X71 163 63 161 2 1 XOR2HS $T=558000 971160 1 180 $X=552420 $Y=970780
X72 152 148 149 2 1 XNR2HS $T=476780 961080 1 180 $X=471200 $Y=960700
X73 155 147 154 2 1 XNR2HS $T=491040 971160 1 180 $X=485460 $Y=970780
X74 158 55 54 2 1 XNR2HS $T=532580 971160 0 180 $X=527000 $Y=965740
X75 163 162 159 2 1 XNR2HS $T=551180 971160 1 180 $X=545600 $Y=970780
X76 161 59 2 1 57 159 MUX2 $T=541880 971160 1 180 $X=537540 $Y=970780
X77 157 1 2 156 DELB $T=513360 971160 0 0 $X=513360 $Y=970780
X78 149 41 1 2 151 AN2 $T=466860 971160 0 0 $X=466860 $Y=970780
X79 150 42 2 151 1 43 AOI12HS $T=465000 961080 0 0 $X=465000 $Y=960700
X80 32 141 33 1 2 144 OA12 $T=403000 971160 0 0 $X=403000 $Y=970780
X81 143 22 29 2 1 31 QDFFRBS $T=376960 971160 1 0 $X=376960 $Y=965740
X82 142 1 2 143 BUF1CK $T=370760 961080 0 0 $X=370760 $Y=960700
X83 9 11 13 14 15 138 1 10 2 12 FACS1S $T=251100 971160 1 0 $X=251100 $Y=965740
X84 5 6 1 2 INV6CK $T=221960 961080 0 0 $X=221960 $Y=960700
X85 4 5 1 2 INV12CK $T=220100 971160 0 0 $X=220100 $Y=970780
.ENDS
***************************************
.SUBCKT OR2B1S I1 B1 GND O VCC
** N=6 EP=5 IP=0 FDC=0
.ENDS
***************************************
.SUBCKT ND2 I1 O I2 GND VCC
** N=6 EP=5 IP=0 FDC=0
.ENDS
***************************************
.SUBCKT OAI12HS B2 B1 GND A1 VCC O
** N=7 EP=6 IP=0 FDC=0
.ENDS
***************************************
.SUBCKT OAI22S B2 GND B1 A2 O A1 VCC
** N=8 EP=7 IP=0 FDC=0
.ENDS
***************************************
.SUBCKT AO13S B3 B2 B1 A1 GND VCC O
** N=8 EP=7 IP=0 FDC=0
.ENDS
***************************************
.SUBCKT AOI22S A1 B1 O B2 GND A2 VCC
** N=8 EP=7 IP=0 FDC=0
.ENDS
***************************************
.SUBCKT BUF2 I O GND VCC
** N=5 EP=4 IP=0 FDC=0
.ENDS
***************************************
.SUBCKT INV2 I O GND VCC
** N=5 EP=4 IP=0 FDC=0
.ENDS
***************************************
.SUBCKT MOAI1S B1 B2 GND A1 A2 O VCC
** N=8 EP=7 IP=0 FDC=0
.ENDS
***************************************
.SUBCKT AOI13HS B3 O B2 B1 VCC A1 GND
** N=8 EP=7 IP=0 FDC=0
.ENDS
***************************************
.SUBCKT ND3 I3 GND I2 O VCC I1
** N=7 EP=6 IP=0 FDC=0
.ENDS
***************************************
.SUBCKT MAOI1 B1 B2 A1 A2 VCC GND O
** N=8 EP=7 IP=0 FDC=0
.ENDS
***************************************
.SUBCKT MOAI1 B1 B2 GND A1 O A2 VCC
** N=8 EP=7 IP=0 FDC=0
.ENDS
***************************************
.SUBCKT AO22 O A2 A1 VCC B1 B2 GND
** N=8 EP=7 IP=0 FDC=0
.ENDS
***************************************
.SUBCKT MUX3 B S0 A S1 VCC C GND O
** N=9 EP=8 IP=0 FDC=0
.ENDS
***************************************
.SUBCKT XOR3 I2 I1 I3 VCC GND O
** N=7 EP=6 IP=0 FDC=0
.ENDS
***************************************
.SUBCKT MAO222 B1 A1 C1 GND VCC O
** N=7 EP=6 IP=0 FDC=0
.ENDS
***************************************
.SUBCKT AO12 B2 B1 A1 GND VCC O
** N=7 EP=6 IP=0 FDC=0
.ENDS
***************************************
.SUBCKT BUF4CK I GND O VCC
** N=5 EP=4 IP=0 FDC=0
.ENDS
***************************************
.SUBCKT HA1 A B C GND VCC S
** N=7 EP=6 IP=0 FDC=0
.ENDS
***************************************
.SUBCKT DELA I GND VCC O
** N=5 EP=4 IP=0 FDC=0
.ENDS
***************************************
.SUBCKT BUF1S I GND VCC O
** N=5 EP=4 IP=0 FDC=0
.ENDS
***************************************
.SUBCKT BUF2CK I O GND VCC
** N=5 EP=4 IP=0 FDC=0
.ENDS
***************************************
.SUBCKT BUF3 I VCC GND O
** N=5 EP=4 IP=0 FDC=0
.ENDS
***************************************
.SUBCKT QDFFRBT D CK RB GND VCC Q
** N=7 EP=6 IP=0 FDC=0
.ENDS
***************************************
.SUBCKT ND2P I2 GND I1 O VCC
** N=6 EP=5 IP=0 FDC=0
.ENDS
***************************************
.SUBCKT MXL2HS B S OB A VCC GND
** N=7 EP=6 IP=0 FDC=0
.ENDS
***************************************
.SUBCKT MOAI1H B1 B2 GND A1 O A2 VCC
** N=8 EP=7 IP=0 FDC=0
.ENDS
***************************************
.SUBCKT AN2B1S I1 VCC B1 O GND
** N=6 EP=5 IP=0 FDC=0
.ENDS
***************************************
.SUBCKT MAO222P A1 B1 C1 O GND VCC
** N=7 EP=6 IP=0 FDC=0
.ENDS
***************************************
.SUBCKT MAO222T A1 B1 C1 O GND VCC
** N=7 EP=6 IP=0 FDC=0
.ENDS
***************************************
.SUBCKT ICV_3 1 2 3 4 5 6 7 8 9 10 11 12 13 14 15 16 17 18 19 20
+ 21 22 23 24 25 26 27 28 29 30 31 32 33 34 35 36 37 38 39 40
+ 41 42 43 44 45 46 47 48 49 50 51 52 53 54 55 56 57 58 59 60
+ 61 62 63 64 65 66 67 68 69 70 71 72 73 74 75 76 77 78 79 80
+ 81 82 83 84 85 86 87 88 89 90 91 92 93 94 95 96 97 98 99 100
+ 101 102 103 104 105 106 107 108 109 110 111 112 113 114 115 116 117 118 119 120
+ 121 122 123 124 125 126 127 128 129 130 131 132 133 134 135 136 137 138 139 140
+ 141 142 143 144 145 146 147 148 149 150 151 152 153 154 155 156 157 158 159 160
+ 161 162 163 164 165 166 167 168 169 170 171 172 173 174 175 176 177 178 179 180
+ 181 182 183 184 185 186 187 188 189 190 191 192 193 194 195 196 197 198 199 200
+ 201 202 203 204 205 206 207 208 209 210 211 212 213 214 215 216 217 218 219 220
+ 221 222 223 224 225 226 227 228 229 230 231 232 233 234 235 236 237 238 239 240
+ 241 242 243 244 245 246 247 248 249 250 251 252 253 254 255 256 257 258 259 260
+ 261 262 263 264 265 266 267 268 269 270 271 272 273 274 275 276 277 278 279 280
+ 281 282 283 284 285 286 287 288 289 290 291 292 293 294 295 296 297 298 299 300
+ 301 302 303 304 305 306 307 308 309 310 311 312 313 314 315 316 317 318 319 320
+ 321 322 323 324 325 326 327 328 329 330 331 340
** N=1641 EP=332 IP=7757 FDC=0
X0 330 328 328 328 329 325 331 YA2GSD $T=1199700 881320 0 90 $X=1060200 $Y=884170
X1 3 2 1 5 BUF1 $T=221960 920760 0 0 $X=221960 $Y=920380
X2 6 2 1 348 BUF1 $T=224440 880440 1 0 $X=224440 $Y=875020
X3 7 2 1 343 BUF1 $T=226920 880440 1 0 $X=226920 $Y=875020
X4 8 2 1 384 BUF1 $T=243660 900600 0 0 $X=243660 $Y=900220
X5 22 2 1 16 BUF1 $T=257920 870360 0 180 $X=255440 $Y=864940
X6 410 2 1 4 BUF1 $T=262260 880440 0 180 $X=259780 $Y=875020
X7 430 2 1 25 BUF1 $T=267840 880440 1 180 $X=265360 $Y=880060
X8 28 2 1 395 BUF1 $T=271560 890520 0 0 $X=271560 $Y=890140
X9 27 2 1 372 BUF1 $T=280240 880440 1 0 $X=280240 $Y=875020
X10 34 2 1 434 BUF1 $T=283340 910680 1 180 $X=280860 $Y=910300
X11 32 2 1 406 BUF1 $T=281480 910680 1 0 $X=281480 $Y=905260
X12 517 2 1 346 BUF1 $T=310000 900600 0 180 $X=307520 $Y=895180
X13 45 2 1 8 BUF1 $T=314960 870360 0 180 $X=312480 $Y=864940
X14 524 2 1 525 BUF1 $T=316200 910680 0 0 $X=316200 $Y=910300
X15 512 2 1 47 BUF1 $T=327360 870360 0 0 $X=327360 $Y=869980
X16 552 2 1 512 BUF1 $T=331080 910680 0 180 $X=328600 $Y=905260
X17 49 2 1 552 BUF1 $T=332940 940920 0 0 $X=332940 $Y=940540
X18 49 2 1 51 BUF1 $T=337900 961080 1 0 $X=337900 $Y=955660
X19 591 2 1 430 BUF1 $T=357740 880440 1 180 $X=355260 $Y=880060
X20 47 2 1 56 BUF1 $T=357740 870360 0 0 $X=357740 $Y=869980
X21 56 2 1 615 BUF1 $T=372620 880440 1 0 $X=372620 $Y=875020
X22 645 2 1 646 BUF1 $T=381920 910680 1 0 $X=381920 $Y=905260
X23 51 2 1 63 BUF1 $T=381920 961080 1 0 $X=381920 $Y=955660
X24 493 2 1 645 BUF1 $T=385640 900600 0 0 $X=385640 $Y=900220
X25 45 2 1 621 BUF1 $T=393700 890520 0 180 $X=391220 $Y=885100
X26 517 2 1 623 BUF1 $T=397420 900600 1 0 $X=397420 $Y=895180
X27 524 2 1 706 BUF1 $T=419740 900600 1 0 $X=419740 $Y=895180
X28 517 2 1 702 BUF1 $T=422220 900600 0 0 $X=422220 $Y=900220
X29 78 2 1 740 BUF1 $T=438340 940920 1 0 $X=438340 $Y=935500
X30 825 2 1 773 BUF1 $T=470580 900600 0 180 $X=468100 $Y=895180
X31 740 2 1 825 BUF1 $T=468100 920760 0 0 $X=468100 $Y=920380
X32 740 2 1 840 BUF1 $T=473680 920760 0 0 $X=473680 $Y=920380
X33 102 2 1 834 BUF1 $T=477400 870360 0 0 $X=477400 $Y=869980
X34 840 2 1 828 BUF1 $T=477400 920760 0 0 $X=477400 $Y=920380
X35 840 2 1 887 BUF1 $T=500960 920760 1 0 $X=500960 $Y=915340
X36 887 2 1 113 BUF1 $T=509020 951000 0 180 $X=506540 $Y=945580
X37 887 2 1 120 BUF1 $T=512740 951000 1 0 $X=512740 $Y=945580
X38 112 2 1 886 BUF1 $T=525760 900600 1 0 $X=525760 $Y=895180
X39 112 2 1 122 BUF1 $T=540020 920760 1 0 $X=540020 $Y=915340
X40 1000 2 1 980 BUF1 $T=566680 890520 0 180 $X=564200 $Y=885100
X41 1038 2 1 1000 BUF1 $T=586520 900600 1 180 $X=584040 $Y=900220
X42 158 2 1 1063 BUF1 $T=600160 940920 1 0 $X=600160 $Y=935500
X43 1066 2 1 159 BUF1 $T=612560 880440 1 180 $X=610080 $Y=880060
X44 1063 2 1 1038 BUF1 $T=614420 910680 0 180 $X=611940 $Y=905260
X45 1066 2 1 160 BUF1 $T=613180 880440 1 0 $X=613180 $Y=875020
X46 1063 2 1 1066 BUF1 $T=619380 910680 1 0 $X=619380 $Y=905260
X47 1066 2 1 1100 BUF1 $T=628060 910680 1 0 $X=628060 $Y=905260
X48 1100 2 1 1112 BUF1 $T=647280 910680 1 0 $X=647280 $Y=905260
X49 1112 2 1 1113 BUF1 $T=652240 900600 0 0 $X=652240 $Y=900220
X50 1112 2 1 1129 BUF1 $T=652240 920760 0 0 $X=652240 $Y=920380
X51 1112 2 1 170 BUF1 $T=654720 940920 0 180 $X=652240 $Y=935500
X52 175 2 1 1156 BUF1 $T=672700 910680 0 0 $X=672700 $Y=910300
X53 180 2 1 182 BUF1 $T=680140 870360 1 0 $X=680140 $Y=864940
X54 1186 2 1 1168 BUF1 $T=693160 920760 0 0 $X=693160 $Y=920380
X55 1233 2 1 196 BUF1 $T=704320 870360 0 0 $X=704320 $Y=869980
X56 199 2 1 1237 BUF1 $T=704320 910680 1 0 $X=704320 $Y=905260
X57 1234 2 1 1204 BUF1 $T=704320 920760 1 0 $X=704320 $Y=915340
X58 1237 2 1 1185 BUF1 $T=704940 910680 0 0 $X=704940 $Y=910300
X59 1244 2 1 1214 BUF1 $T=711140 951000 0 180 $X=708660 $Y=945580
X60 1247 2 1 1201 BUF1 $T=711140 930840 1 0 $X=711140 $Y=925420
X61 1234 2 1 1239 BUF1 $T=712380 920760 0 0 $X=712380 $Y=920380
X62 207 2 1 1257 BUF1 $T=713620 910680 0 0 $X=713620 $Y=910300
X63 195 2 1 211 BUF1 $T=716100 880440 1 0 $X=716100 $Y=875020
X64 1259 2 1 1234 BUF1 $T=716720 900600 0 0 $X=716720 $Y=900220
X65 191 2 1 1261 BUF1 $T=720440 900600 1 0 $X=720440 $Y=895180
X66 1233 2 1 1170 BUF1 $T=721060 920760 0 0 $X=721060 $Y=920380
X67 219 2 1 1186 BUF1 $T=724160 920760 1 0 $X=724160 $Y=915340
X68 190 2 1 1247 BUF1 $T=729740 890520 0 0 $X=729740 $Y=890140
X69 1261 2 1 1290 BUF1 $T=732840 920760 1 0 $X=732840 $Y=915340
X70 1235 2 1 1283 BUF1 $T=732840 920760 0 0 $X=732840 $Y=920380
X71 1292 2 1 1174 BUF1 $T=738420 940920 0 180 $X=735940 $Y=935500
X72 1257 2 1 1309 BUF1 $T=739660 910680 0 0 $X=739660 $Y=910300
X73 177 2 1 1265 BUF1 $T=740900 920760 0 0 $X=740900 $Y=920380
X74 225 2 1 1302 BUF1 $T=744000 880440 1 0 $X=744000 $Y=875020
X75 1265 2 1 1289 BUF1 $T=744000 920760 0 0 $X=744000 $Y=920380
X76 247 2 1 1356 BUF1 $T=779960 880440 0 180 $X=777480 $Y=875020
X77 1302 2 1 1367 BUF1 $T=778100 880440 0 0 $X=778100 $Y=880060
X78 255 2 1 1345 BUF1 $T=793600 870360 1 180 $X=791120 $Y=869980
X79 203 2 1 1382 BUF1 $T=791120 880440 0 0 $X=791120 $Y=880060
X80 256 2 1 1373 BUF1 $T=793600 900600 0 180 $X=791120 $Y=895180
X81 1439 2 1 262 BUF1 $T=836380 920760 1 180 $X=833900 $Y=920380
X82 282 2 1 1439 BUF1 $T=856220 940920 1 180 $X=853740 $Y=940540
X83 1472 2 1 289 BUF1 $T=864900 880440 0 180 $X=862420 $Y=875020
X84 282 2 1 1472 BUF1 $T=868000 930840 0 180 $X=865520 $Y=925420
X85 300 2 1 291 BUF1 $T=894660 870360 1 0 $X=894660 $Y=864940
X86 243 2 1 301 BUF1 $T=894660 880440 1 0 $X=894660 $Y=875020
X87 1507 2 1 1486 BUF1 $T=899620 880440 0 0 $X=899620 $Y=880060
X88 303 2 1 1534 BUF1 $T=902720 920760 1 0 $X=902720 $Y=915340
X89 1335 2 1 310 BUF1 $T=906440 890520 0 0 $X=906440 $Y=890140
X90 328 2 1 325 BUF1 $T=975260 920760 1 180 $X=972780 $Y=920380
X91 492 42 512 2 1 523 QDFFRBN $T=301940 880440 1 0 $X=301940 $Y=875020
X92 43 42 512 2 1 539 QDFFRBN $T=305040 880440 0 0 $X=305040 $Y=880060
X93 465 42 512 2 1 528 QDFFRBN $T=305040 890520 1 0 $X=305040 $Y=885100
X94 515 42 512 2 1 545 QDFFRBN $T=318680 900600 0 0 $X=318680 $Y=900220
X95 530 42 512 2 1 547 QDFFRBN $T=319920 890520 0 0 $X=319920 $Y=890140
X96 529 42 49 2 1 562 QDFFRBN $T=329840 940920 1 0 $X=329840 $Y=935500
X97 499 42 552 2 1 560 QDFFRBN $T=331080 930840 1 0 $X=331080 $Y=925420
X98 546 42 47 2 1 557 QDFFRBN $T=331700 870360 0 0 $X=331700 $Y=869980
X99 551 42 552 2 1 548 QDFFRBN $T=344720 900600 1 180 $X=332940 $Y=900220
X100 550 42 49 2 1 566 QDFFRBN $T=334180 951000 1 0 $X=334180 $Y=945580
X101 556 42 552 2 1 579 QDFFRBN $T=338520 940920 0 0 $X=338520 $Y=940540
X102 526 42 51 2 1 598 QDFFRBN $T=345340 961080 1 0 $X=345340 $Y=955660
X103 585 42 552 2 1 611 QDFFRBN $T=352780 940920 0 0 $X=352780 $Y=940540
X104 58 42 47 2 1 572 QDFFRBN $T=365800 870360 0 180 $X=354020 $Y=864940
X105 571 42 615 2 1 629 QDFFRBN $T=363320 880440 0 0 $X=363320 $Y=880060
X106 604 42 51 2 1 57 QDFFRBN $T=375720 951000 0 180 $X=363940 $Y=945580
X107 567 42 615 2 1 653 QDFFRBN $T=366420 890520 1 0 $X=366420 $Y=885100
X108 584 42 56 2 1 61 QDFFRBN $T=368280 870360 1 0 $X=368280 $Y=864940
X109 603 42 63 2 1 651 QDFFRBN $T=375720 951000 0 0 $X=375720 $Y=950620
X110 590 42 615 2 1 660 QDFFRBN $T=376960 880440 1 0 $X=376960 $Y=875020
X111 569 42 615 2 1 655 QDFFRBN $T=378200 880440 0 0 $X=378200 $Y=880060
X112 630 42 63 2 1 675 QDFFRBN $T=388740 961080 1 0 $X=388740 $Y=955660
X113 659 42 63 2 1 679 QDFFRBN $T=390600 951000 1 0 $X=390600 $Y=945580
X114 661 42 63 2 1 687 QDFFRBN $T=392460 940920 0 0 $X=392460 $Y=940540
X115 709 42 71 2 1 682 QDFFRBN $T=416640 870360 0 180 $X=404860 $Y=864940
X116 689 42 63 2 1 716 QDFFRBN $T=406100 951000 1 0 $X=406100 $Y=945580
X117 594 42 78 2 1 742 QDFFRBN $T=416020 940920 1 0 $X=416020 $Y=935500
X118 718 42 78 2 1 738 QDFFRBN $T=417880 961080 1 0 $X=417880 $Y=955660
X119 724 42 78 2 1 747 QDFFRBN $T=421600 951000 1 0 $X=421600 $Y=945580
X120 80 42 71 2 1 721 QDFFRBN $T=434620 870360 0 180 $X=422840 $Y=864940
X121 729 42 740 2 1 746 QDFFRBN $T=424080 930840 0 0 $X=424080 $Y=930460
X122 755 42 740 2 1 781 QDFFRBN $T=438340 930840 0 0 $X=438340 $Y=930460
X123 757 42 88 2 1 790 QDFFRBN $T=442060 961080 1 0 $X=442060 $Y=955660
X124 788 42 773 2 1 86 QDFFRBN $T=454460 870360 1 180 $X=442680 $Y=869980
X125 771 91 740 2 1 775 QDFFRBN $T=458800 920760 1 180 $X=447020 $Y=920380
X126 802 42 773 2 1 728 QDFFRBN $T=460660 880440 1 180 $X=448880 $Y=880060
X127 808 42 773 2 1 753 QDFFRBN $T=463140 890520 1 180 $X=451360 $Y=890140
X128 810 42 773 2 1 774 QDFFRBN $T=464380 900600 0 180 $X=452600 $Y=895180
X129 827 91 773 2 1 739 QDFFRBN $T=473680 880440 1 180 $X=461900 $Y=880060
X130 833 91 825 2 1 824 QDFFRBN $T=479880 890520 1 180 $X=468100 $Y=890140
X131 835 91 825 2 1 791 QDFFRBN $T=481740 910680 0 180 $X=469960 $Y=905260
X132 836 91 828 2 1 801 QDFFRBN $T=481740 961080 0 180 $X=469960 $Y=955660
X133 794 91 828 2 1 839 QDFFRBN $T=470580 940920 0 0 $X=470580 $Y=940540
X134 837 91 825 2 1 792 QDFFRBN $T=482980 910680 1 180 $X=471200 $Y=910300
X135 104 91 773 2 1 803 QDFFRBN $T=484840 880440 0 180 $X=473060 $Y=875020
X136 841 91 825 2 1 813 QDFFRBN $T=484840 900600 0 180 $X=473060 $Y=895180
X137 843 91 828 2 1 830 QDFFRBN $T=486700 951000 0 180 $X=474920 $Y=945580
X138 868 91 825 2 1 823 QDFFRBN $T=487320 880440 1 180 $X=475540 $Y=880060
X139 797 91 828 2 1 854 QDFFRBN $T=475540 940920 1 0 $X=475540 $Y=935500
X140 851 91 840 2 1 832 QDFFRBN $T=491660 930840 0 180 $X=479880 $Y=925420
X141 863 91 840 2 1 838 QDFFRBN $T=495380 910680 0 180 $X=483600 $Y=905260
X142 869 91 840 2 1 844 QDFFRBN $T=497240 910680 1 180 $X=485460 $Y=910300
X143 901 91 113 2 1 856 QDFFRBN $T=514600 951000 1 180 $X=502820 $Y=950620
X144 908 91 887 2 1 881 QDFFRBN $T=518320 940920 1 180 $X=506540 $Y=940540
X145 925 91 887 2 1 891 QDFFRBN $T=522660 930840 0 180 $X=510880 $Y=925420
X146 918 91 887 2 1 899 QDFFRBN $T=523280 930840 1 180 $X=511500 $Y=930460
X147 930 91 120 2 1 907 QDFFRBN $T=528240 951000 1 180 $X=516460 $Y=950620
X148 933 91 120 2 1 909 QDFFRBN $T=528860 951000 0 180 $X=517080 $Y=945580
X149 135 91 980 2 1 983 QDFFRBN $T=546840 870360 1 0 $X=546840 $Y=864940
X150 136 91 980 2 1 987 QDFFRBN $T=546840 870360 0 0 $X=546840 $Y=869980
X151 999 91 980 2 1 911 QDFFRBN $T=559860 890520 0 180 $X=548080 $Y=885100
X152 137 91 980 2 1 982 QDFFRBN $T=549940 880440 1 0 $X=549940 $Y=875020
X153 1018 91 1000 2 1 984 QDFFRBN $T=571020 890520 1 180 $X=559240 $Y=890140
X154 1012 91 1000 2 1 995 QDFFRBN $T=571020 910680 0 180 $X=559240 $Y=905260
X155 150 91 980 2 1 142 QDFFRBN $T=574740 870360 1 180 $X=562960 $Y=869980
X156 1022 91 980 2 1 976 QDFFRBN $T=576600 880440 1 180 $X=564820 $Y=880060
X157 1010 91 1000 2 1 1007 QDFFRBN $T=578460 900600 1 180 $X=566680 $Y=900220
X158 998 91 1000 2 1 152 QDFFRBN $T=570400 890520 1 0 $X=570400 $Y=885100
X159 1023 91 1000 2 1 153 QDFFRBN $T=574740 890520 0 0 $X=574740 $Y=890140
X160 1027 91 1038 2 1 1039 QDFFRBN $T=577220 910680 1 0 $X=577220 $Y=905260
X161 1035 91 1038 2 1 1058 QDFFRBN $T=592100 910680 0 0 $X=592100 $Y=910300
X162 1064 91 1038 2 1 1047 QDFFRBN $T=608840 920760 0 180 $X=597060 $Y=915340
X163 1065 157 158 2 1 1049 QDFFRBN $T=608840 951000 1 180 $X=597060 $Y=950620
X164 161 157 159 2 1 1057 QDFFRBN $T=609460 870360 1 180 $X=597680 $Y=869980
X165 156 157 160 2 1 1067 QDFFRBN $T=597680 880440 1 0 $X=597680 $Y=875020
X166 1069 157 158 2 1 1055 QDFFRBN $T=613180 961080 0 180 $X=601400 $Y=955660
X167 163 157 1066 2 1 1048 QDFFRBN $T=616280 890520 1 180 $X=604500 $Y=890140
X168 1070 157 1063 2 1 1059 QDFFRBN $T=616280 940920 1 180 $X=604500 $Y=940540
X169 1071 157 158 2 1 1062 QDFFRBN $T=617520 940920 0 180 $X=605740 $Y=935500
X170 1081 157 1063 2 1 1040 QDFFRBN $T=618140 930840 0 180 $X=606360 $Y=925420
X171 1073 157 1066 2 1 973 QDFFRBN $T=618760 900600 0 180 $X=606980 $Y=895180
X172 1075 157 1063 2 1 1002 QDFFRBN $T=621240 920760 1 180 $X=609460 $Y=920380
X173 1083 157 158 2 1 994 QDFFRBN $T=622480 951000 1 180 $X=610700 $Y=950620
X174 1076 157 1066 2 1 1097 QDFFRBN $T=620000 900600 0 0 $X=620000 $Y=900220
X175 1104 157 160 2 1 1074 QDFFRBN $T=638600 870360 0 180 $X=626820 $Y=864940
X176 1108 157 160 2 1 1089 QDFFRBN $T=641700 880440 0 180 $X=629920 $Y=875020
X177 1116 157 1100 2 1 1099 QDFFRBN $T=646040 910680 0 180 $X=634260 $Y=905260
X178 1125 157 1112 2 1 1103 QDFFRBN $T=650380 940920 0 180 $X=638600 $Y=935500
X179 1126 157 1112 2 1 1102 QDFFRBN $T=651620 930840 0 180 $X=639840 $Y=925420
X180 1128 157 1113 2 1 1096 QDFFRBN $T=652240 890520 1 180 $X=640460 $Y=890140
X181 1139 157 170 2 1 165 QDFFRBN $T=658440 961080 0 180 $X=646660 $Y=955660
X182 1135 157 170 2 1 1092 QDFFRBN $T=660920 940920 1 180 $X=649140 $Y=940540
X183 1133 157 170 2 1 1086 QDFFRBN $T=660920 951000 0 180 $X=649140 $Y=945580
X184 1136 157 1113 2 1 1120 QDFFRBN $T=661540 890520 0 180 $X=649760 $Y=885100
X185 1134 157 1112 2 1 1122 QDFFRBN $T=664020 910680 0 180 $X=652240 $Y=905260
X186 1148 157 1113 2 1 1117 QDFFRBN $T=667120 890520 1 180 $X=655340 $Y=890140
X187 1178 157 1113 2 1 1123 QDFFRBN $T=668360 900600 1 180 $X=656580 $Y=900220
X188 1142 157 1129 2 1 1119 QDFFRBN $T=668360 930840 1 180 $X=656580 $Y=930460
X189 1146 157 1129 2 1 1114 QDFFRBN $T=670840 920760 1 180 $X=659060 $Y=920380
X190 1150 157 1113 2 1 1118 QDFFRBN $T=672080 880440 1 180 $X=660300 $Y=880060
X191 1149 157 1129 2 1 1107 QDFFRBN $T=673320 920760 0 180 $X=661540 $Y=915340
X192 1361 259 262 2 1 1400 QDFFRBN $T=792980 890520 0 0 $X=792980 $Y=890140
X193 258 259 262 2 1 1399 QDFFRBN $T=793600 870360 0 0 $X=793600 $Y=869980
X194 261 259 262 2 1 1395 QDFFRBN $T=794840 880440 1 0 $X=794840 $Y=875020
X195 1423 259 262 2 1 1409 QDFFRBN $T=821500 910680 0 180 $X=809720 $Y=905260
X196 1414 259 1439 2 1 1444 QDFFRBN $T=822740 910680 0 0 $X=822740 $Y=910300
X197 1430 259 262 2 1 1427 QDFFRBN $T=835760 910680 0 180 $X=823980 $Y=905260
X198 1426 259 1439 2 1 1451 QDFFRBN $T=826460 930840 1 0 $X=826460 $Y=925420
X199 1443 259 1439 2 1 1425 QDFFRBN $T=844440 890520 1 180 $X=832660 $Y=890140
X200 1456 259 82 2 1 1446 QDFFRBN $T=846920 961080 0 180 $X=835140 $Y=955660
X201 1442 259 1439 2 1 1458 QDFFRBN $T=838240 910680 1 0 $X=838240 $Y=905260
X202 1466 259 1439 2 1 1404 QDFFRBN $T=858080 890520 1 180 $X=846300 $Y=890140
X203 1464 259 282 2 1 1459 QDFFRBN $T=859320 930840 1 180 $X=847540 $Y=930460
X204 1471 259 282 2 1 1460 QDFFRBN $T=861180 930840 0 180 $X=849400 $Y=925420
X205 1478 259 1472 2 1 1468 QDFFRBN $T=869240 920760 1 180 $X=857460 $Y=920380
X206 1469 259 289 2 1 290 QDFFRBN $T=859320 870360 0 0 $X=859320 $Y=869980
X207 1477 259 1472 2 1 1467 QDFFRBN $T=872340 890520 1 180 $X=860560 $Y=890140
X208 1488 259 1472 2 1 1470 QDFFRBN $T=877920 880440 0 180 $X=866140 $Y=875020
X209 294 259 282 2 1 1411 QDFFRBN $T=884740 961080 0 180 $X=872960 $Y=955660
X210 444 2 412 1 INV1S $T=278380 910680 1 180 $X=277140 $Y=910300
X211 31 2 444 1 INV1S $T=280240 910680 1 0 $X=280240 $Y=905260
X212 468 2 467 1 INV1S $T=296360 930840 0 0 $X=296360 $Y=930460
X213 444 2 504 1 INV1S $T=305660 910680 1 0 $X=305660 $Y=905260
X214 498 2 502 1 INV1S $T=305660 940920 1 0 $X=305660 $Y=935500
X215 494 2 510 1 INV1S $T=309380 930840 0 0 $X=309380 $Y=930460
X216 514 2 513 1 INV1S $T=314960 930840 1 0 $X=314960 $Y=925420
X217 482 2 469 1 INV1S $T=314960 930840 0 0 $X=314960 $Y=930460
X218 568 2 575 1 INV1S $T=347200 890520 0 0 $X=347200 $Y=890140
X219 593 2 587 1 INV1S $T=354640 910680 1 180 $X=353400 $Y=910300
X220 45 2 589 1 INV1S $T=355880 890520 1 0 $X=355880 $Y=885100
X221 58 2 591 1 INV1S $T=365800 870360 1 180 $X=364560 $Y=869980
X222 46 2 602 1 INV1S $T=365800 880440 0 180 $X=364560 $Y=875020
X223 60 2 613 1 INV1S $T=372000 920760 0 180 $X=370760 $Y=915340
X224 614 2 638 1 INV1S $T=375720 940920 1 0 $X=375720 $Y=935500
X225 607 2 648 1 INV1S $T=385640 900600 1 180 $X=384400 $Y=900220
X226 641 2 639 1 INV1S $T=387500 940920 0 0 $X=387500 $Y=940540
X227 660 2 673 1 INV1S $T=391840 870360 0 0 $X=391840 $Y=869980
X228 629 2 662 1 INV1S $T=391840 880440 0 0 $X=391840 $Y=880060
X229 655 2 668 1 INV1S $T=395560 880440 0 0 $X=395560 $Y=880060
X230 653 2 693 1 INV1S $T=401140 890520 1 0 $X=401140 $Y=885100
X231 679 2 684 1 INV1S $T=404240 951000 0 0 $X=404240 $Y=950620
X232 463 2 695 1 INV1S $T=407340 900600 0 0 $X=407340 $Y=900220
X233 713 2 688 1 INV1S $T=413540 930840 0 180 $X=412300 $Y=925420
X234 694 2 711 1 INV1S $T=412300 930840 0 0 $X=412300 $Y=930460
X235 695 2 703 1 INV1S $T=414160 890520 1 180 $X=412920 $Y=890140
X236 695 2 712 1 INV1S $T=414780 900600 0 0 $X=414780 $Y=900220
X237 74 2 726 1 INV1S $T=418500 930840 0 0 $X=418500 $Y=930460
X238 687 2 736 1 INV1S $T=420980 951000 0 0 $X=420980 $Y=950620
X239 651 2 725 1 INV1S $T=421600 920760 1 0 $X=421600 $Y=915340
X240 706 2 760 1 INV1S $T=423460 930840 1 0 $X=423460 $Y=925420
X241 716 2 743 1 INV1S $T=433380 961080 1 0 $X=433380 $Y=955660
X242 742 2 745 1 INV1S $T=437100 900600 0 0 $X=437100 $Y=900220
X243 81 2 82 1 INV1S $T=438960 870360 0 0 $X=438960 $Y=869980
X244 761 2 758 1 INV1S $T=442060 940920 1 180 $X=440820 $Y=940540
X245 776 2 766 1 INV1S $T=445160 951000 0 180 $X=443920 $Y=945580
X246 738 2 826 1 INV1S $T=453840 951000 1 0 $X=453840 $Y=945580
X247 790 2 795 1 INV1S $T=453840 951000 0 0 $X=453840 $Y=950620
X248 93 2 800 1 INV1S $T=456940 940920 0 0 $X=456940 $Y=940540
X249 839 2 855 1 INV1S $T=486700 940920 0 0 $X=486700 $Y=940540
X250 858 2 849 1 INV1S $T=490420 880440 0 180 $X=489180 $Y=875020
X251 854 2 865 1 INV1S $T=492280 930840 0 0 $X=492280 $Y=930460
X252 859 2 860 1 INV1S $T=500340 900600 0 180 $X=499100 $Y=895180
X253 900 2 898 1 INV1S $T=514600 910680 1 180 $X=513360 $Y=910300
X254 116 2 906 1 INV1S $T=515840 870360 0 0 $X=515840 $Y=869980
X255 911 2 890 1 INV1S $T=517700 880440 0 180 $X=516460 $Y=875020
X256 954 2 949 1 INV1S $T=535060 961080 0 180 $X=533820 $Y=955660
X257 955 2 939 1 INV1S $T=537540 890520 1 180 $X=536300 $Y=890140
X258 958 2 961 1 INV1S $T=544360 920760 0 180 $X=543120 $Y=915340
X259 131 2 970 1 INV1S $T=544980 890520 0 0 $X=544980 $Y=890140
X260 976 2 883 1 INV1S $T=546840 880440 0 180 $X=545600 $Y=875020
X261 952 2 975 1 INV1S $T=549320 940920 1 180 $X=548080 $Y=940540
X262 973 2 966 1 INV1S $T=549940 890520 1 180 $X=548700 $Y=890140
X263 957 2 972 1 INV1S $T=550560 900600 0 180 $X=549320 $Y=895180
X264 984 2 905 1 INV1S $T=554900 890520 1 180 $X=553660 $Y=890140
X265 987 2 993 1 INV1S $T=554900 910680 1 0 $X=554900 $Y=905260
X266 994 2 986 1 INV1S $T=558620 951000 1 180 $X=557380 $Y=950620
X267 1002 2 991 1 INV1S $T=559240 910680 1 180 $X=558000 $Y=910300
X268 982 2 990 1 INV1S $T=559240 940920 1 180 $X=558000 $Y=940540
X269 995 2 989 1 INV1S $T=561720 900600 1 180 $X=560480 $Y=900220
X270 1031 2 1015 1 INV1S $T=577220 940920 1 180 $X=575980 $Y=940540
X271 151 2 1043 1 INV1S $T=581560 880440 1 0 $X=581560 $Y=875020
X272 1033 2 1028 1 INV1S $T=582800 920760 1 180 $X=581560 $Y=920380
X273 149 2 1011 1 INV1S $T=582800 951000 1 180 $X=581560 $Y=950620
X274 1040 2 1036 1 INV1S $T=585280 920760 1 180 $X=584040 $Y=920380
X275 1029 2 1034 1 INV1S $T=585280 930840 0 180 $X=584040 $Y=925420
X276 1039 2 1044 1 INV1S $T=590240 940920 1 0 $X=590240 $Y=935500
X277 1047 2 1042 1 INV1S $T=592100 920760 0 180 $X=590860 $Y=915340
X278 1049 2 1037 1 INV1S $T=594580 940920 1 180 $X=593340 $Y=940540
X279 1055 2 154 1 INV1S $T=595820 961080 0 180 $X=594580 $Y=955660
X280 1057 2 1045 1 INV1S $T=597680 880440 1 180 $X=596440 $Y=880060
X281 1059 2 981 1 INV1S $T=600780 940920 1 180 $X=599540 $Y=940540
X282 1067 2 1054 1 INV1S $T=603260 880440 1 180 $X=602020 $Y=880060
X283 1062 2 1052 1 INV1S $T=603260 930840 0 180 $X=602020 $Y=925420
X284 1068 2 965 1 INV1S $T=608840 910680 0 180 $X=607600 $Y=905260
X285 164 2 1077 1 INV1S $T=620620 880440 1 0 $X=620620 $Y=875020
X286 1074 2 1082 1 INV1S $T=623100 870360 1 0 $X=623100 $Y=864940
X287 1092 2 1084 1 INV1S $T=626820 940920 1 180 $X=625580 $Y=940540
X288 1086 2 1078 1 INV1S $T=627440 951000 1 180 $X=626200 $Y=950620
X289 1091 2 1087 1 INV1S $T=628680 920760 1 180 $X=627440 $Y=920380
X290 1103 2 1094 1 INV1S $T=636120 930840 1 180 $X=634880 $Y=930460
X291 168 2 1109 1 INV1S $T=637980 961080 1 0 $X=637980 $Y=955660
X292 1102 2 1111 1 INV1S $T=641080 951000 1 0 $X=641080 $Y=945580
X293 177 2 175 1 INV1S $T=672700 900600 1 0 $X=672700 $Y=895180
X294 1153 2 1126 1 INV1S $T=674560 930840 1 180 $X=673320 $Y=930460
X295 1159 2 1152 1 INV1S $T=674560 951000 0 180 $X=673320 $Y=945580
X296 1157 2 1171 1 INV1S $T=675800 920760 0 0 $X=675800 $Y=920380
X297 1165 2 1166 1 INV1S $T=679520 961080 1 0 $X=679520 $Y=955660
X298 1175 2 1145 1 INV1S $T=682000 930840 0 0 $X=682000 $Y=930460
X299 181 2 1157 1 INV1S $T=682620 920760 0 0 $X=682620 $Y=920380
X300 184 2 180 1 INV1S $T=685100 870360 1 0 $X=685100 $Y=864940
X301 1203 2 1167 1 INV1S $T=691920 940920 1 180 $X=690680 $Y=940540
X302 187 2 1180 1 INV1S $T=692540 890520 0 180 $X=691300 $Y=885100
X303 1215 2 1172 1 INV1S $T=693780 900600 0 180 $X=692540 $Y=895180
X304 1211 2 1199 1 INV1S $T=695020 951000 1 180 $X=693780 $Y=950620
X305 1196 2 1205 1 INV1S $T=694400 900600 0 0 $X=694400 $Y=900220
X306 193 2 1220 1 INV1S $T=699360 880440 1 0 $X=699360 $Y=875020
X307 1236 2 1230 1 INV1S $T=704320 900600 0 180 $X=703080 $Y=895180
X308 199 2 1233 1 INV1S $T=704320 880440 1 0 $X=704320 $Y=875020
X309 200 2 1209 1 INV1S $T=707420 870360 0 180 $X=706180 $Y=864940
X310 197 2 1259 1 INV1S $T=719820 900600 0 0 $X=719820 $Y=900220
X311 1267 2 192 1 INV1S $T=723540 910680 1 180 $X=722300 $Y=910300
X312 222 2 1231 1 INV1S $T=727880 910680 1 180 $X=726640 $Y=910300
X313 1245 2 1244 1 INV1S $T=726640 940920 1 0 $X=726640 $Y=935500
X314 1178 2 1275 1 INV1S $T=729740 910680 1 0 $X=729740 $Y=905260
X315 190 2 204 1 INV1S $T=738420 890520 1 0 $X=738420 $Y=885100
X316 222 2 1267 1 INV1S $T=745860 910680 0 180 $X=744620 $Y=905260
X317 1292 2 1242 1 INV1S $T=750200 930840 1 180 $X=748960 $Y=930460
X318 248 2 1347 1 INV1S $T=781820 880440 1 180 $X=780580 $Y=880060
X319 1435 2 1428 1 INV1S $T=825840 890520 0 180 $X=824600 $Y=885100
X320 1433 2 1449 1 INV1S $T=837000 880440 1 0 $X=837000 $Y=875020
X321 297 2 1487 1 INV1S $T=886600 890520 1 180 $X=885360 $Y=890140
X322 1512 2 1503 1 INV1S $T=888460 930840 1 180 $X=887220 $Y=930460
X323 1522 2 1496 1 INV1S $T=889080 920760 0 180 $X=887840 $Y=915340
X324 293 2 298 1 INV1S $T=890320 870360 0 0 $X=890320 $Y=869980
X325 1492 2 1513 1 INV1S $T=890940 880440 0 0 $X=890940 $Y=880060
X326 304 2 1507 1 INV1S $T=897760 880440 0 0 $X=897760 $Y=880060
X327 248 2 1535 1 INV1S $T=905200 890520 1 0 $X=905200 $Y=885100
X328 315 2 1580 1 INV1S $T=929380 870360 1 0 $X=929380 $Y=864940
X329 1566 2 1578 1 INV1S $T=931860 880440 1 0 $X=931860 $Y=875020
X330 1558 2 1579 1 INV1S $T=931860 880440 0 0 $X=931860 $Y=880060
X331 1576 2 1585 1 INV1S $T=934340 900600 0 0 $X=934340 $Y=900220
X332 1573 2 1586 1 INV1S $T=934340 910680 0 0 $X=934340 $Y=910300
X333 1602 2 1612 1 INV1S $T=956660 920760 1 0 $X=956660 $Y=915340
X334 1628 2 1636 1 INV1S $T=962240 870360 0 0 $X=962240 $Y=869980
X335 1616 2 1609 1 INV1S $T=962240 930840 1 0 $X=962240 $Y=925420
X336 1605 2 1624 1 INV1S $T=965960 900600 0 0 $X=965960 $Y=900220
X337 1630 2 1622 1 INV1S $T=969060 910680 0 0 $X=969060 $Y=910300
X338 1610 2 1634 1 INV1S $T=970920 910680 1 0 $X=970920 $Y=905260
X339 364 376 2 382 367 1 404 FA1 $T=234360 951000 1 0 $X=234360 $Y=945580
X340 373 389 2 342 364 1 18 FA1 $T=239940 951000 0 0 $X=239940 $Y=950620
X341 381 408 2 405 377 1 382 FA1 $T=249240 920760 1 0 $X=249240 $Y=915340
X342 407 388 2 433 354 1 461 FA1 $T=258540 951000 1 0 $X=258540 $Y=945580
X343 24 407 2 436 404 1 456 FA1 $T=261640 951000 0 0 $X=261640 $Y=950620
X344 462 464 2 459 439 1 448 FA1 $T=300700 890520 0 180 $X=285200 $Y=885100
X345 550 506 2 531 543 1 522 FA1 $T=330460 951000 0 180 $X=314960 $Y=945580
X346 526 533 2 542 522 1 48 FA1 $T=316200 961080 1 0 $X=316200 $Y=955660
X347 659 674 2 680 619 1 694 FA1 $T=393700 930840 0 0 $X=393700 $Y=930460
X348 724 700 2 748 727 1 754 FA1 $T=423460 910680 1 0 $X=423460 $Y=905260
X349 771 735 2 732 754 1 730 FA1 $T=440200 920760 0 180 $X=424700 $Y=915340
X350 729 731 2 760 730 1 755 FA1 $T=428420 920760 0 0 $X=428420 $Y=920380
X351 998 147 2 148 144 1 1032 FA1 $T=561720 870360 1 0 $X=561720 $Y=864940
X352 1027 151 2 1045 1051 1 1050 FA1 $T=579080 880440 0 0 $X=579080 $Y=880060
X353 1023 155 2 1043 1032 1 1051 FA1 $T=579700 870360 0 0 $X=579700 $Y=869980
X354 1035 1054 2 1057 1050 1 1056 FA1 $T=585280 890520 1 0 $X=585280 $Y=885100
X355 1022 1089 2 1093 1085 1 1101 FA1 $T=618140 880440 0 0 $X=618140 $Y=880060
X356 1018 1096 2 1099 1105 1 1106 FA1 $T=621240 900600 1 0 $X=621240 $Y=895180
X357 999 1098 2 1097 1101 1 1105 FA1 $T=622480 890520 1 0 $X=622480 $Y=885100
X358 1088 1107 2 1110 1124 1 1121 FA1 $T=628680 910680 0 0 $X=628680 $Y=910300
X359 1070 1102 2 167 1115 1 1095 FA1 $T=646040 940920 1 180 $X=630540 $Y=940540
X360 1083 1109 2 1111 1095 1 169 FA1 $T=630540 951000 0 0 $X=630540 $Y=950620
X361 1075 1114 2 1119 1121 1 1115 FA1 $T=634260 920760 0 0 $X=634260 $Y=920380
X362 1073 1117 2 1122 1106 1 1124 FA1 $T=634880 900600 0 0 $X=634880 $Y=900220
X363 1104 1127 2 1130 172 1 1131 FA1 $T=640460 870360 0 0 $X=640460 $Y=869980
X364 1108 1143 2 1147 1131 1 1162 FA1 $T=657200 870360 0 0 $X=657200 $Y=869980
X365 1128 1176 2 1177 1184 1 1189 FA1 $T=672700 890520 0 0 $X=672700 $Y=890140
X366 1150 1160 2 1162 1144 1 1176 FA1 $T=673320 880440 0 0 $X=673320 $Y=880060
X367 1148 1181 2 1187 1189 1 1197 FA1 $T=676420 900600 1 0 $X=676420 $Y=895180
X368 1132 1344 2 1208 1341 1 1353 FA1 $T=757640 930840 1 0 $X=757640 $Y=925420
X369 1142 240 2 1321 1353 1 234 FA1 $T=775000 961080 0 180 $X=759500 $Y=955660
X370 260 1369 2 246 252 1 1359 FA1 $T=791120 870360 0 180 $X=775620 $Y=864940
X371 1361 1351 2 1376 1359 1 1384 FA1 $T=776240 890520 1 0 $X=776240 $Y=885100
X372 1379 1391 2 1375 1381 1 1403 FA1 $T=789880 920760 0 0 $X=789880 $Y=920380
X373 1406 1387 2 1385 1396 1 1381 FA1 $T=806000 910680 1 180 $X=790500 $Y=910300
X374 1380 1394 2 1338 1384 1 1396 FA1 $T=791120 900600 0 0 $X=791120 $Y=900220
X375 1402 1407 2 270 264 1 1424 FA1 $T=807240 880440 1 0 $X=807240 $Y=875020
X376 1415 1428 2 1432 1424 1 1440 FA1 $T=814680 890520 0 0 $X=814680 $Y=890140
X377 1416 1429 2 1393 1403 1 1445 FA1 $T=814680 951000 1 0 $X=814680 $Y=945580
X378 1437 1450 2 1449 1440 1 1455 FA1 $T=830180 890520 1 0 $X=830180 $Y=885100
X379 276 1444 2 1458 1417 1 1462 FA1 $T=835140 900600 1 0 $X=835140 $Y=895180
X380 283 1451 2 1446 1462 1 1447 FA1 $T=851260 910680 1 180 $X=835760 $Y=910300
X381 277 1459 2 1460 1447 1 1465 FA1 $T=839480 920760 0 0 $X=839480 $Y=920380
X382 1452 284 2 1461 1455 1 286 FA1 $T=843200 880440 1 0 $X=843200 $Y=875020
X383 280 1467 2 1470 1475 1 288 FA1 $T=847540 890520 1 0 $X=847540 $Y=885100
X384 1463 287 2 1473 1453 1 1477 FA1 $T=851880 900600 1 0 $X=851880 $Y=895180
X385 285 1468 2 1474 1465 1 1475 FA1 $T=853740 910680 0 0 $X=853740 $Y=910300
X386 1471 1452 2 1485 1457 1 1478 FA1 $T=863040 930840 0 0 $X=863040 $Y=930460
X387 1438 1484 2 1480 1499 1 1482 FA1 $T=884120 900600 0 180 $X=868620 $Y=895180
X388 1420 1476 2 1491 1482 1 1504 FA1 $T=870480 910680 0 0 $X=870480 $Y=910300
X389 1434 1496 2 1502 1504 1 1505 FA1 $T=871720 920760 0 0 $X=871720 $Y=920380
X390 1485 1510 2 1508 1493 1 1521 FA1 $T=878540 940920 0 0 $X=878540 $Y=940540
X391 1490 1495 2 1503 1505 1 1493 FA1 $T=894660 951000 0 180 $X=879160 $Y=945580
X392 1520 1525 2 1540 1544 1 1560 FA1 $T=895900 930840 0 0 $X=895900 $Y=930460
X393 1510 1562 2 1560 1574 1 1555 FA1 $T=932480 940920 1 180 $X=916980 $Y=940540
X394 1473 1589 2 1555 1521 1 1604 FA1 $T=930620 940920 1 0 $X=930620 $Y=935500
X395 1506 1623 2 1577 1604 1 1616 FA1 $T=946740 930840 1 0 $X=946740 $Y=925420
X396 353 2 365 370 358 1 341 FA1S $T=234360 930840 1 180 $X=222580 $Y=930460
X397 354 2 356 353 359 1 342 FA1S $T=235600 940920 0 180 $X=223820 $Y=935500
X398 356 2 347 352 350 1 377 FA1S $T=226920 920760 0 0 $X=226920 $Y=920380
X399 366 2 362 357 375 1 379 FA1S $T=231260 910680 1 0 $X=231260 $Y=905260
X400 367 2 366 378 341 1 403 FA1S $T=233740 910680 0 0 $X=233740 $Y=910300
X401 388 2 397 400 393 1 376 FA1S $T=254200 940920 0 180 $X=242420 $Y=935500
X402 385 2 371 15 413 1 20 FA1S $T=243660 870360 0 0 $X=243660 $Y=869980
X403 389 2 394 381 401 1 409 FA1S $T=245520 910680 1 0 $X=245520 $Y=905260
X404 394 2 392 387 411 1 418 FA1S $T=248000 900600 0 0 $X=248000 $Y=900220
X405 414 2 361 417 419 1 17 FA1S $T=267220 890520 0 180 $X=255440 $Y=885100
X406 423 2 429 435 428 1 359 FA1S $T=271560 940920 0 180 $X=259780 $Y=935500
X407 420 2 422 403 409 1 441 FA1S $T=260400 910680 1 0 $X=260400 $Y=905260
X408 422 2 379 418 414 1 439 FA1S $T=262260 900600 1 0 $X=262260 $Y=895180
X409 432 2 396 421 426 1 440 FA1S $T=265980 880440 1 0 $X=265980 $Y=875020
X410 30 2 385 440 29 1 33 FA1S $T=269700 870360 1 0 $X=269700 $Y=864940
X411 438 2 427 431 425 1 450 FA1S $T=271560 920760 0 0 $X=271560 $Y=920380
X412 445 2 455 452 446 1 433 FA1S $T=285200 930840 0 180 $X=273420 $Y=925420
X413 447 2 437 450 423 1 436 FA1S $T=286440 940920 0 180 $X=274660 $Y=935500
X414 401 2 454 453 443 1 464 FA1S $T=277760 890520 0 0 $X=277760 $Y=890140
X415 453 2 402 442 449 1 472 FA1S $T=279620 880440 0 0 $X=279620 $Y=880060
X416 459 2 481 432 472 1 41 FA1S $T=286440 870360 0 0 $X=286440 $Y=869980
X417 468 2 447 460 461 1 486 FA1S $T=287060 940920 1 0 $X=287060 $Y=935500
X418 478 2 458 471 445 1 489 FA1S $T=289540 920760 1 0 $X=289540 $Y=915340
X419 485 2 438 496 489 1 460 FA1S $T=302560 930840 0 180 $X=290780 $Y=925420
X420 484 2 457 470 495 1 496 FA1S $T=292640 910680 1 0 $X=292640 $Y=905260
X421 494 2 478 490 485 1 482 FA1S $T=297600 930840 0 0 $X=297600 $Y=930460
X422 506 2 507 518 511 1 514 FA1S $T=303180 930840 1 0 $X=303180 $Y=925420
X423 511 2 501 484 519 1 490 FA1S $T=315580 920760 0 180 $X=303800 $Y=915340
X424 507 2 500 475 520 1 519 FA1S $T=304420 900600 0 0 $X=304420 $Y=900220
X425 533 2 532 527 540 1 531 FA1S $T=317440 930840 0 0 $X=317440 $Y=930460
X426 540 2 538 521 535 1 518 FA1S $T=319300 920760 1 0 $X=319300 $Y=915340
X427 549 2 539 557 564 1 563 FA1S $T=331700 880440 0 0 $X=331700 $Y=880060
X428 553 2 545 547 549 1 559 FA1S $T=331700 890520 1 0 $X=331700 $Y=885100
X429 555 2 560 548 553 1 569 FA1S $T=334180 910680 0 0 $X=334180 $Y=910300
X430 558 2 523 572 52 1 577 FA1S $T=338520 870360 1 0 $X=338520 $Y=864940
X431 574 2 562 565 555 1 594 FA1S $T=344100 930840 0 0 $X=344100 $Y=930460
X432 586 2 566 579 574 1 599 FA1S $T=349060 951000 1 0 $X=349060 $Y=945580
X433 601 2 609 608 592 1 610 FA1S $T=358360 920760 1 0 $X=358360 $Y=915340
X434 605 2 612 610 595 1 556 FA1S $T=370140 930840 0 180 $X=358360 $Y=925420
X435 606 2 601 616 605 1 585 FA1S $T=370140 930840 1 180 $X=358360 $Y=930460
X436 59 2 598 611 586 1 624 FA1S $T=360840 951000 0 0 $X=360840 $Y=950620
X437 614 2 625 618 606 1 604 FA1S $T=375720 940920 0 180 $X=363940 $Y=935500
X438 625 2 644 617 640 1 616 FA1S $T=384400 930840 1 180 $X=372620 $Y=930460
X439 641 2 663 652 658 1 618 FA1S $T=394320 940920 0 180 $X=382540 $Y=935500
X440 657 2 647 649 637 1 658 FA1S $T=386260 930840 1 0 $X=386260 $Y=925420
X441 674 2 666 657 677 1 636 FA1S $T=404860 920760 1 180 $X=393080 $Y=920380
X442 670 2 66 665 672 1 683 FA1S $T=393700 890520 0 0 $X=393700 $Y=890140
X443 671 2 656 664 650 1 677 FA1S $T=394940 900600 0 0 $X=394940 $Y=900220
X444 681 2 669 671 683 1 680 FA1S $T=398660 910680 0 0 $X=398660 $Y=910300
X445 700 2 691 705 670 1 707 FA1S $T=406720 910680 1 0 $X=406720 $Y=905260
X446 735 2 79 717 722 1 748 FA1S $T=425320 900600 0 0 $X=425320 $Y=900220
X447 1640 2 1047 1036 1046 1 1026 FA1S $T=589000 920760 0 0 $X=589000 $Y=920380
X448 1080 2 1084 1086 1079 1 1065 FA1S $T=629920 951000 0 180 $X=618140 $Y=945580
X449 1079 2 1078 165 166 1 1072 FA1S $T=631160 961080 0 180 $X=619380 $Y=955660
X450 1091 2 1092 1094 1080 1 1071 FA1S $T=633020 930840 1 180 $X=621240 $Y=930460
X451 1127 2 174 176 173 1 171 FA1S $T=668360 870360 0 180 $X=656580 $Y=864940
X452 1140 2 1152 1154 1151 1 1133 FA1S $T=675800 951000 1 180 $X=664020 $Y=950620
X453 1151 2 1166 1155 178 1 1139 FA1S $T=677660 961080 0 180 $X=665880 $Y=955660
X454 1143 2 1169 1164 179 1 1130 FA1S $T=680140 870360 0 180 $X=668360 $Y=864940
X455 1153 2 1173 1172 1161 1 1146 FA1S $T=680760 910680 0 180 $X=668980 $Y=905260
X456 1159 2 1194 1190 1182 1 1165 FA1S $T=690060 951000 0 180 $X=678280 $Y=945580
X457 1161 2 1205 1238 1197 1 1149 FA1S $T=694400 910680 0 180 $X=682620 $Y=905260
X458 1155 2 1183 1212 1199 1 183 FA1S $T=694400 961080 0 180 $X=682620 $Y=955660
X459 1195 2 188 1209 186 1 1164 FA1S $T=695020 870360 1 180 $X=683240 $Y=869980
X460 1160 2 1206 1207 1195 1 1147 FA1S $T=696880 880440 0 180 $X=685100 $Y=875020
X461 1213 2 1221 1225 189 1 185 FA1S $T=700600 870360 0 180 $X=688820 $Y=864940
X462 1215 2 1218 1223 1222 1 1196 FA1S $T=701840 890520 1 180 $X=690060 $Y=890140
X463 1218 2 1228 1210 1216 1 1236 FA1S $T=693160 890520 1 0 $X=693160 $Y=885100
X464 1182 2 1227 1217 1232 1 1211 FA1S $T=696260 951000 0 0 $X=696260 $Y=950620
X465 1212 2 1174 1227 1198 1 201 FA1S $T=696880 961080 1 0 $X=696880 $Y=955660
X466 1238 2 1248 1230 1243 1 1187 FA1S $T=712380 900600 1 180 $X=700600 $Y=900220
X467 1184 2 1262 1278 1253 1 1144 FA1S $T=718580 890520 0 180 $X=706800 $Y=885100
X468 1253 2 202 210 1255 1 1207 FA1S $T=719200 870360 1 180 $X=707420 $Y=869980
X469 1248 2 1246 1241 1252 1 1266 FA1S $T=707420 900600 1 0 $X=707420 $Y=895180
X470 1255 2 205 212 1213 1 1169 FA1S $T=719820 870360 0 180 $X=708040 $Y=864940
X471 209 2 206 1250 1268 1 214 FA1S $T=711140 961080 1 0 $X=711140 $Y=955660
X472 1181 2 1271 1285 1269 1 1177 FA1S $T=728500 890520 1 180 $X=716720 $Y=890140
X473 1271 2 1276 1249 216 1 1262 FA1S $T=730980 880440 1 180 $X=719200 $Y=880060
X474 1274 2 218 1272 215 1 1206 FA1S $T=733460 880440 0 180 $X=721680 $Y=875020
X475 1243 2 1270 1266 1295 1 1285 FA1S $T=724160 900600 1 0 $X=724160 $Y=895180
X476 220 2 1273 1264 1281 1 1286 FA1S $T=724160 940920 0 0 $X=724160 $Y=940540
X477 1268 2 1293 1288 1284 1 217 FA1S $T=737800 961080 0 180 $X=726020 $Y=955660
X478 1276 2 1291 224 223 1 1272 FA1S $T=739040 870360 0 180 $X=727260 $Y=864940
X479 1269 2 226 1306 1274 1 1278 FA1S $T=744620 880440 1 180 $X=732840 $Y=880060
X480 1295 2 1287 1304 1296 1 1306 FA1S $T=736560 890520 0 0 $X=736560 $Y=890140
X481 1300 2 1294 1282 1298 1 1314 FA1S $T=737800 940920 0 0 $X=737800 $Y=940540
X482 1311 2 228 1326 1312 1 1301 FA1S $T=754540 890520 0 180 $X=742760 $Y=885100
X483 230 2 1315 1300 1286 1 235 FA1S $T=742760 961080 1 0 $X=742760 $Y=955660
X484 1318 2 1327 237 1323 1 1307 FA1S $T=758260 880440 1 180 $X=746480 $Y=880060
X485 1316 2 1307 1301 238 1 1332 FA1S $T=748340 880440 1 0 $X=748340 $Y=875020
X486 1317 2 231 1311 1318 1 1329 FA1S $T=748340 900600 1 0 $X=748340 $Y=895180
X487 1331 2 1330 1350 1339 1 1324 FA1S $T=767560 910680 1 180 $X=755780 $Y=910300
X488 1333 2 1331 1328 1317 1 1352 FA1S $T=757020 920760 1 0 $X=757020 $Y=915340
X489 1338 2 1329 1334 1316 1 1351 FA1S $T=759500 890520 0 0 $X=759500 $Y=890140
X490 1340 2 1346 1322 242 1 1368 FA1S $T=760740 870360 0 0 $X=760740 $Y=869980
X491 1341 2 1325 1192 1337 1 1208 FA1S $T=760740 930840 0 0 $X=760740 $Y=930460
X492 1348 2 1362 1357 1343 1 1328 FA1S $T=773140 940920 1 180 $X=761360 $Y=940540
X493 1349 2 1355 1324 1340 1 1334 FA1S $T=773760 900600 1 180 $X=761980 $Y=900220
X494 1346 2 1354 1336 1342 1 245 FA1S $T=763220 880440 1 0 $X=763220 $Y=875020
X495 1370 2 1365 1374 1348 1 1358 FA1S $T=786160 951000 0 180 $X=774380 $Y=945580
X496 1366 2 1372 1360 1364 1 1378 FA1S $T=775000 910680 0 0 $X=775000 $Y=910300
X497 1372 2 1363 1377 1371 1 1355 FA1S $T=788020 900600 1 180 $X=776240 $Y=900220
X498 1375 2 1366 1358 1333 1 1387 FA1S $T=779960 930840 0 0 $X=779960 $Y=930460
X499 1376 2 1368 1332 251 1 1369 FA1S $T=781820 880440 1 0 $X=781820 $Y=875020
X500 1383 2 1388 1390 1386 1 1374 FA1S $T=797940 940920 1 180 $X=786160 $Y=940540
X501 1385 2 1378 1352 1349 1 1394 FA1S $T=789260 910680 1 0 $X=789260 $Y=905260
X502 1392 2 1397 1399 1395 1 257 FA1S $T=805380 880440 1 180 $X=793600 $Y=880060
X503 1393 2 1383 1389 1370 1 1391 FA1S $T=796080 951000 1 0 $X=796080 $Y=945580
X504 1405 2 1413 1412 1401 1 1389 FA1S $T=812820 940920 1 180 $X=801040 $Y=940540
X505 1417 2 1409 1427 1419 1 265 FA1S $T=820260 900600 1 180 $X=808480 $Y=900220
X506 1414 2 1420 1402 1406 1 1423 FA1S $T=809100 910680 0 0 $X=809100 $Y=910300
X507 1419 2 1425 1410 1392 1 267 FA1S $T=823360 890520 0 180 $X=811580 $Y=885100
X508 1421 2 1405 1418 1422 1 1429 FA1S $T=814680 940920 1 0 $X=814680 $Y=935500
X509 1426 2 1434 1415 1379 1 1442 FA1S $T=819020 920760 0 0 $X=819020 $Y=920380
X510 1430 2 1438 269 1380 1 1443 FA1S $T=821500 900600 1 0 $X=821500 $Y=895180
X511 1433 2 272 271 1431 1 1435 FA1S $T=823360 880440 1 0 $X=823360 $Y=875020
X512 1448 2 278 275 1436 1 1432 FA1S $T=841960 870360 1 180 $X=830180 $Y=869980
X513 1461 2 1448 279 281 1 1450 FA1S $T=845060 870360 0 0 $X=845060 $Y=869980
X514 1464 2 1490 1437 1416 1 1456 FA1S $T=858700 951000 0 180 $X=846920 $Y=945580
X515 1469 2 296 292 1506 1 1488 FA1S $T=889700 870360 0 180 $X=877920 $Y=864940
X516 1508 2 1524 1520 1511 1 1495 FA1S $T=892800 930840 0 180 $X=881020 $Y=925420
X517 1512 2 1517 1509 1515 1 1522 FA1S $T=885980 910680 0 0 $X=885980 $Y=910300
X518 1524 2 1516 1527 1514 1 1502 FA1S $T=902100 920760 1 180 $X=890320 $Y=920380
X519 1542 2 1532 1537 1526 1 1511 FA1S $T=905200 920760 0 0 $X=905200 $Y=920380
X520 1558 2 1547 1554 1545 1 1573 FA1S $T=914500 880440 0 0 $X=914500 $Y=880060
X521 1561 2 1549 1536 1553 1 1571 FA1S $T=915740 890520 0 0 $X=915740 $Y=890140
X522 1565 2 1548 1557 1568 1 1574 FA1S $T=919460 910680 0 0 $X=919460 $Y=910300
X523 1566 2 1556 1563 1539 1 1576 FA1S $T=920080 870360 0 0 $X=920080 $Y=869980
X524 1567 2 1571 1552 1542 1 1562 FA1S $T=920080 920760 0 0 $X=920080 $Y=920380
X525 1569 2 1559 1551 1561 1 1581 FA1S $T=921320 910680 1 0 $X=921320 $Y=905260
X526 1572 2 1575 1564 1570 1 1582 FA1S $T=923180 890520 1 0 $X=923180 $Y=885100
X527 1577 2 1581 1584 1567 1 1589 FA1S $T=927520 930840 1 0 $X=927520 $Y=925420
X528 1583 2 1578 1580 1587 1 1595 FA1S $T=932480 870360 0 0 $X=932480 $Y=869980
X529 1588 2 1582 1586 1565 1 1584 FA1S $T=934960 920760 0 0 $X=934960 $Y=920380
X530 1587 2 1579 1530 1572 1 1600 FA1S $T=935580 880440 0 0 $X=935580 $Y=880060
X531 1591 2 1599 1585 1569 1 1601 FA1S $T=936820 910680 1 0 $X=936820 $Y=905260
X532 1597 2 1590 1593 1594 1 1599 FA1S $T=941160 900600 0 0 $X=941160 $Y=900220
X533 318 2 1596 1592 1613 1 1631 FA1S $T=946740 870360 0 0 $X=946740 $Y=869980
X534 1602 2 1601 1600 1588 1 1623 FA1S $T=952320 920760 0 0 $X=952320 $Y=920380
X535 1605 2 1595 1633 1591 1 1610 FA1S $T=959140 910680 1 0 $X=959140 $Y=905260
X536 1637 2 1639 1531 1597 1 1633 FA1S $T=974640 900600 0 180 $X=962860 $Y=895180
X537 324 2 327 1638 1583 1 1628 FA1S $T=975260 870360 1 180 $X=963480 $Y=869980
X538 322 2 1631 321 1637 1 1638 FA1S $T=964100 880440 1 0 $X=964100 $Y=875020
X539 323 2 1635 1617 1621 1 1639 FA1S $T=965340 890520 0 0 $X=965340 $Y=890140
X540 6 2 349 4 1 NR2 $T=225060 870360 0 180 $X=223200 $Y=864940
X541 343 2 355 346 1 NR2 $T=224440 890520 1 0 $X=224440 $Y=885100
X542 348 2 347 344 1 NR2 $T=226300 910680 0 180 $X=224440 $Y=905260
X543 346 2 350 9 1 NR2 $T=225060 910680 0 0 $X=225060 $Y=910300
X544 7 2 360 8 1 NR2 $T=226920 870360 0 0 $X=226920 $Y=869980
X545 343 2 351 344 1 NR2 $T=226920 890520 0 0 $X=226920 $Y=890140
X546 348 2 363 8 1 NR2 $T=231260 880440 1 0 $X=231260 $Y=875020
X547 348 2 345 346 1 NR2 $T=239940 900600 0 180 $X=238080 $Y=895180
X548 343 2 368 380 1 NR2 $T=238700 880440 1 0 $X=238700 $Y=875020
X549 348 2 369 374 1 NR2 $T=239320 890520 0 0 $X=239320 $Y=890140
X550 4 2 12 13 1 NR2 $T=239940 870360 1 0 $X=239940 $Y=864940
X551 386 2 365 372 1 NR2 $T=241800 930840 0 180 $X=239940 $Y=925420
X552 343 2 391 374 1 NR2 $T=246760 890520 0 180 $X=244900 $Y=885100
X553 348 2 383 380 1 NR2 $T=247380 880440 0 180 $X=245520 $Y=875020
X554 343 2 390 386 1 NR2 $T=245520 880440 0 0 $X=245520 $Y=880060
X555 380 2 375 372 1 NR2 $T=245520 900600 1 0 $X=245520 $Y=895180
X556 374 2 405 16 1 NR2 $T=246140 920760 0 0 $X=246140 $Y=920380
X557 380 2 370 395 1 NR2 $T=246140 930840 0 0 $X=246140 $Y=930460
X558 374 2 392 9 1 NR2 $T=249240 890520 0 0 $X=249240 $Y=890140
X559 348 2 399 386 1 NR2 $T=251720 890520 1 0 $X=251720 $Y=885100
X560 386 2 397 395 1 NR2 $T=251720 930840 1 0 $X=251720 $Y=925420
X561 386 2 387 16 1 NR2 $T=254820 900600 1 0 $X=254820 $Y=895180
X562 380 2 400 406 1 NR2 $T=257300 930840 1 0 $X=257300 $Y=925420
X563 344 2 398 9 1 NR2 $T=259780 910680 1 180 $X=257920 $Y=910300
X564 384 2 393 412 1 NR2 $T=257920 930840 0 0 $X=257920 $Y=930460
X565 384 2 358 406 1 NR2 $T=259160 930840 1 0 $X=259160 $Y=925420
X566 8 2 23 22 1 NR2 $T=261640 870360 0 180 $X=259780 $Y=864940
X567 384 2 411 395 1 NR2 $T=260400 900600 1 0 $X=260400 $Y=895180
X568 416 2 417 16 1 NR2 $T=264740 880440 1 180 $X=262880 $Y=880060
X569 25 2 413 27 1 NR2 $T=263500 870360 1 0 $X=263500 $Y=864940
X570 4 2 426 27 1 NR2 $T=263500 870360 0 0 $X=263500 $Y=869980
X571 416 2 421 9 1 NR2 $T=263500 880440 1 0 $X=263500 $Y=875020
X572 410 2 378 412 1 NR2 $T=263500 910680 0 0 $X=263500 $Y=910300
X573 346 2 415 16 1 NR2 $T=263500 920760 0 0 $X=263500 $Y=920380
X574 344 2 427 16 1 NR2 $T=268460 910680 1 180 $X=266600 $Y=910300
X575 384 2 431 434 1 NR2 $T=266600 920760 1 0 $X=266600 $Y=915340
X576 374 2 429 372 1 NR2 $T=267220 920760 0 0 $X=267220 $Y=920380
X577 430 2 408 434 1 NR2 $T=274660 910680 1 180 $X=272800 $Y=910300
X578 410 2 435 434 1 NR2 $T=272800 920760 1 0 $X=272800 $Y=915340
X579 386 2 442 9 1 NR2 $T=277140 880440 1 180 $X=275280 $Y=880060
X580 430 2 419 32 1 NR2 $T=275280 890520 1 0 $X=275280 $Y=885100
X581 424 2 437 412 1 NR2 $T=277140 930840 1 180 $X=275280 $Y=930460
X582 430 2 443 31 1 NR2 $T=275900 900600 0 0 $X=275900 $Y=900220
X583 420 2 26 373 1 NR2 $T=277760 961080 0 180 $X=275900 $Y=955660
X584 410 2 454 32 1 NR2 $T=283340 900600 1 180 $X=281480 $Y=900220
X585 8 2 449 372 1 NR2 $T=283960 880440 1 0 $X=283960 $Y=875020
X586 344 2 475 395 1 NR2 $T=288920 900600 1 180 $X=287060 $Y=900220
X587 424 2 470 434 1 NR2 $T=288920 910680 1 180 $X=287060 $Y=910300
X588 374 2 452 395 1 NR2 $T=288920 920760 1 180 $X=287060 $Y=920380
X589 463 2 446 406 1 NR2 $T=288920 930840 1 180 $X=287060 $Y=930460
X590 344 2 457 372 1 NR2 $T=289540 910680 0 180 $X=287680 $Y=905260
X591 346 2 458 395 1 NR2 $T=289540 920760 0 180 $X=287680 $Y=915340
X592 346 2 455 372 1 NR2 $T=289540 930840 0 180 $X=287680 $Y=925420
X593 40 2 466 36 1 NR2 $T=293880 961080 0 180 $X=292020 $Y=955660
X594 410 2 481 28 1 NR2 $T=296980 880440 1 180 $X=295120 $Y=880060
X595 463 2 471 504 1 NR2 $T=299460 920760 0 0 $X=299460 $Y=920380
X596 493 2 495 406 1 NR2 $T=301940 900600 1 180 $X=300080 $Y=900220
X597 486 2 487 456 1 NR2 $T=301940 961080 0 180 $X=300080 $Y=955660
X598 463 2 500 34 1 NR2 $T=301940 900600 1 0 $X=301940 $Y=895180
X599 503 2 505 502 1 NR2 $T=306900 940920 1 0 $X=306900 $Y=935500
X600 493 2 501 504 1 NR2 $T=310000 910680 1 180 $X=308140 $Y=910300
X601 510 2 503 513 1 NR2 $T=308760 940920 1 0 $X=308760 $Y=935500
X602 517 2 520 406 1 NR2 $T=316200 910680 0 180 $X=314340 $Y=905260
X603 525 2 521 406 1 NR2 $T=316200 910680 1 180 $X=314340 $Y=910300
X604 525 2 527 504 1 NR2 $T=316820 920760 1 0 $X=316820 $Y=915340
X605 517 2 535 504 1 NR2 $T=321160 910680 0 180 $X=319300 $Y=905260
X606 517 2 532 34 1 NR2 $T=320540 920760 0 0 $X=320540 $Y=920380
X607 493 2 538 34 1 NR2 $T=323020 910680 1 0 $X=323020 $Y=905260
X608 536 2 544 537 1 NR2 $T=327980 890520 0 180 $X=326120 $Y=885100
X609 525 2 542 34 1 NR2 $T=328600 920760 1 180 $X=326740 $Y=920380
X610 544 2 576 575 1 NR2 $T=346580 900600 0 0 $X=346580 $Y=900220
X611 583 2 593 588 1 NR2 $T=352780 910680 1 0 $X=352780 $Y=905260
X612 45 2 573 602 1 NR2 $T=361460 890520 1 0 $X=361460 $Y=885100
X613 424 2 600 602 1 NR2 $T=361460 910680 1 0 $X=361460 $Y=905260
X614 591 2 596 424 1 NR2 $T=363320 890520 0 0 $X=363320 $Y=890140
X615 591 2 597 607 1 NR2 $T=364560 900600 0 0 $X=364560 $Y=900220
X616 607 2 608 602 1 NR2 $T=367040 910680 1 180 $X=365180 $Y=910300
X617 424 2 609 621 1 NR2 $T=370760 910680 1 0 $X=370760 $Y=905260
X618 591 2 628 623 1 NR2 $T=371380 900600 0 0 $X=371380 $Y=900220
X619 591 2 642 524 1 NR2 $T=377580 900600 0 180 $X=375720 $Y=895180
X620 607 2 622 621 1 NR2 $T=376340 910680 1 0 $X=376340 $Y=905260
X621 591 2 634 645 1 NR2 $T=378200 900600 0 0 $X=378200 $Y=900220
X622 646 2 644 602 1 NR2 $T=384400 920760 1 180 $X=382540 $Y=920380
X623 607 2 647 60 1 NR2 $T=385020 920760 1 0 $X=385020 $Y=915340
X624 623 2 649 602 1 NR2 $T=387500 920760 1 180 $X=385640 $Y=920380
X625 646 2 663 621 1 NR2 $T=388120 910680 0 180 $X=386260 $Y=905260
X626 524 2 656 602 1 NR2 $T=389980 900600 0 180 $X=388120 $Y=895180
X627 524 2 665 621 1 NR2 $T=391220 900600 1 0 $X=391220 $Y=895180
X628 623 2 664 621 1 NR2 $T=391220 900600 0 0 $X=391220 $Y=900220
X629 646 2 666 60 1 NR2 $T=391840 920760 1 0 $X=391840 $Y=915340
X630 646 2 669 607 1 NR2 $T=394320 910680 1 0 $X=394320 $Y=905260
X631 667 2 676 678 1 NR2 $T=397420 880440 1 0 $X=397420 $Y=875020
X632 623 2 672 60 1 NR2 $T=397420 890520 1 0 $X=397420 $Y=885100
X633 706 2 691 60 1 NR2 $T=410440 920760 1 180 $X=408580 $Y=920380
X634 702 2 705 703 1 NR2 $T=411680 900600 0 0 $X=411680 $Y=900220
X635 707 2 713 681 1 NR2 $T=414160 910680 1 180 $X=412300 $Y=910300
X636 714 2 715 720 1 NR2 $T=417880 890520 1 0 $X=417880 $Y=885100
X637 706 2 717 712 1 NR2 $T=419740 900600 1 180 $X=417880 $Y=900220
X638 702 2 722 645 1 NR2 $T=422220 900600 1 180 $X=420360 $Y=900220
X639 706 2 732 645 1 NR2 $T=422840 910680 1 180 $X=420980 $Y=910300
X640 706 2 731 702 1 NR2 $T=424080 920760 0 0 $X=424080 $Y=920380
X641 743 2 749 708 1 NR2 $T=434620 951000 1 180 $X=432760 $Y=950620
X642 744 2 761 708 1 NR2 $T=435860 940920 0 0 $X=435860 $Y=940540
X643 756 2 765 763 1 NR2 $T=440820 880440 0 0 $X=440820 $Y=880060
X644 766 2 783 758 1 NR2 $T=444540 940920 0 0 $X=444540 $Y=940540
X645 780 2 777 784 1 NR2 $T=447640 920760 1 0 $X=447640 $Y=915340
X646 807 2 817 814 1 NR2 $T=462520 920760 1 0 $X=462520 $Y=915340
X647 820 2 818 805 1 NR2 $T=466860 961080 0 180 $X=465000 $Y=955660
X648 111 2 858 883 1 NR2 $T=502820 880440 0 180 $X=500960 $Y=875020
X649 882 2 878 874 1 NR2 $T=502820 951000 0 180 $X=500960 $Y=945580
X650 114 2 117 118 1 NR2 $T=510260 870360 1 0 $X=510260 $Y=864940
X651 906 2 904 911 1 NR2 $T=517080 890520 1 0 $X=517080 $Y=885100
X652 121 2 900 905 1 NR2 $T=518940 890520 0 0 $X=518940 $Y=890140
X653 970 2 964 973 1 NR2 $T=544360 900600 1 0 $X=544360 $Y=895180
X654 134 2 957 965 1 NR2 $T=549320 900600 0 0 $X=549320 $Y=900220
X655 983 2 952 981 1 NR2 $T=553040 940920 0 180 $X=551180 $Y=935500
X656 990 2 978 994 1 NR2 $T=557380 951000 1 0 $X=557380 $Y=945580
X657 142 2 141 143 1 NR2 $T=561100 951000 0 0 $X=561100 $Y=950620
X658 993 2 977 1002 1 NR2 $T=562340 920760 1 0 $X=562340 $Y=915340
X659 1044 2 1041 1049 1 NR2 $T=591480 951000 1 0 $X=591480 $Y=945580
X660 1058 2 1029 1052 1 NR2 $T=597680 930840 1 180 $X=595820 $Y=930460
X661 1077 2 1085 1082 1 NR2 $T=624340 880440 1 0 $X=624340 $Y=875020
X662 1145 2 1076 175 1 NR2 $T=668980 910680 1 180 $X=667120 $Y=910300
X663 1137 2 1138 1163 1 NR2 $T=672080 940920 1 0 $X=672080 $Y=935500
X664 1156 2 1158 1168 1 NR2 $T=675800 910680 0 0 $X=675800 $Y=910300
X665 1174 2 1137 1167 1 NR2 $T=680760 940920 0 180 $X=678900 $Y=935500
X666 177 2 1178 1170 1 NR2 $T=679520 910680 0 0 $X=679520 $Y=910300
X667 1208 2 1134 1202 1 NR2 $T=695640 910680 1 180 $X=693780 $Y=910300
X668 1219 2 1202 1193 1 NR2 $T=695640 920760 0 180 $X=693780 $Y=915340
X669 1214 2 1203 1163 1 NR2 $T=695640 951000 0 180 $X=693780 $Y=945580
X670 195 2 1228 197 1 NR2 $T=701220 880440 1 0 $X=701220 $Y=875020
X671 196 2 1221 198 1 NR2 $T=702460 870360 0 0 $X=702460 $Y=869980
X672 197 2 1222 198 1 NR2 $T=703080 890520 0 0 $X=703080 $Y=890140
X673 180 2 1225 195 1 NR2 $T=703700 870360 1 0 $X=703700 $Y=864940
X674 192 2 1249 198 1 NR2 $T=708040 880440 1 0 $X=708040 $Y=875020
X675 192 2 1241 203 1 NR2 $T=708040 890520 0 0 $X=708040 $Y=890140
X676 207 2 1246 198 1 NR2 $T=713000 890520 1 180 $X=711140 $Y=890140
X677 211 2 1252 204 1 NR2 $T=716720 900600 1 180 $X=714860 $Y=900220
X678 1254 2 1250 1251 1 NR2 $T=714860 951000 1 0 $X=714860 $Y=945580
X679 219 2 213 211 1 NR2 $T=725400 870360 0 180 $X=723540 $Y=864940
X680 219 2 1287 203 1 NR2 $T=732840 890520 1 0 $X=732840 $Y=885100
X681 1283 2 1292 1293 1 NR2 $T=735940 930840 0 0 $X=735940 $Y=930460
X682 225 2 1291 207 1 NR2 $T=740280 870360 1 180 $X=738420 $Y=869980
X683 1302 2 1296 204 1 NR2 $T=743380 900600 0 180 $X=741520 $Y=895180
X684 227 2 228 229 1 NR2 $T=744000 870360 0 0 $X=744000 $Y=869980
X685 1309 2 1304 211 1 NR2 $T=750820 900600 0 0 $X=750820 $Y=900220
X686 1310 2 1321 1314 1 NR2 $T=755780 951000 0 0 $X=755780 $Y=950620
X687 1302 2 1327 239 1 NR2 $T=758880 890520 1 0 $X=758880 $Y=885100
X688 241 2 1323 211 1 NR2 $T=761360 880440 1 180 $X=759500 $Y=880060
X689 241 2 1336 1302 1 NR2 $T=763840 890520 0 180 $X=761980 $Y=885100
X690 1302 2 1330 1345 1 NR2 $T=761980 910680 1 0 $X=761980 $Y=905260
X691 1347 2 1342 239 1 NR2 $T=768800 880440 1 180 $X=766940 $Y=880060
X692 1347 2 1312 1345 1 NR2 $T=768180 890520 1 0 $X=768180 $Y=885100
X693 1335 2 1339 244 1 NR2 $T=770660 910680 0 0 $X=770660 $Y=910300
X694 1347 2 1350 1356 1 NR2 $T=771280 910680 1 0 $X=771280 $Y=905260
X695 243 2 1354 1345 1 NR2 $T=773760 880440 0 0 $X=773760 $Y=880060
X696 243 2 1326 1356 1 NR2 $T=773760 890520 1 0 $X=773760 $Y=885100
X697 241 2 1343 203 1 NR2 $T=775620 890520 1 180 $X=773760 $Y=890140
X698 1302 2 1360 1356 1 NR2 $T=776860 910680 1 0 $X=776860 $Y=905260
X699 241 2 1363 1373 1 NR2 $T=779960 900600 1 0 $X=779960 $Y=895180
X700 1335 2 1364 1345 1 NR2 $T=779960 920760 1 0 $X=779960 $Y=915340
X701 1347 2 1362 249 1 NR2 $T=779960 920760 0 0 $X=779960 $Y=920380
X702 1373 2 1357 244 1 NR2 $T=781820 940920 0 180 $X=779960 $Y=935500
X703 1335 2 1365 1356 1 NR2 $T=779960 940920 0 0 $X=779960 $Y=940540
X704 243 2 1377 249 1 NR2 $T=787400 900600 0 180 $X=785540 $Y=895180
X705 253 2 1371 203 1 NR2 $T=788020 880440 1 180 $X=786160 $Y=880060
X706 1373 2 1388 1345 1 NR2 $T=797320 940920 1 0 $X=797320 $Y=935500
X707 249 2 1390 1367 1 NR2 $T=797940 930840 1 0 $X=797940 $Y=925420
X708 1382 2 1386 244 1 NR2 $T=802900 930840 1 180 $X=801040 $Y=930460
X709 249 2 1412 1335 1 NR2 $T=805380 930840 1 0 $X=805380 $Y=925420
X710 1410 2 1397 1398 1 NR2 $T=808480 890520 0 180 $X=806620 $Y=885100
X711 1400 2 1398 1404 1 NR2 $T=806620 890520 0 0 $X=806620 $Y=890140
X712 1382 2 1401 1345 1 NR2 $T=809720 940920 0 180 $X=807860 $Y=935500
X713 249 2 1418 1373 1 NR2 $T=812200 920760 0 0 $X=812200 $Y=920380
X714 1373 2 1413 1356 1 NR2 $T=812200 930840 1 0 $X=812200 $Y=925420
X715 268 2 1436 253 1 NR2 $T=818400 870360 1 0 $X=818400 $Y=864940
X716 1382 2 1422 1356 1 NR2 $T=821500 930840 0 180 $X=819640 $Y=925420
X717 1421 2 1454 1445 1 NR2 $T=837000 951000 0 180 $X=835140 $Y=945580
X718 1454 2 1453 274 1 NR2 $T=845680 930840 0 180 $X=843820 $Y=925420
X719 1489 2 1480 1483 1 NR2 $T=876680 890520 1 180 $X=874820 $Y=890140
X720 297 2 1499 298 1 NR2 $T=889700 900600 1 0 $X=889700 $Y=895180
X721 299 2 1481 298 1 NR2 $T=894040 890520 1 180 $X=892180 $Y=890140
X722 297 2 1514 243 1 NR2 $T=893420 900600 1 0 $X=893420 $Y=895180
X723 1523 2 1500 301 1 NR2 $T=895280 870360 0 0 $X=895280 $Y=869980
X724 1534 2 1516 1367 1 NR2 $T=897140 920760 0 180 $X=895280 $Y=915340
X725 303 2 1501 301 1 NR2 $T=897140 890520 0 0 $X=897140 $Y=890140
X726 1519 2 1525 1518 1 NR2 $T=899000 910680 1 0 $X=899000 $Y=905260
X727 1523 2 1527 1535 1 NR2 $T=899000 910680 0 0 $X=899000 $Y=910300
X728 299 2 1526 301 1 NR2 $T=902100 890520 0 180 $X=900240 $Y=885100
X729 303 2 1536 256 1 NR2 $T=903960 900600 0 0 $X=903960 $Y=900220
X730 1529 2 1531 1533 1 NR2 $T=904580 880440 1 0 $X=904580 $Y=875020
X731 1528 2 1532 1535 1 NR2 $T=904580 910680 1 0 $X=904580 $Y=905260
X732 1534 2 1537 1335 1 NR2 $T=905820 920760 1 0 $X=905820 $Y=915340
X733 1543 2 1548 1538 1 NR2 $T=908300 910680 1 180 $X=906440 $Y=910300
X734 312 2 1541 301 1 NR2 $T=910780 870360 1 0 $X=910780 $Y=864940
X735 1523 2 1549 310 1 NR2 $T=910780 890520 0 0 $X=910780 $Y=890140
X736 1550 2 1551 1546 1 NR2 $T=914500 900600 1 180 $X=912640 $Y=900220
X737 1523 2 1544 1367 1 NR2 $T=913880 930840 1 0 $X=913880 $Y=925420
X738 313 2 1553 301 1 NR2 $T=918220 870360 0 180 $X=916360 $Y=864940
X739 1523 2 1564 256 1 NR2 $T=918840 890520 1 0 $X=918840 $Y=885100
X740 1528 2 1557 1367 1 NR2 $T=918840 910680 1 0 $X=918840 $Y=905260
X741 314 2 1554 298 1 NR2 $T=921320 870360 0 180 $X=919460 $Y=864940
X742 299 2 1568 1535 1 NR2 $T=922560 900600 0 0 $X=922560 $Y=900220
X743 314 2 1563 304 1 NR2 $T=925040 870360 1 0 $X=925040 $Y=864940
X744 316 2 1570 304 1 NR2 $T=930000 880440 1 180 $X=928140 $Y=880060
X745 1528 2 1575 310 1 NR2 $T=928140 900600 0 0 $X=928140 $Y=900220
X746 1528 2 1594 256 1 NR2 $T=933100 900600 0 180 $X=931240 $Y=895180
X747 313 2 317 1382 1 NR2 $T=934340 870360 1 0 $X=934340 $Y=864940
X748 299 2 1592 1382 1 NR2 $T=938680 880440 0 180 $X=936820 $Y=875020
X749 299 2 1590 310 1 NR2 $T=938060 890520 0 0 $X=938060 $Y=890140
X750 312 2 1596 310 1 NR2 $T=943020 880440 1 0 $X=943020 $Y=875020
X751 312 2 1593 1535 1 NR2 $T=944880 890520 0 0 $X=944880 $Y=890140
X752 316 2 1613 1367 1 NR2 $T=949220 880440 1 0 $X=949220 $Y=875020
X753 316 2 1621 1535 1 NR2 $T=952320 890520 0 180 $X=950460 $Y=885100
X754 312 2 1617 1367 1 NR2 $T=952940 890520 1 180 $X=951080 $Y=890140
X755 1528 2 1635 1382 1 NR2 $T=959760 890520 1 180 $X=957900 $Y=890140
X756 467 469 2 1 474 OR2 $T=290780 940920 0 0 $X=290780 $Y=940540
X757 514 494 2 1 498 OR2 $T=310620 940920 0 0 $X=310620 $Y=940540
X758 410 430 2 1 537 OR2 $T=316820 880440 1 0 $X=316820 $Y=875020
X759 510 513 2 1 534 OR2 $T=319920 940920 1 0 $X=319920 $Y=935500
X760 45 430 2 1 536 OR2 $T=322400 870360 0 0 $X=322400 $Y=869980
X761 578 573 2 1 561 OR2 $T=349060 890520 0 180 $X=346580 $Y=885100
X762 68 69 2 1 667 OR2 $T=398660 870360 1 0 $X=398660 $Y=864940
X763 699 686 2 1 696 OR2 $T=413540 880440 1 180 $X=411060 $Y=880060
X764 72 684 2 1 708 OR2 $T=411680 961080 1 0 $X=411680 $Y=955660
X765 662 721 2 1 714 OR2 $T=421600 870360 1 180 $X=419120 $Y=869980
X766 693 728 2 1 734 OR2 $T=423460 890520 0 0 $X=423460 $Y=890140
X767 733 734 2 1 737 OR2 $T=429040 890520 1 0 $X=429040 $Y=885100
X768 668 739 2 1 756 OR2 $T=435240 880440 0 0 $X=435240 $Y=880060
X769 762 759 2 1 768 OR2 $T=441440 910680 1 0 $X=441440 $Y=905260
X770 793 789 2 1 787 OR2 $T=454460 930840 1 180 $X=451980 $Y=930460
X771 736 791 2 1 799 OR2 $T=453220 900600 0 0 $X=453220 $Y=900220
X772 726 792 2 1 807 OR2 $T=453220 920760 1 0 $X=453220 $Y=915340
X773 795 801 2 1 96 OR2 $T=458180 961080 1 0 $X=458180 $Y=955660
X774 798 799 2 1 811 OR2 $T=459420 910680 1 0 $X=459420 $Y=905260
X775 826 819 2 1 820 OR2 $T=471200 951000 1 0 $X=471200 $Y=945580
X776 848 109 2 1 862 OR2 $T=491660 951000 0 0 $X=491660 $Y=950620
X777 855 856 2 1 882 OR2 $T=494760 951000 1 0 $X=494760 $Y=945580
X778 892 891 2 1 870 OR2 $T=507160 930840 0 180 $X=504680 $Y=925420
X779 865 881 2 1 892 OR2 $T=504680 930840 0 0 $X=504680 $Y=930460
X780 888 893 2 1 895 OR2 $T=506540 870360 0 0 $X=506540 $Y=869980
X781 846 842 2 1 903 OR2 $T=509640 870360 0 0 $X=509640 $Y=869980
X782 890 116 2 1 850 OR2 $T=513360 880440 1 180 $X=510880 $Y=880060
X783 895 903 2 1 922 OR2 $T=518320 870360 1 0 $X=518320 $Y=864940
X784 915 917 2 1 921 OR2 $T=521420 890520 1 0 $X=521420 $Y=885100
X785 940 923 2 1 920 OR2 $T=525760 940920 0 180 $X=523280 $Y=935500
X786 921 928 2 1 919 OR2 $T=527000 880440 0 180 $X=524520 $Y=875020
X787 916 885 2 1 928 OR2 $T=524520 890520 0 0 $X=524520 $Y=890140
X788 919 922 2 1 125 OR2 $T=525140 870360 1 0 $X=525140 $Y=864940
X789 924 920 2 1 934 OR2 $T=525760 930840 1 0 $X=525760 $Y=925420
X790 124 943 2 1 924 OR2 $T=533200 951000 1 180 $X=530720 $Y=950620
X791 948 934 2 1 128 OR2 $T=533820 880440 0 0 $X=533820 $Y=880060
X792 966 131 2 1 947 OR2 $T=543120 880440 1 180 $X=540640 $Y=880060
X793 950 979 2 1 948 OR2 $T=553660 920760 1 180 $X=551180 $Y=920380
X794 986 982 2 1 967 OR2 $T=553660 951000 1 180 $X=551180 $Y=950620
X795 991 987 2 1 953 OR2 $T=557380 920760 0 180 $X=554900 $Y=915340
X796 988 992 2 1 979 OR2 $T=559240 930840 1 180 $X=556760 $Y=930460
X797 996 1001 2 1 950 OR2 $T=565440 920760 1 180 $X=562960 $Y=920380
X798 1040 1042 2 1 1019 OR2 $T=589000 920760 0 180 $X=586520 $Y=915340
X799 1037 1039 2 1 1020 OR2 $T=592100 940920 1 180 $X=589620 $Y=940540
X800 1174 1163 2 1 1154 OR2 $T=680760 940920 1 180 $X=678280 $Y=940540
X801 373 35 420 2 1 ND2S $T=285820 961080 0 180 $X=283960 $Y=955660
X802 561 554 568 2 1 ND2S $T=343480 900600 1 0 $X=343480 $Y=895180
X803 587 580 582 2 1 ND2S $T=349680 910680 0 0 $X=349680 $Y=910300
X804 578 568 573 2 1 ND2S $T=350300 890520 1 0 $X=350300 $Y=885100
X805 588 582 583 2 1 ND2S $T=354020 900600 1 180 $X=352160 $Y=900220
X806 627 620 614 2 1 ND2S $T=375720 940920 0 0 $X=375720 $Y=940540
X807 633 630 631 2 1 ND2S $T=376960 951000 1 0 $X=376960 $Y=945580
X808 626 632 627 2 1 ND2S $T=377580 940920 0 0 $X=377580 $Y=940540
X809 635 631 638 2 1 ND2S $T=378820 940920 1 0 $X=378820 $Y=935500
X810 678 685 667 2 1 ND2S $T=399280 870360 1 180 $X=397420 $Y=869980
X811 688 690 698 2 1 ND2S $T=406720 930840 0 180 $X=404860 $Y=925420
X812 681 698 707 2 1 ND2S $T=412300 920760 0 0 $X=412300 $Y=920380
X813 720 719 714 2 1 ND2S $T=419740 880440 0 180 $X=417880 $Y=875020
X814 716 744 747 2 1 ND2S $T=435240 940920 1 0 $X=435240 $Y=935500
X815 763 764 756 2 1 ND2S $T=440820 890520 0 180 $X=438960 $Y=885100
X816 784 782 780 2 1 ND2S $T=449500 910680 0 180 $X=447640 $Y=905260
X817 94 767 95 2 1 ND2S $T=458180 870360 0 0 $X=458180 $Y=869980
X818 814 822 807 2 1 ND2S $T=464380 920760 1 180 $X=462520 $Y=920380
X819 805 812 820 2 1 ND2S $T=465620 951000 0 0 $X=465620 $Y=950620
X820 850 847 859 2 1 ND2S $T=491040 890520 0 0 $X=491040 $Y=890140
X821 849 857 853 2 1 ND2S $T=492280 880440 1 0 $X=492280 $Y=875020
X822 883 853 111 2 1 ND2S $T=500960 870360 0 0 $X=500960 $Y=869980
X823 874 864 882 2 1 ND2S $T=500960 940920 0 0 $X=500960 $Y=940540
X824 890 859 116 2 1 ND2S $T=504680 880440 0 0 $X=504680 $Y=880060
X825 898 884 896 2 1 ND2S $T=511500 910680 1 0 $X=511500 $Y=905260
X826 905 896 121 2 1 ND2S $T=515840 900600 1 0 $X=515840 $Y=895180
X827 947 931 955 2 1 ND2S $T=533820 890520 1 0 $X=533820 $Y=885100
X828 972 938 951 2 1 ND2S $T=536920 910680 1 0 $X=536920 $Y=905260
X829 953 914 958 2 1 ND2S $T=536920 920760 1 0 $X=536920 $Y=915340
X830 966 955 131 2 1 ND2S $T=539400 890520 0 0 $X=539400 $Y=890140
X831 965 951 134 2 1 ND2S $T=542500 900600 0 0 $X=542500 $Y=900220
X832 967 963 954 2 1 ND2S $T=544360 951000 0 180 $X=542500 $Y=945580
X833 975 959 960 2 1 ND2S $T=548080 930840 0 0 $X=548080 $Y=930460
X834 991 958 987 2 1 ND2S $T=549940 910680 0 0 $X=549940 $Y=910300
X835 981 960 983 2 1 ND2S $T=551800 930840 0 0 $X=551800 $Y=930460
X836 986 954 982 2 1 ND2S $T=551800 951000 1 0 $X=551800 $Y=945580
X837 880 138 989 2 1 ND2S $T=554900 900600 0 0 $X=554900 $Y=900220
X838 1011 1005 1014 2 1 ND2S $T=568540 961080 1 0 $X=568540 $Y=955660
X839 1020 1004 1031 2 1 ND2S $T=578460 951000 1 0 $X=578460 $Y=945580
X840 1019 1024 1033 2 1 ND2S $T=580940 910680 0 0 $X=580940 $Y=910300
X841 1034 1016 1025 2 1 ND2S $T=584040 930840 0 0 $X=584040 $Y=930460
X842 1037 1031 1039 2 1 ND2S $T=584040 940920 0 0 $X=584040 $Y=940540
X843 154 1014 153 2 1 ND2S $T=586520 951000 0 0 $X=586520 $Y=950620
X844 1040 1033 1042 2 1 ND2S $T=587140 910680 0 0 $X=587140 $Y=910300
X845 1052 1025 1058 2 1 ND2S $T=595820 940920 1 0 $X=595820 $Y=935500
X846 190 1216 194 2 1 ND2S $T=696880 870360 0 0 $X=696880 $Y=869980
X847 1204 1173 1220 2 1 ND2S $T=696880 910680 1 0 $X=696880 $Y=905260
X848 191 1210 1220 2 1 ND2S $T=697500 880440 1 0 $X=697500 $Y=875020
X849 1201 1223 1220 2 1 ND2S $T=700600 900600 0 180 $X=698740 $Y=895180
X850 1235 1232 1214 2 1 ND2S $T=704320 940920 1 180 $X=702460 $Y=940540
X851 1239 1263 1244 2 1 ND2S $T=720440 951000 1 0 $X=720440 $Y=945580
X852 221 1270 1259 2 1 ND2S $T=724780 900600 1 180 $X=722920 $Y=900220
X853 1265 1294 1244 2 1 ND2S $T=729740 951000 1 180 $X=727880 $Y=950620
X854 1305 1284 1277 2 1 ND2S $T=738420 951000 0 0 $X=738420 $Y=950620
X855 1283 1298 1175 2 1 ND2S $T=742140 930840 1 180 $X=740280 $Y=930460
X856 1290 1303 1283 2 1 ND2S $T=744620 940920 0 180 $X=742760 $Y=935500
X857 1308 1320 1313 2 1 ND2S $T=755780 940920 1 0 $X=755780 $Y=935500
X858 232 1408 273 2 1 ND2S $T=817780 870360 0 0 $X=817780 $Y=869980
X859 291 1497 248 2 1 ND2S $T=876680 870360 1 180 $X=874820 $Y=869980
X860 291 1483 1486 2 1 ND2S $T=874820 890520 1 0 $X=874820 $Y=885100
X861 1487 1479 1486 2 1 ND2S $T=876060 910680 1 0 $X=876060 $Y=905260
X862 295 1489 293 2 1 ND2S $T=880400 890520 0 0 $X=880400 $Y=890140
X863 295 1498 1507 2 1 ND2S $T=887220 890520 1 0 $X=887220 $Y=885100
X864 302 1519 1507 2 1 ND2S $T=897760 890520 0 180 $X=895900 $Y=885100
X865 295 1529 306 2 1 ND2S $T=900240 880440 0 180 $X=898380 $Y=875020
X866 311 1518 293 2 1 ND2S $T=900240 900600 0 180 $X=898380 $Y=895180
X867 309 1533 307 2 1 ND2S $T=906440 870360 1 180 $X=904580 $Y=869980
X868 311 1543 1507 2 1 ND2S $T=909540 900600 1 180 $X=907680 $Y=900220
X869 309 1546 293 2 1 ND2S $T=910160 890520 0 180 $X=908300 $Y=885100
X870 302 1545 221 2 1 ND2S $T=912020 880440 1 180 $X=910160 $Y=880060
X871 308 1538 293 2 1 ND2S $T=912020 910680 0 180 $X=910160 $Y=905260
X872 311 1547 248 2 1 ND2S $T=915120 890520 0 180 $X=913260 $Y=885100
X873 308 1550 1507 2 1 ND2S $T=915740 910680 0 180 $X=913880 $Y=905260
X874 311 1556 221 2 1 ND2S $T=916360 870360 0 0 $X=916360 $Y=869980
X875 1606 1607 1609 2 1 ND2S $T=949840 910680 0 0 $X=949840 $Y=910300
X876 1605 1618 1628 2 1 ND2S $T=953560 880440 0 0 $X=953560 $Y=880060
X877 1619 1620 1622 2 1 ND2S $T=955420 880440 0 0 $X=955420 $Y=880060
X878 1624 1625 1628 2 1 ND2S $T=957280 880440 0 0 $X=957280 $Y=880060
X879 858 108 1 853 845 2 OAI12H $T=494760 890520 0 180 $X=488560 $Y=885100
X880 904 872 1 850 894 2 OAI12H $T=515840 890520 1 180 $X=509640 $Y=890140
X881 900 873 1 896 929 2 OAI12H $T=515840 900600 0 0 $X=515840 $Y=900220
X882 957 941 1 951 912 2 OAI12H $T=539400 910680 1 180 $X=533200 $Y=910300
X883 952 956 1 960 962 2 OAI12H $T=535060 940920 0 0 $X=535060 $Y=940540
X884 964 910 1 947 937 2 OAI12H $T=542500 900600 0 180 $X=536300 $Y=895180
X885 977 942 1 953 969 2 OAI12H $T=551800 920760 0 180 $X=545600 $Y=915340
X886 978 971 1 967 133 2 OAI12H $T=551800 961080 0 180 $X=545600 $Y=955660
X887 149 145 1 1014 1003 2 OAI12H $T=579080 961080 0 180 $X=572880 $Y=955660
X888 1029 1013 1 1025 1021 2 OAI12H $T=580940 930840 0 180 $X=574740 $Y=925420
X889 1634 1612 1 1626 1630 2 OAI12H $T=961000 910680 0 0 $X=961000 $Y=910300
X890 1636 1624 1 1632 326 2 OAI12H $T=966580 880440 0 0 $X=966580 $Y=880060
X891 37 36 2 483 466 1 AOI12H $T=286440 951000 0 0 $X=286440 $Y=950620
X892 94 85 2 99 97 1 AOI12H $T=468720 870360 0 180 $X=462520 $Y=864940
X893 850 845 2 873 860 1 AOI12H $T=489180 900600 1 0 $X=489180 $Y=895180
X894 853 110 2 872 858 1 AOI12H $T=496000 890520 1 0 $X=496000 $Y=885100
X895 896 894 2 910 900 1 AOI12H $T=508400 900600 1 0 $X=508400 $Y=895180
X896 947 929 2 941 939 1 AOI12H $T=535060 900600 0 180 $X=528860 $Y=895180
X897 953 912 2 956 961 1 AOI12H $T=535680 930840 1 0 $X=535680 $Y=925420
X898 967 962 2 130 949 1 AOI12H $T=543740 961080 0 180 $X=537540 $Y=955660
X899 951 937 2 942 957 1 AOI12H $T=540640 910680 0 0 $X=540640 $Y=910300
X900 960 969 2 971 952 1 AOI12H $T=548080 940920 0 180 $X=541880 $Y=935500
X901 139 133 2 140 141 1 AOI12H $T=553660 961080 1 0 $X=553660 $Y=955660
X902 1020 1003 2 1013 1015 1 AOI12H $T=575980 940920 0 180 $X=569780 $Y=935500
X903 1019 1021 2 1009 1028 1 AOI12H $T=574120 920760 1 0 $X=574120 $Y=915340
X904 486 456 509 2 1 XOR2HS $T=305040 961080 1 0 $X=305040 $Y=955660
X905 537 536 530 2 1 XOR2HS $T=324260 890520 0 180 $X=318680 $Y=885100
X906 580 576 570 2 1 XOR2HS $T=351540 910680 0 180 $X=345960 $Y=905260
X907 528 558 581 2 1 XOR2HS $T=347200 870360 0 0 $X=347200 $Y=869980
X908 776 761 87 2 1 XOR2HS $T=445780 951000 0 0 $X=445780 $Y=950620
X909 767 90 89 2 1 XOR2HS $T=456320 870360 0 180 $X=450740 $Y=864940
X910 100 99 788 2 1 XOR2HS $T=469960 870360 1 180 $X=464380 $Y=869980
X911 857 108 868 2 1 XOR2HS $T=492280 870360 0 0 $X=492280 $Y=869980
X912 847 872 876 2 1 XOR2HS $T=495380 890520 0 0 $X=495380 $Y=890140
X913 884 873 841 2 1 XOR2HS $T=502820 910680 0 180 $X=497240 $Y=905260
X914 914 942 932 2 1 XOR2HS $T=533820 920760 0 180 $X=528240 $Y=915340
X915 931 910 926 2 1 XOR2HS $T=534440 890520 1 180 $X=528860 $Y=890140
X916 938 941 869 2 1 XOR2HS $T=535060 910680 0 180 $X=529480 $Y=905260
X917 959 956 851 2 1 XOR2HS $T=539400 930840 1 180 $X=533820 $Y=930460
X918 963 971 974 2 1 XOR2HS $T=544360 951000 0 0 $X=544360 $Y=950620
X919 1005 145 930 2 1 XOR2HS $T=567300 961080 0 180 $X=561720 $Y=955660
X920 1016 1013 918 2 1 XOR2HS $T=574120 930840 1 180 $X=568540 $Y=930460
X921 1004 1017 997 2 1 XOR2HS $T=574740 940920 1 180 $X=569160 $Y=940540
X922 1074 164 162 2 1 XOR2HS $T=618760 870360 1 180 $X=613180 $Y=869980
X923 509 508 515 2 1 XNR2HS $T=307520 951000 0 0 $X=307520 $Y=950620
X924 544 554 551 2 1 XNR2HS $T=340380 900600 0 180 $X=334800 $Y=895180
X925 69 68 67 2 1 XNR2HS $T=395560 870360 0 180 $X=389980 $Y=864940
X926 690 694 689 2 1 XNR2HS $T=406720 940920 0 0 $X=406720 $Y=940540
X927 692 72 701 2 1 XNR2HS $T=407960 951000 0 0 $X=407960 $Y=950620
X928 728 693 720 2 1 XNR2HS $T=426560 890520 0 180 $X=420980 $Y=885100
X929 721 662 699 2 1 XNR2HS $T=426560 880440 1 0 $X=426560 $Y=875020
X930 739 668 733 2 1 XNR2HS $T=433380 880440 1 180 $X=427800 $Y=880060
X931 750 708 757 2 1 XNR2HS $T=435860 961080 1 0 $X=435860 $Y=955660
X932 767 85 83 2 1 XNR2HS $T=444540 870360 0 180 $X=438960 $Y=864940
X933 781 778 786 2 1 XNR2HS $T=447640 940920 1 0 $X=447640 $Y=935500
X934 791 736 784 2 1 XNR2HS $T=456320 910680 0 180 $X=450740 $Y=905260
X935 792 726 798 2 1 XNR2HS $T=456940 910680 0 0 $X=456940 $Y=910300
X936 801 795 805 2 1 XNR2HS $T=457560 951000 0 0 $X=457560 $Y=950620
X937 819 826 793 2 1 XNR2HS $T=473060 940920 0 180 $X=467480 $Y=935500
X938 100 101 829 2 1 XNR2HS $T=471200 870360 0 0 $X=471200 $Y=869980
X939 847 845 833 2 1 XNR2HS $T=487940 890520 1 180 $X=482360 $Y=890140
X940 856 855 848 2 1 XNR2HS $T=493520 951000 0 180 $X=487940 $Y=945580
X941 857 110 875 2 1 XNR2HS $T=494760 870360 1 0 $X=494760 $Y=864940
X942 881 865 874 2 1 XNR2HS $T=501580 930840 1 180 $X=496000 $Y=930460
X943 884 894 889 2 1 XNR2HS $T=509020 910680 0 180 $X=503440 $Y=905260
X944 914 912 897 2 1 XNR2HS $T=520800 920760 0 180 $X=515220 $Y=915340
X945 931 929 863 2 1 XNR2HS $T=528240 910680 0 180 $X=522660 $Y=905260
X946 938 937 927 2 1 XNR2HS $T=531960 910680 1 180 $X=526380 $Y=910300
X947 963 962 843 2 1 XNR2HS $T=541880 951000 1 180 $X=536300 $Y=950620
X948 959 969 946 2 1 XNR2HS $T=545600 930840 1 180 $X=540020 $Y=930460
X949 1004 1003 933 2 1 XNR2HS $T=567300 940920 1 180 $X=561720 $Y=940540
X950 1005 146 1006 2 1 XNR2HS $T=571020 951000 1 180 $X=565440 $Y=950620
X951 1024 1021 1010 2 1 XNR2HS $T=576600 910680 1 180 $X=571020 $Y=910300
X952 1016 1030 1008 2 1 XNR2HS $T=581560 930840 1 180 $X=575980 $Y=930460
X953 829 834 2 1 842 788 MUX2 $T=480500 870360 0 0 $X=480500 $Y=869980
X954 107 834 2 1 846 104 MUX2 $T=491040 870360 1 180 $X=486700 $Y=869980
X955 889 886 2 1 885 841 MUX2 $T=507160 900600 0 180 $X=502820 $Y=895180
X956 875 112 2 1 893 868 MUX2 $T=503440 870360 1 0 $X=503440 $Y=864940
X957 876 886 2 1 888 833 MUX2 $T=503440 890520 0 0 $X=503440 $Y=890140
X958 888 895 2 1 902 846 MUX2 $T=509640 880440 1 0 $X=509640 $Y=875020
X959 921 919 2 1 913 895 MUX2 $T=523900 870360 1 180 $X=519560 $Y=869980
X960 927 122 2 1 917 869 MUX2 $T=525140 910680 1 180 $X=520800 $Y=910300
X961 926 886 2 1 916 863 MUX2 $T=525760 900600 0 180 $X=521420 $Y=895180
X962 932 122 2 1 915 897 MUX2 $T=527000 920760 0 180 $X=522660 $Y=915340
X963 915 921 2 1 944 916 MUX2 $T=527000 890520 1 0 $X=527000 $Y=885100
X964 946 122 2 1 923 851 MUX2 $T=531960 930840 1 180 $X=527620 $Y=930460
X965 944 919 2 1 935 902 MUX2 $T=532580 870360 1 180 $X=528240 $Y=869980
X966 123 122 2 1 943 127 MUX2 $T=528240 961080 1 0 $X=528240 $Y=955660
X967 124 924 2 1 945 940 MUX2 $T=528860 940920 0 0 $X=528860 $Y=940540
X968 950 948 2 1 936 924 MUX2 $T=534440 930840 0 180 $X=530100 $Y=925420
X969 974 122 2 1 940 843 MUX2 $T=535680 951000 0 180 $X=531340 $Y=945580
X970 948 128 2 1 126 919 MUX2 $T=536300 870360 0 180 $X=531960 $Y=864940
X971 968 128 2 1 129 935 MUX2 $T=541880 870360 1 180 $X=537540 $Y=869980
X972 936 128 2 1 132 913 MUX2 $T=539400 870360 1 0 $X=539400 $Y=864940
X973 985 948 2 1 968 945 MUX2 $T=548700 930840 0 180 $X=544360 $Y=925420
X974 997 112 2 1 988 933 MUX2 $T=560480 940920 0 180 $X=556140 $Y=935500
X975 996 950 2 1 985 988 MUX2 $T=561100 920760 1 180 $X=556760 $Y=920380
X976 1008 1009 2 1 1001 918 MUX2 $T=566680 930840 1 180 $X=562340 $Y=930460
X977 1006 1009 2 1 992 930 MUX2 $T=567300 940920 0 180 $X=562960 $Y=935500
X978 1026 1009 2 1 996 1010 MUX2 $T=572880 920760 1 180 $X=568540 $Y=920380
X979 76 1 2 709 DELB $T=416640 870360 1 0 $X=416640 $Y=864940
X980 803 1 2 802 DELB $T=459420 880440 1 0 $X=459420 $Y=875020
X981 813 1 2 810 DELB $T=463140 890520 0 0 $X=463140 $Y=890140
X982 823 1 2 827 DELB $T=468100 880440 1 0 $X=468100 $Y=875020
X983 824 1 2 808 DELB $T=468100 900600 0 0 $X=468100 $Y=900220
X984 830 1 2 836 DELB $T=474920 951000 0 0 $X=474920 $Y=950620
X985 832 1 2 831 DELB $T=476780 930840 0 0 $X=476780 $Y=930460
X986 838 1 2 835 DELB $T=481740 900600 0 0 $X=481740 $Y=900220
X987 844 1 2 837 DELB $T=485460 920760 1 0 $X=485460 $Y=915340
X988 871 1 2 866 DELB $T=496000 920760 1 0 $X=496000 $Y=915340
X989 115 1 2 119 DELB $T=509640 961080 1 0 $X=509640 $Y=955660
X990 907 1 2 901 DELB $T=516460 961080 1 0 $X=516460 $Y=955660
X991 909 1 2 908 DELB $T=518320 940920 0 0 $X=518320 $Y=940540
X992 899 1 2 925 DELB $T=521420 920760 0 0 $X=521420 $Y=920380
X993 1007 1 2 1012 DELB $T=571020 910680 1 0 $X=571020 $Y=905260
X994 46 537 1 2 546 AN2 $T=324880 880440 0 0 $X=324880 $Y=880060
X995 558 528 1 2 564 AN2 $T=347820 880440 0 0 $X=347820 $Y=880060
X996 699 686 1 2 704 AN2 $T=411060 880440 1 0 $X=411060 $Y=875020
X997 733 734 1 2 741 AN2 $T=429660 890520 0 0 $X=429660 $Y=890140
X998 762 759 1 2 770 AN2 $T=441440 900600 0 0 $X=441440 $Y=900220
X999 793 789 1 2 809 AN2 $T=455080 940920 1 0 $X=455080 $Y=935500
X1000 798 799 1 2 816 AN2 $T=458800 900600 0 0 $X=458800 $Y=900220
X1001 848 109 1 2 879 AN2 $T=491660 961080 1 0 $X=491660 $Y=955660
X1002 892 891 1 2 877 AN2 $T=507160 920760 1 0 $X=507160 $Y=915340
X1003 1140 1137 1 2 1125 AN2 $T=667120 940920 0 180 $X=664640 $Y=935500
X1004 1179 1145 1 2 1192 AN2 $T=684480 940920 0 0 $X=684480 $Y=940540
X1005 1400 1404 1 2 1410 AN2 $T=809720 890520 0 0 $X=809720 $Y=890140
X1006 62 64 2 65 1 654 AOI12HS $T=383160 870360 0 0 $X=383160 $Y=869980
X1007 696 697 2 704 1 710 AOI12HS $T=410440 890520 1 0 $X=410440 $Y=885100
X1008 737 723 2 741 1 769 AOI12HS $T=432760 890520 1 0 $X=432760 $Y=885100
X1009 768 772 2 770 1 779 AOI12HS $T=444540 890520 0 0 $X=444540 $Y=890140
X1010 787 804 2 809 1 815 AOI12HS $T=460040 940920 1 0 $X=460040 $Y=935500
X1011 811 785 2 816 1 821 AOI12HS $T=463140 900600 0 0 $X=463140 $Y=900220
X1012 870 861 2 877 1 880 AOI12HS $T=496000 930840 1 0 $X=496000 $Y=925420
X1013 862 852 2 879 1 867 AOI12HS $T=496620 951000 0 0 $X=496620 $Y=950620
X1014 1014 146 2 149 1 1017 AOI12HS $T=573500 951000 0 0 $X=573500 $Y=950620
X1015 749 751 758 1 2 84 OA12 $T=437720 951000 1 0 $X=437720 $Y=945580
X1016 783 752 778 1 2 794 OA12 $T=449500 940920 0 0 $X=449500 $Y=940540
X1017 1237 1265 1256 1 2 1288 OA12 $T=729740 930840 0 0 $X=729740 $Y=930460
X1018 1313 1308 1320 1 2 1325 OA12 $T=752060 930840 1 0 $X=752060 $Y=925420
X1019 570 42 552 2 1 565 QDFFRBS $T=356500 930840 0 180 $X=344720 $Y=925420
X1020 831 91 740 2 1 819 QDFFRBS $T=478020 930840 0 180 $X=466240 $Y=925420
X1021 866 91 840 2 1 806 QDFFRBS $T=496620 920760 1 180 $X=484840 $Y=920380
X1022 897 91 887 2 1 871 QDFFRBS $T=511500 910680 1 180 $X=499720 $Y=910300
X1023 1088 157 1063 2 1 1068 QDFFRBS $T=623720 910680 1 180 $X=611940 $Y=910300
X1024 1132 157 1129 2 1 1110 QDFFRBS $T=659680 920760 0 180 $X=647900 $Y=915340
X1025 1463 259 1472 2 1 1474 QDFFRBS $T=852500 910680 1 0 $X=852500 $Y=905260
X1026 380 1 2 416 BUF1CK $T=256060 880440 1 0 $X=256060 $Y=875020
X1027 559 1 2 567 BUF1CK $T=343480 890520 1 0 $X=343480 $Y=885100
X1028 563 1 2 571 BUF1CK $T=345340 880440 0 0 $X=345340 $Y=880060
X1029 577 1 2 584 BUF1CK $T=350300 870360 1 0 $X=350300 $Y=864940
X1030 599 1 2 603 BUF1CK $T=361460 951000 1 0 $X=361460 $Y=945580
X1031 624 1 2 661 BUF1CK $T=389980 940920 0 0 $X=389980 $Y=940540
X1032 675 1 2 70 BUF1CK $T=400520 961080 1 0 $X=400520 $Y=955660
X1033 679 1 2 692 BUF1CK $T=405480 951000 0 0 $X=405480 $Y=950620
X1034 746 1 2 752 BUF1CK $T=435860 930840 0 0 $X=435860 $Y=930460
X1035 1054 1 2 1060 BUF1CK $T=602640 900600 0 0 $X=602640 $Y=900220
X1036 1061 1 2 1064 BUF1CK $T=605120 900600 0 0 $X=605120 $Y=900220
X1037 1072 1 2 1069 BUF1CK $T=615660 961080 1 0 $X=615660 $Y=955660
X1038 1094 1 2 1090 BUF1CK $T=630540 930840 1 0 $X=630540 $Y=925420
X1039 92 796 1 2 INV6CK $T=457560 890520 0 180 $X=451980 $Y=885100
X1040 55 54 1 2 INV12CK $T=357120 900600 0 180 $X=347200 $Y=895180
X1041 55 77 1 2 INV12CK $T=413540 880440 0 0 $X=413540 $Y=880060
X1042 796 42 1 2 INV12CK $T=471200 890520 0 180 $X=461280 $Y=885100
X1043 796 91 1 2 INV12CK $T=484840 890520 0 180 $X=474920 $Y=885100
X1044 482 467 1 473 2 OR2B1S $T=298840 940920 1 0 $X=298840 $Y=935500
X1045 636 639 1 627 2 OR2B1S $T=383160 940920 0 0 $X=383160 $Y=940540
X1046 1319 1320 1 1344 2 OR2B1S $T=758880 951000 1 0 $X=758880 $Y=945580
X1047 1610 1612 1 1611 2 OR2B1S $T=952940 920760 1 0 $X=952940 $Y=915340
X1048 1628 1624 1 1627 2 OR2B1S $T=962860 880440 0 0 $X=962860 $Y=880060
X1049 473 480 488 1 2 ND2 $T=298220 951000 1 0 $X=298220 $Y=945580
X1050 620 619 626 1 2 ND2 $T=373860 940920 0 0 $X=373860 $Y=940540
X1051 632 633 614 1 2 ND2 $T=378820 951000 1 0 $X=378820 $Y=945580
X1052 639 643 636 1 2 ND2 $T=380680 940920 1 0 $X=380680 $Y=935500
X1053 641 626 636 1 2 ND2 $T=380680 951000 1 0 $X=380680 $Y=945580
X1054 1602 1598 1610 1 2 ND2 $T=947980 910680 0 0 $X=947980 $Y=910300
X1055 1598 1603 1611 1 2 ND2 $T=949220 920760 1 0 $X=949220 $Y=915340
X1056 1603 1608 1616 1 2 ND2 $T=951700 910680 1 0 $X=951700 $Y=905260
X1057 1612 1614 1610 1 2 ND2 $T=951700 910680 0 0 $X=951700 $Y=910300
X1058 1608 319 1607 1 2 ND2 $T=953560 910680 0 0 $X=953560 $Y=910300
X1059 1611 1626 1616 1 2 ND2 $T=955420 910680 1 0 $X=955420 $Y=905260
X1060 1618 1615 1627 1 2 ND2 $T=956660 880440 1 0 $X=956660 $Y=875020
X1061 1615 1629 1630 1 2 ND2 $T=957900 890520 1 0 $X=957900 $Y=885100
X1062 1627 1632 1630 1 2 ND2 $T=959140 880440 0 0 $X=959140 $Y=880060
X1063 1629 320 1620 1 2 ND2 $T=961620 890520 1 0 $X=961620 $Y=885100
X1064 593 576 1 582 2 595 OAI12HS $T=357120 910680 0 0 $X=357120 $Y=910300
X1065 636 639 1 643 2 635 OAI12HS $T=379440 940920 0 0 $X=379440 $Y=940540
X1066 676 654 1 685 2 697 OAI12HS $T=403000 880440 1 0 $X=403000 $Y=875020
X1067 715 710 1 719 2 723 OAI12HS $T=417260 890520 0 0 $X=417260 $Y=890140
X1068 713 711 1 698 2 727 OAI12HS $T=417260 920760 0 0 $X=417260 $Y=920380
X1069 765 769 1 764 2 772 OAI12HS $T=442680 890520 1 0 $X=442680 $Y=885100
X1070 777 779 1 782 2 785 OAI12HS $T=446400 900600 0 0 $X=446400 $Y=900220
X1071 818 815 1 812 2 98 OAI12HS $T=466240 940920 1 180 $X=462520 $Y=940540
X1072 817 821 1 822 2 804 OAI12HS $T=465620 910680 0 0 $X=465620 $Y=910300
X1073 103 105 1 106 2 852 OAI12HS $T=484220 961080 1 0 $X=484220 $Y=955660
X1074 878 867 1 864 2 861 OAI12HS $T=497240 940920 1 180 $X=493520 $Y=940540
X1075 1041 1017 1 1020 2 1030 OAI12HS $T=587760 951000 0 180 $X=584040 $Y=945580
X1076 1179 1175 1 1188 2 1183 OAI12HS $T=685720 930840 0 0 $X=685720 $Y=930460
X1077 1610 1612 1 1614 2 1606 OAI12HS $T=957280 910680 0 0 $X=957280 $Y=910300
X1078 1628 1624 1 1625 2 1619 OAI12HS $T=960380 880440 1 0 $X=960380 $Y=875020
X1079 1250 1 1251 1250 208 1254 2 OAI22S $T=711760 951000 0 0 $X=711760 $Y=950620
X1080 231 1 233 231 1322 236 2 OAI22S $T=752060 870360 1 0 $X=752060 $Y=864940
X1081 1321 1 1310 1321 1319 1314 2 OAI22S $T=756400 940920 1 180 $X=752680 $Y=940540
X1082 1480 1 1483 1480 1466 1489 2 OAI22S $T=868000 880440 0 0 $X=868000 $Y=880060
X1083 1531 1 1533 1531 1530 1529 2 OAI22S $T=907060 880440 1 180 $X=903340 $Y=880060
X1084 1548 1 1538 1548 1540 1543 2 OAI22S $T=916360 920760 0 180 $X=912640 $Y=915340
X1085 1551 1 1546 1551 1552 1550 2 OAI22S $T=920700 900600 1 180 $X=916980 $Y=900220
X1086 1541 291 306 1539 1 2 1559 AO13S $T=908920 870360 0 0 $X=908920 $Y=869980
X1087 513 514 516 510 1 494 2 AOI22S $T=310620 940920 1 0 $X=310620 $Y=935500
X1088 1180 1186 1179 1171 1 1157 2 AOI22S $T=686340 930840 1 0 $X=686340 $Y=925420
X1089 1214 1203 1217 1188 1 1224 2 AOI22S $T=697500 940920 1 0 $X=697500 $Y=935500
X1090 1175 1229 1227 1192 1 1188 2 AOI22S $T=700600 930840 0 0 $X=700600 $Y=930460
X1091 1214 1203 1190 1224 1 1240 2 AOI22S $T=705560 940920 1 0 $X=705560 $Y=935500
X1092 1186 1180 1188 1234 1 197 2 AOI22S $T=707420 920760 1 0 $X=707420 $Y=915340
X1093 1180 1186 1229 204 1 1201 2 AOI22S $T=708660 910680 0 0 $X=708660 $Y=910300
X1094 1257 1261 1240 1234 1 197 2 AOI22S $T=716720 910680 0 0 $X=716720 $Y=910300
X1095 1244 1203 1264 1258 1 1256 2 AOI22S $T=723540 940920 0 180 $X=719820 $Y=935500
X1096 1235 1260 1273 1175 1 1192 2 AOI22S $T=726640 930840 1 180 $X=722920 $Y=930460
X1097 1283 1174 1281 1279 1 1260 2 AOI22S $T=734700 940920 0 180 $X=730980 $Y=935500
X1098 1280 1178 1282 1257 1 1289 2 AOI22S $T=733460 910680 0 0 $X=733460 $Y=910300
X1099 1283 1292 1310 1299 1 1279 2 AOI22S $T=748340 940920 1 0 $X=748340 $Y=935500
X1100 291 308 1539 307 1 306 2 AOI22S $T=907680 870360 0 180 $X=903960 $Y=864940
X1101 424 380 1 2 BUF2 $T=267220 930840 1 0 $X=267220 $Y=925420
X1102 463 386 1 2 BUF2 $T=300080 900600 1 180 $X=296980 $Y=900220
X1103 493 374 1 2 BUF2 $T=301940 890520 1 180 $X=298840 $Y=890140
X1104 524 344 1 2 BUF2 $T=316200 900600 0 180 $X=313100 $Y=895180
X1105 211 1335 1 2 BUF2 $T=758260 900600 0 0 $X=758260 $Y=900220
X1106 305 1523 1 2 BUF2 $T=898380 870360 0 0 $X=898380 $Y=869980
X1107 297 1528 1 2 BUF2 $T=901480 890520 0 0 $X=901480 $Y=890140
X1108 46 410 1 2 INV2 $T=321160 870360 0 180 $X=319300 $Y=864940
X1109 66 493 1 2 INV2 $T=384400 900600 0 180 $X=382540 $Y=895180
X1110 695 607 1 2 INV2 $T=405480 900600 0 180 $X=403620 $Y=895180
X1111 73 463 1 2 INV2 $T=411060 890520 1 180 $X=409200 $Y=890140
X1112 75 524 1 2 INV2 $T=417260 900600 1 0 $X=417260 $Y=895180
X1113 79 517 1 2 INV2 $T=425940 900600 0 180 $X=424080 $Y=895180
X1114 191 207 1 2 INV2 $T=720440 870360 0 0 $X=720440 $Y=869980
X1115 254 250 1 2 INV2 $T=788020 961080 0 180 $X=786160 $Y=955660
X1116 1411 263 1 2 INV2 $T=807240 961080 0 180 $X=805380 $Y=955660
X1117 295 305 1 2 INV2 $T=899000 870360 1 0 $X=899000 $Y=864940
X1118 1054 1053 1 1060 1053 1061 2 MOAI1S $T=598920 900600 0 0 $X=598920 $Y=900220
X1119 1094 1087 1 1090 1087 1081 2 MOAI1S $T=630540 930840 0 180 $X=626820 $Y=925420
X1120 1140 1138 1 1140 1138 1135 2 MOAI1S $T=668980 940920 1 180 $X=665260 $Y=940540
X1121 1144 1141 1 1144 1141 1136 2 MOAI1S $T=669600 890520 0 180 $X=665880 $Y=885100
X1122 1162 1160 1 1162 1160 1141 2 MOAI1S $T=680140 880440 0 180 $X=676420 $Y=875020
X1123 1157 1170 1 1157 1170 1175 2 MOAI1S $T=678900 930840 1 0 $X=678900 $Y=925420
X1124 1180 1185 1 1180 1185 1191 2 MOAI1S $T=686340 910680 0 0 $X=686340 $Y=910300
X1125 1178 1171 1 1156 1191 1193 2 MOAI1S $T=686340 920760 1 0 $X=686340 $Y=915340
X1126 1214 1188 1 1167 1200 1198 2 MOAI1S $T=694400 940920 0 180 $X=690680 $Y=935500
X1127 1204 192 1 1204 192 1224 2 MOAI1S $T=698120 920760 0 0 $X=698120 $Y=920380
X1128 1178 1168 1 1226 1156 1219 2 MOAI1S $T=699360 920760 1 0 $X=699360 $Y=915340
X1129 1231 1185 1 1231 1185 1226 2 MOAI1S $T=704940 910680 1 180 $X=701220 $Y=910300
X1130 1157 1204 1 1157 1239 1200 2 MOAI1S $T=704940 920760 0 0 $X=704940 $Y=920380
X1131 1235 1240 1 1242 1245 1194 2 MOAI1S $T=707420 930840 0 0 $X=707420 $Y=930460
X1132 1203 1256 1 1245 1200 1251 2 MOAI1S $T=716100 940920 0 180 $X=712380 $Y=935500
X1133 1234 1156 1 1234 1156 1258 2 MOAI1S $T=713620 920760 1 0 $X=713620 $Y=915340
X1134 1239 1170 1 1239 1170 1256 2 MOAI1S $T=717340 920760 0 0 $X=717340 $Y=920380
X1135 1239 1203 1 1263 1265 1305 2 MOAI1S $T=719820 951000 0 0 $X=719820 $Y=950620
X1136 1261 1186 1 1261 1186 1260 2 MOAI1S $T=720440 920760 1 0 $X=720440 $Y=915340
X1137 1261 1247 1 1261 1247 1245 2 MOAI1S $T=722300 930840 1 0 $X=722300 $Y=925420
X1138 177 1256 1 1247 1275 1277 2 MOAI1S $T=728500 920760 0 0 $X=728500 $Y=920380
X1139 1247 1233 1 1247 1233 1280 2 MOAI1S $T=730360 900600 0 0 $X=730360 $Y=900220
X1140 1290 1267 1 1290 1267 1293 2 MOAI1S $T=735940 920760 1 0 $X=735940 $Y=915340
X1141 1290 177 1 1290 1265 1297 2 MOAI1S $T=737180 920760 0 0 $X=737180 $Y=920380
X1142 1257 1237 1 1257 1237 1299 2 MOAI1S $T=739040 910680 1 0 $X=739040 $Y=905260
X1143 1299 1289 1 1275 1267 1313 2 MOAI1S $T=742140 920760 1 0 $X=742140 $Y=915340
X1144 1290 1292 1 1303 1265 1308 2 MOAI1S $T=743380 930840 0 0 $X=743380 $Y=930460
X1145 1305 1277 1 1305 1277 1315 2 MOAI1S $T=745860 951000 0 0 $X=745860 $Y=950620
X1146 1283 1299 1 1242 1297 1337 2 MOAI1S $T=747100 920760 0 0 $X=747100 $Y=920380
X1147 232 1309 1 232 1309 1279 2 MOAI1S $T=752680 910680 1 180 $X=748960 $Y=910300
X1148 266 1408 1 266 1408 1407 2 MOAI1S $T=812820 870360 1 180 $X=809100 $Y=869980
X1149 1481 1479 1 1481 1479 1476 2 MOAI1S $T=871100 910680 0 180 $X=867380 $Y=905260
X1150 1494 1492 1 1494 1492 1491 2 MOAI1S $T=882260 880440 1 180 $X=878540 $Y=880060
X1151 1500 1497 1 1500 1497 1494 2 MOAI1S $T=885360 880440 0 180 $X=881640 $Y=875020
X1152 1501 1498 1 1501 1498 1484 2 MOAI1S $T=885360 890520 0 180 $X=881640 $Y=885100
X1153 1519 1518 1 1519 1518 1517 2 MOAI1S $T=897140 900600 1 180 $X=893420 $Y=900220
X1154 248 1509 1500 291 2 1513 1 AOI13HS $T=888460 880440 1 0 $X=888460 $Y=875020
X1155 776 1 752 778 2 761 ND3 $T=445160 940920 0 180 $X=442680 $Y=935500
X1156 266 1 273 1431 2 232 ND3 $T=823980 870360 0 0 $X=823980 $Y=869980
X1157 1481 1 1486 1515 2 1487 ND3 $T=887840 900600 1 180 $X=885360 $Y=900220
X1158 1501 1 1507 1492 2 295 ND3 $T=886600 880440 0 0 $X=886600 $Y=880060
X1159 1421 1445 1421 1445 2 1 1441 MAOI1 $T=837000 940920 0 0 $X=837000 $Y=940540
X1160 1056 1048 1 1056 1053 1048 2 MOAI1 $T=598920 900600 0 180 $X=594580 $Y=895180
X1161 1204 1201 1 1204 1163 1201 2 MOAI1 $T=696880 930840 1 180 $X=692540 $Y=930460
X1162 219 1267 1 219 1235 1267 2 MOAI1 $T=727880 920760 1 0 $X=727880 $Y=915340
X1163 274 1441 1 274 1457 1441 2 MOAI1 $T=830180 930840 0 0 $X=830180 $Y=930460
X1164 1254 1229 1175 2 1260 1192 1 AO22 $T=714240 930840 0 0 $X=714240 $Y=930460
X1165 1170 1156 1168 1171 2 1158 1 1116 MUX3 $T=683240 920760 0 180 $X=675800 $Y=915340
X1166 373 420 36 2 1 465 XOR3 $T=279620 940920 0 0 $X=279620 $Y=940540
X1167 441 448 451 2 1 492 XOR3 $T=286440 900600 1 0 $X=286440 $Y=895180
X1168 462 38 39 2 1 44 XOR3 $T=294500 870360 1 0 $X=294500 $Y=864940
X1169 1118 1123 1120 2 1 1093 XOR3 $T=655960 880440 0 180 $X=644800 $Y=875020
X1170 1120 1118 1123 1 2 1098 MAO222 $T=647900 890520 0 180 $X=642940 $Y=885100
X1171 1025 1030 1029 1 2 1046 AO12 $T=589000 930840 0 0 $X=589000 $Y=930460
X1172 1009 1 112 2 BUF4CK $T=572260 920760 0 180 $X=567300 $Y=915340
X1173 351 345 352 1 2 357 HA1 $T=224440 900600 1 0 $X=224440 $Y=895180
X1174 360 349 10 1 2 11 HA1 $T=228780 870360 1 0 $X=228780 $Y=864940
X1175 355 369 362 1 2 361 HA1 $T=240560 890520 0 180 $X=232500 $Y=885100
X1176 368 363 371 1 2 14 HA1 $T=233120 870360 0 0 $X=233120 $Y=869980
X1177 390 383 396 1 2 19 HA1 $T=248000 880440 1 0 $X=248000 $Y=875020
X1178 399 391 402 1 2 21 HA1 $T=251100 880440 0 0 $X=251100 $Y=880060
X1179 398 415 425 1 2 428 HA1 $T=262260 930840 0 0 $X=262260 $Y=930460
X1180 589 596 583 1 2 578 HA1 $T=359600 890520 1 180 $X=351540 $Y=890140
X1181 597 600 592 1 2 588 HA1 $T=363320 900600 1 180 $X=355260 $Y=900220
X1182 613 634 617 1 2 612 HA1 $T=380060 920760 1 180 $X=372000 $Y=920380
X1183 628 622 637 1 2 640 HA1 $T=373860 920760 1 0 $X=373860 $Y=915340
X1184 648 642 650 1 2 652 HA1 $T=380680 890520 0 0 $X=380680 $Y=890140
X1185 682 673 686 1 2 678 HA1 $T=399280 880440 0 0 $X=399280 $Y=880060
X1186 753 745 759 1 2 763 HA1 $T=434000 890520 0 0 $X=434000 $Y=890140
X1187 774 725 780 1 2 762 HA1 $T=441440 910680 0 0 $X=441440 $Y=910300
X1188 806 800 789 1 2 814 HA1 $T=456940 930840 0 0 $X=456940 $Y=930460
X1189 786 1 2 797 DELA $T=451360 930840 1 0 $X=451360 $Y=925420
X1190 483 1 2 508 BUF1S $T=301320 951000 1 0 $X=301320 $Y=945580
X1191 488 1 2 497 BUF1S $T=307520 951000 1 0 $X=307520 $Y=945580
X1192 581 1 2 590 BUF1S $T=352780 870360 0 0 $X=352780 $Y=869980
X1193 701 1 2 718 BUF1S $T=415400 961080 1 0 $X=415400 $Y=955660
X1194 716 1 2 750 BUF1S $T=436480 951000 0 0 $X=436480 $Y=950620
X1195 775 1 2 776 BUF1S $T=445160 930840 1 0 $X=445160 $Y=925420
X1196 747 751 1 2 BUF2CK $T=434620 951000 1 0 $X=434620 $Y=945580
X1197 60 2 1 424 BUF3 $T=373240 900600 0 180 $X=369520 $Y=895180
X1198 53 42 51 1 2 50 QDFFRBT $T=350300 920760 1 180 $X=336660 $Y=920380
X1199 474 1 480 477 2 ND2P $T=293260 940920 0 0 $X=293260 $Y=940540
X1200 477 1 498 541 2 ND2P $T=313100 940920 0 0 $X=313100 $Y=940540
X1201 534 1 541 543 2 ND2P $T=322400 940920 1 0 $X=322400 $Y=935500
X1202 467 482 491 468 2 1 MXL2HS $T=296980 940920 0 0 $X=296980 $Y=940540
X1203 479 497 499 491 2 1 MXL2HS $T=302560 940920 0 0 $X=302560 $Y=940540
X1204 505 477 529 516 2 1 MXL2HS $T=314340 940920 1 0 $X=314340 $Y=935500
X1205 486 456 1 483 488 487 2 MOAI1H $T=306280 951000 1 180 $X=298840 $Y=950620
X1206 473 2 476 479 1 AN2B1S $T=292020 951000 1 0 $X=292020 $Y=945580
X1207 482 2 467 476 1 AN2B1S $T=295120 951000 1 0 $X=295120 $Y=945580
X1208 38 462 39 451 1 2 MAO222P $T=288920 870360 1 0 $X=288920 $Y=864940
X1209 448 441 451 36 1 2 MAO222T $T=280240 900600 1 0 $X=280240 $Y=895180
.ENDS
***************************************
.SUBCKT NR2P I1 VCC I2 GND O
** N=6 EP=5 IP=0 FDC=0
.ENDS
***************************************
.SUBCKT OA222 A2 A1 B2 B1 C2 C1 GND VCC O
** N=10 EP=9 IP=0 FDC=0
.ENDS
***************************************
.SUBCKT INV8CK I O GND VCC
** N=5 EP=4 IP=0 FDC=0
.ENDS
***************************************
.SUBCKT INV2CK I O GND VCC
** N=5 EP=4 IP=0 FDC=0
.ENDS
***************************************
.SUBCKT XNR3 I2 I1 I3 VCC GND O
** N=7 EP=6 IP=0 FDC=0
.ENDS
***************************************
.SUBCKT OR2T I2 I1 GND O VCC
** N=6 EP=5 IP=0 FDC=0
.ENDS
***************************************
.SUBCKT BUF6CK I GND O VCC
** N=5 EP=4 IP=0 FDC=0
.ENDS
***************************************
.SUBCKT OR2P I2 I1 O GND VCC
** N=6 EP=5 IP=0 FDC=0
.ENDS
***************************************
.SUBCKT OAI112HS C2 C1 GND B1 O A1 VCC
** N=8 EP=7 IP=0 FDC=0
.ENDS
***************************************
.SUBCKT ICV_4 1 2 3 4 5 6 7 8 9 10 11 12 13 14 15 16 17 18 19 20
+ 21 22 23 24 25 26 27 28 29 30 31 32 33 34 35 36 37 38 39 40
+ 41 42 43 44 45 46 47 48 49 50 51 52 53 54 55 56 57 58 59 60
+ 61 62 63 64 65 66 67 68 69 70 71 72 73 74 75 76 77 78 79 80
+ 81 82 83 84 85 86 87 88 89 90 91 92 93 94 95 96 97 98 99 100
+ 101 102 103 104 105 106 107 108 109 110 111 112 113 114 115 116 117 118 119 120
+ 121 122 123 124 125 126 127 128 129 130 131 132 133 134 135 136 137 138 139 140
+ 141 142 143 144 145 146 147 148 149 150 151 152 153 154 155 156 157 158 159 160
+ 161 162 163 164 165 166 167 168 169 170 171 172 173 174 175 176 177 178 179 180
+ 181 182 183 184 185 186 187 188 189 190 191 192 193 194 195 196 197 198 199 200
+ 201 202 203 204 205 206 207 208 209 210 211 212 213 214 215 216 217 218 219 220
+ 221 222 223 224 225 226 227 228 229 230 231 232 233 234 235 236 237 238 239 240
+ 241 242 243 244 245 246 247 248 249 250 251 252 253 254 255 256 257 258 259 260
+ 261 262 263 264 265 266 267 268 269 270 271 272 273 274 275 276 277 278 279 280
+ 281 282 283 284 285 286 287 288 289 290 291 292 293 294 295 296 297 298 299 300
+ 301 302 303 304 305 306 307 308 309 310 311 312 313 314 315 316 317 318 319 320
+ 321 322 323 324 325 326 327 328 329 330 331 332 333 334 335 336 337 338 339 340
+ 341 342 343 344 345 346 347 348 349 350 351 352 353 354 355 356 357 358 359 360
+ 361 362 363 364 365 366 367 368 369 370 371 372 373 374 375 376 377 378 379 380
+ 381 382 383 384 385 386 387 388 389 390 391 392 393 394 395 396 397 398 399 400
+ 401 402 403 404 405 406 407 408 409 410 411 412 413 414 415 416 417 418 419 420
+ 421 422 423 424 425 426 427 428 429 430 431 432 433 434 435 436 437 438 439 440
+ 441 442 443 444 445 446 447 448 449 450 451 452 453 454 455 456 457 458 459 460
+ 461 462 463 464 465 466 467 468 469 470 471 472 473 474 475 476 477 478 479 480
+ 481 482 483 484 485 486 487 488 489 490 491 492 493 494 495 496 497 498 499 500
+ 501 529
** N=1694 EP=502 IP=7945 FDC=0
X0 500 499 499 499 501 494 498 YA2GSD $T=1199700 792010 0 90 $X=1060200 $Y=794860
X1 537 2 1 5 BUF1 $T=239940 809880 0 180 $X=237460 $Y=804460
X2 14 2 1 6 BUF1 $T=243660 830040 1 180 $X=241180 $Y=829660
X3 569 2 1 537 BUF1 $T=249860 830040 1 180 $X=247380 $Y=829660
X4 17 2 1 20 BUF1 $T=248000 860280 0 0 $X=248000 $Y=859900
X5 31 2 1 32 BUF1 $T=266600 799800 1 0 $X=266600 $Y=794380
X6 39 2 1 602 BUF1 $T=274660 789720 0 0 $X=274660 $Y=789340
X7 594 2 1 46 BUF1 $T=278380 809880 1 0 $X=278380 $Y=804460
X8 608 2 1 44 BUF1 $T=278380 850200 1 0 $X=278380 $Y=844780
X9 624 2 1 569 BUF1 $T=298840 840120 1 180 $X=296360 $Y=839740
X10 624 2 1 633 BUF1 $T=302560 840120 0 0 $X=302560 $Y=839740
X11 633 2 1 655 BUF1 $T=307520 840120 1 0 $X=307520 $Y=834700
X12 655 2 1 56 BUF1 $T=326120 809880 0 180 $X=323640 $Y=804460
X13 655 2 1 698 BUF1 $T=331080 819960 1 0 $X=331080 $Y=814540
X14 82 2 1 59 BUF1 $T=372620 840120 1 0 $X=372620 $Y=834700
X15 77 2 1 775 BUF1 $T=376340 840120 0 0 $X=376340 $Y=839740
X16 84 2 1 97 BUF1 $T=395560 789720 1 0 $X=395560 $Y=784300
X17 775 2 1 101 BUF1 $T=403000 850200 0 0 $X=403000 $Y=849820
X18 125 2 1 880 BUF1 $T=438960 789720 0 0 $X=438960 $Y=789340
X19 876 2 1 125 BUF1 $T=452600 809880 1 180 $X=450120 $Y=809500
X20 876 2 1 910 BUF1 $T=459420 819960 0 0 $X=459420 $Y=819580
X21 880 2 1 899 BUF1 $T=476160 789720 0 180 $X=473680 $Y=784300
X22 880 2 1 946 BUF1 $T=491660 789720 0 0 $X=491660 $Y=789340
X23 910 2 1 930 BUF1 $T=492900 830040 0 0 $X=492900 $Y=829660
X24 946 2 1 165 BUF1 $T=506540 789720 1 0 $X=506540 $Y=784300
X25 930 2 1 964 BUF1 $T=509640 840120 0 0 $X=509640 $Y=839740
X26 946 2 1 962 BUF1 $T=512740 809880 1 0 $X=512740 $Y=804460
X27 990 2 1 180 BUF1 $T=547460 799800 0 0 $X=547460 $Y=799420
X28 962 2 1 990 BUF1 $T=553660 809880 0 180 $X=551180 $Y=804460
X29 990 2 1 211 BUF1 $T=571640 809880 1 0 $X=571640 $Y=804460
X30 222 2 1 1017 BUF1 $T=586520 850200 1 180 $X=584040 $Y=849820
X31 1056 2 1 1049 BUF1 $T=611320 830040 0 180 $X=608840 $Y=824620
X32 222 2 1 1056 BUF1 $T=611940 850200 0 0 $X=611940 $Y=849820
X33 1056 2 1 1073 BUF1 $T=619380 850200 0 0 $X=619380 $Y=849820
X34 246 2 1 237 BUF1 $T=639840 850200 1 180 $X=637360 $Y=849820
X35 249 2 1 1146 BUF1 $T=651620 809880 1 0 $X=651620 $Y=804460
X36 248 2 1 1158 BUF1 $T=660920 779640 0 0 $X=660920 $Y=779260
X37 257 2 1 263 BUF1 $T=662780 819960 1 0 $X=662780 $Y=814540
X38 1158 2 1 1142 BUF1 $T=665260 819960 1 0 $X=665260 $Y=814540
X39 252 2 1 1171 BUF1 $T=670840 840120 0 0 $X=670840 $Y=839740
X40 266 2 1 282 BUF1 $T=685100 840120 0 0 $X=685100 $Y=839740
X41 289 2 1 277 BUF1 $T=702460 830040 0 0 $X=702460 $Y=829660
X42 293 2 1 1228 BUF1 $T=704940 840120 0 180 $X=702460 $Y=834700
X43 1244 2 1 1155 BUF1 $T=708660 830040 0 180 $X=706180 $Y=824620
X44 293 2 1 300 BUF1 $T=708040 850200 1 0 $X=708040 $Y=844780
X45 291 2 1 304 BUF1 $T=714240 860280 1 0 $X=714240 $Y=854860
X46 1264 2 1 294 BUF1 $T=719200 840120 1 0 $X=719200 $Y=834700
X47 246 2 1 1252 BUF1 $T=720440 850200 1 0 $X=720440 $Y=844780
X48 322 2 1 1293 BUF1 $T=734700 809880 1 0 $X=734700 $Y=804460
X49 244 2 1 1298 BUF1 $T=737800 840120 0 0 $X=737800 $Y=839740
X50 288 2 1 332 BUF1 $T=742760 830040 0 0 $X=742760 $Y=829660
X51 337 2 1 339 BUF1 $T=749580 779640 0 0 $X=749580 $Y=779260
X52 275 2 1 1331 BUF1 $T=758260 860280 0 0 $X=758260 $Y=859900
X53 1332 2 1 1337 BUF1 $T=760740 819960 0 0 $X=760740 $Y=819580
X54 1339 2 1 366 BUF1 $T=787400 840120 0 180 $X=784920 $Y=834700
X55 373 2 1 1274 BUF1 $T=788020 789720 0 180 $X=785540 $Y=784300
X56 367 2 1 350 BUF1 $T=788020 860280 0 180 $X=785540 $Y=854860
X57 1379 2 1 1406 BUF1 $T=796700 840120 0 0 $X=796700 $Y=839740
X58 1332 2 1 385 BUF1 $T=798560 840120 1 0 $X=798560 $Y=834700
X59 395 2 1 1457 BUF1 $T=817780 809880 1 0 $X=817780 $Y=804460
X60 396 2 1 1403 BUF1 $T=818400 860280 0 0 $X=818400 $Y=859900
X61 1249 2 1 406 BUF1 $T=848160 850200 0 0 $X=848160 $Y=849820
X62 1503 2 1 1427 BUF1 $T=851260 809880 1 0 $X=851260 $Y=804460
X63 1505 2 1 1430 BUF1 $T=854980 799800 1 180 $X=852500 $Y=799420
X64 391 2 1 1509 BUF1 $T=855600 789720 1 0 $X=855600 $Y=784300
X65 418 2 1 1519 BUF1 $T=861800 779640 0 0 $X=861800 $Y=779260
X66 1519 2 1 425 BUF1 $T=874200 850200 1 180 $X=871720 $Y=849820
X67 342 2 1 1532 BUF1 $T=875440 830040 1 0 $X=875440 $Y=824620
X68 1505 2 1 1528 BUF1 $T=876060 799800 1 0 $X=876060 $Y=794380
X69 1298 2 1 1562 BUF1 $T=878540 840120 1 0 $X=878540 $Y=834700
X70 1503 2 1 1550 BUF1 $T=884740 789720 0 0 $X=884740 $Y=789340
X71 433 2 1 1552 BUF1 $T=886600 860280 0 0 $X=886600 $Y=859900
X72 1529 2 1 1567 BUF1 $T=887840 789720 0 0 $X=887840 $Y=789340
X73 1302 2 1 1576 BUF1 $T=888460 830040 1 0 $X=888460 $Y=824620
X74 428 2 1 437 BUF1 $T=889700 799800 0 0 $X=889700 $Y=799420
X75 1550 2 1 1575 BUF1 $T=892180 789720 0 0 $X=892180 $Y=789340
X76 1406 2 1 1543 BUF1 $T=894660 840120 1 0 $X=894660 $Y=834700
X77 1484 2 1 1569 BUF1 $T=894660 840120 0 0 $X=894660 $Y=839740
X78 1562 2 1 1555 BUF1 $T=903960 850200 1 0 $X=903960 $Y=844780
X79 373 2 1 1582 BUF1 $T=907060 799800 0 180 $X=904580 $Y=794380
X80 448 2 1 1583 BUF1 $T=907060 860280 0 180 $X=904580 $Y=854860
X81 1544 2 1 1601 BUF1 $T=906440 779640 0 0 $X=906440 $Y=779260
X82 1587 2 1 1597 BUF1 $T=911400 799800 0 0 $X=911400 $Y=799420
X83 1605 2 1 1568 BUF1 $T=913880 819960 1 180 $X=911400 $Y=819580
X84 1562 2 1 1600 BUF1 $T=911400 840120 1 0 $X=911400 $Y=834700
X85 455 2 1 450 BUF1 $T=914500 860280 0 180 $X=912020 $Y=854860
X86 1572 2 1 1612 BUF1 $T=915740 799800 0 0 $X=915740 $Y=799420
X87 1575 2 1 1633 BUF1 $T=916980 789720 0 0 $X=916980 $Y=789340
X88 459 2 1 461 BUF1 $T=919460 850200 1 0 $X=919460 $Y=844780
X89 446 2 1 1618 BUF1 $T=920700 809880 1 0 $X=920700 $Y=804460
X90 1591 2 1 1625 BUF1 $T=920700 830040 1 0 $X=920700 $Y=824620
X91 1617 2 1 1619 BUF1 $T=922560 819960 0 0 $X=922560 $Y=819580
X92 1528 2 1 1621 BUF1 $T=923800 809880 0 0 $X=923800 $Y=809500
X93 464 2 1 1609 BUF1 $T=926900 840120 0 180 $X=924420 $Y=834700
X94 375 2 1 1644 BUF1 $T=931240 850200 0 0 $X=931240 $Y=849820
X95 1597 2 1 1639 BUF1 $T=938060 809880 1 0 $X=938060 $Y=804460
X96 1567 2 1 1653 BUF1 $T=938680 789720 0 0 $X=938680 $Y=789340
X97 1589 2 1 1674 BUF1 $T=946740 799800 1 0 $X=946740 $Y=794380
X98 492 2 1 498 BUF1 $T=973400 840120 0 0 $X=973400 $Y=839740
X99 499 2 1 494 BUF1 $T=977120 809880 1 180 $X=974640 $Y=809500
X100 548 3 537 2 1 531 QDFFRBN $T=232500 840120 0 180 $X=220720 $Y=834700
X101 535 3 5 2 1 530 QDFFRBN $T=233120 789720 1 180 $X=221340 $Y=789340
X102 533 3 5 2 1 554 QDFFRBN $T=221340 799800 0 0 $X=221340 $Y=799420
X103 550 3 5 2 1 532 QDFFRBN $T=234360 809880 0 180 $X=222580 $Y=804460
X104 551 3 537 2 1 543 QDFFRBN $T=241180 830040 0 180 $X=229400 $Y=824620
X105 556 3 569 2 1 575 QDFFRBN $T=241180 840120 1 0 $X=241180 $Y=834700
X106 557 3 537 2 1 574 QDFFRBN $T=241800 809880 1 0 $X=241800 $Y=804460
X107 564 3 537 2 1 583 QDFFRBN $T=244900 819960 1 0 $X=244900 $Y=814540
X108 577 3 569 2 1 597 QDFFRBN $T=252960 830040 1 0 $X=252960 $Y=824620
X109 579 3 569 2 1 600 QDFFRBN $T=254200 840120 1 0 $X=254200 $Y=834700
X110 566 3 569 2 1 612 QDFFRBN $T=263500 850200 1 0 $X=263500 $Y=844780
X111 592 3 569 2 1 613 QDFFRBN $T=264120 840120 0 0 $X=264120 $Y=839740
X112 616 3 624 2 1 632 QDFFRBN $T=279620 840120 0 0 $X=279620 $Y=839740
X113 636 3 633 2 1 628 QDFFRBN $T=301320 830040 0 180 $X=289540 $Y=824620
X114 634 3 633 2 1 658 QDFFRBN $T=296980 850200 1 0 $X=296980 $Y=844780
X115 662 3 56 2 1 649 QDFFRBN $T=313100 789720 0 180 $X=301320 $Y=784300
X116 652 3 655 2 1 669 QDFFRBN $T=303180 830040 1 0 $X=303180 $Y=824620
X117 666 3 655 2 1 635 QDFFRBN $T=315580 799800 1 180 $X=303800 $Y=799420
X118 654 57 633 2 1 670 QDFFRBN $T=304420 860280 1 0 $X=304420 $Y=854860
X119 656 3 633 2 1 673 QDFFRBN $T=307520 840120 0 0 $X=307520 $Y=839740
X120 664 3 655 2 1 683 QDFFRBN $T=311860 840120 1 0 $X=311860 $Y=834700
X121 68 3 56 2 1 663 QDFFRBN $T=324880 789720 0 180 $X=313100 $Y=784300
X122 687 3 56 2 1 665 QDFFRBN $T=329220 799800 1 180 $X=317440 $Y=799420
X123 64 57 70 2 1 692 QDFFRBN $T=323640 860280 0 0 $X=323640 $Y=859900
X124 706 3 655 2 1 674 QDFFRBN $T=341000 809880 1 180 $X=329220 $Y=809500
X125 691 57 70 2 1 709 QDFFRBN $T=329840 850200 0 0 $X=329840 $Y=849820
X126 713 3 698 2 1 694 QDFFRBN $T=345960 830040 0 180 $X=334180 $Y=824620
X127 699 57 70 2 1 726 QDFFRBN $T=334800 860280 1 0 $X=334800 $Y=854860
X128 728 3 698 2 1 707 QDFFRBN $T=355880 809880 1 180 $X=344100 $Y=809500
X129 740 3 77 2 1 710 QDFFRBN $T=360220 830040 1 180 $X=348440 $Y=829660
X130 748 3 698 2 1 716 QDFFRBN $T=362080 830040 0 180 $X=350300 $Y=824620
X131 766 3 77 2 1 732 QDFFRBN $T=370760 840120 0 180 $X=358980 $Y=834700
X132 771 3 77 2 1 751 QDFFRBN $T=374480 830040 1 180 $X=362700 $Y=829660
X133 85 3 80 2 1 752 QDFFRBN $T=377580 779640 1 180 $X=365800 $Y=779260
X134 780 3 84 2 1 769 QDFFRBN $T=383160 789720 0 180 $X=371380 $Y=784300
X135 787 3 775 2 1 760 QDFFRBN $T=386260 850200 0 180 $X=374480 $Y=844780
X136 798 3 775 2 1 765 QDFFRBN $T=392460 840120 1 180 $X=380680 $Y=839740
X137 802 3 84 2 1 786 QDFFRBN $T=396800 799800 0 180 $X=385020 $Y=794380
X138 813 3 775 2 1 779 QDFFRBN $T=401140 860280 0 180 $X=389360 $Y=854860
X139 818 3 775 2 1 796 QDFFRBN $T=401760 850200 0 180 $X=389980 $Y=844780
X140 107 3 97 2 1 804 QDFFRBN $T=409200 789720 1 180 $X=397420 $Y=789340
X141 826 57 101 2 1 98 QDFFRBN $T=410440 860280 1 180 $X=398660 $Y=859900
X142 827 3 97 2 1 795 QDFFRBN $T=411060 799800 0 180 $X=399280 $Y=794380
X143 844 3 101 2 1 816 QDFFRBN $T=416640 850200 0 180 $X=404860 $Y=844780
X144 839 57 101 2 1 822 QDFFRBN $T=419120 860280 0 180 $X=407340 $Y=854860
X145 116 3 97 2 1 823 QDFFRBN $T=420360 809880 0 180 $X=408580 $Y=804460
X146 122 57 101 2 1 113 QDFFRBN $T=425940 860280 1 180 $X=414160 $Y=859900
X147 123 124 876 2 1 878 QDFFRBN $T=431520 819960 1 0 $X=431520 $Y=814540
X148 886 124 125 2 1 854 QDFFRBN $T=444540 799800 0 180 $X=432760 $Y=794380
X149 884 124 125 2 1 821 QDFFRBN $T=445780 809880 1 180 $X=434000 $Y=809500
X150 136 124 125 2 1 99 QDFFRBN $T=456940 789720 0 180 $X=445160 $Y=784300
X151 132 124 876 2 1 890 QDFFRBN $T=445780 819960 1 0 $X=445780 $Y=814540
X152 133 124 899 2 1 888 QDFFRBN $T=447020 779640 0 0 $X=447020 $Y=779260
X153 889 124 876 2 1 898 QDFFRBN $T=449500 830040 1 0 $X=449500 $Y=824620
X154 896 124 910 2 1 906 QDFFRBN $T=455700 830040 0 0 $X=455700 $Y=829660
X155 140 124 880 2 1 912 QDFFRBN $T=458800 779640 0 0 $X=458800 $Y=779260
X156 141 124 899 2 1 897 QDFFRBN $T=459420 789720 1 0 $X=459420 $Y=784300
X157 921 124 910 2 1 833 QDFFRBN $T=474920 830040 0 180 $X=463140 $Y=824620
X158 920 124 910 2 1 903 QDFFRBN $T=475540 840120 1 180 $X=463760 $Y=839740
X159 144 124 880 2 1 924 QDFFRBN $T=466860 789720 0 0 $X=466860 $Y=789340
X160 146 124 899 2 1 931 QDFFRBN $T=470580 779640 0 0 $X=470580 $Y=779260
X161 934 124 910 2 1 914 QDFFRBN $T=485460 819960 1 180 $X=473680 $Y=819580
X162 937 124 930 2 1 922 QDFFRBN $T=489180 830040 0 180 $X=477400 $Y=824620
X163 902 124 910 2 1 926 QDFFRBN $T=477400 840120 1 0 $X=477400 $Y=834700
X164 150 124 880 2 1 936 QDFFRBN $T=478640 789720 1 0 $X=478640 $Y=784300
X165 156 124 880 2 1 933 QDFFRBN $T=494760 779640 1 180 $X=482980 $Y=779260
X166 927 124 930 2 1 948 QDFFRBN $T=483600 840120 0 0 $X=483600 $Y=839740
X167 152 124 946 2 1 949 QDFFRBN $T=485460 809880 1 0 $X=485460 $Y=804460
X168 155 124 946 2 1 951 QDFFRBN $T=492280 789720 1 0 $X=492280 $Y=784300
X169 960 124 930 2 1 916 QDFFRBN $T=507160 850200 0 180 $X=495380 $Y=844780
X170 943 124 930 2 1 163 QDFFRBN $T=496620 840120 0 0 $X=496620 $Y=839740
X171 161 124 946 2 1 957 QDFFRBN $T=505920 799800 1 0 $X=505920 $Y=794380
X172 172 124 946 2 1 945 QDFFRBN $T=518320 789720 1 180 $X=506540 $Y=789340
X173 164 124 962 2 1 967 QDFFRBN $T=507780 819960 1 0 $X=507780 $Y=814540
X174 168 124 165 2 1 968 QDFFRBN $T=509640 779640 0 0 $X=509640 $Y=779260
X175 959 171 964 2 1 176 QDFFRBN $T=514600 860280 1 0 $X=514600 $Y=854860
X176 170 124 962 2 1 974 QDFFRBN $T=515840 809880 1 0 $X=515840 $Y=804460
X177 973 171 964 2 1 169 QDFFRBN $T=528860 860280 1 180 $X=517080 $Y=859900
X178 961 124 964 2 1 184 QDFFRBN $T=518320 840120 0 0 $X=518320 $Y=839740
X179 173 124 962 2 1 971 QDFFRBN $T=519560 799800 0 0 $X=519560 $Y=799420
X180 993 171 964 2 1 963 QDFFRBN $T=532580 850200 0 180 $X=520800 $Y=844780
X181 174 124 180 2 1 979 QDFFRBN $T=522660 779640 0 0 $X=522660 $Y=779260
X182 195 124 962 2 1 977 QDFFRBN $T=543120 819960 0 180 $X=531340 $Y=814540
X183 194 124 180 2 1 975 QDFFRBN $T=544980 799800 0 180 $X=533200 $Y=794380
X184 976 171 964 2 1 196 QDFFRBN $T=536920 850200 0 0 $X=536920 $Y=849820
X185 992 171 964 2 1 980 QDFFRBN $T=549940 860280 0 180 $X=538160 $Y=854860
X186 191 124 990 2 1 987 QDFFRBN $T=538780 809880 0 0 $X=538780 $Y=809500
X187 981 124 962 2 1 1014 QDFFRBN $T=544980 819960 1 0 $X=544980 $Y=814540
X188 200 124 180 2 1 983 QDFFRBN $T=557380 789720 1 180 $X=545600 $Y=789340
X189 201 124 180 2 1 984 QDFFRBN $T=558000 789720 0 180 $X=546220 $Y=784300
X190 199 124 990 2 1 1013 QDFFRBN $T=553040 799800 1 0 $X=553040 $Y=794380
X191 996 124 990 2 1 1007 QDFFRBN $T=554900 809880 0 0 $X=554900 $Y=809500
X192 1000 124 990 2 1 997 QDFFRBN $T=557380 809880 1 0 $X=557380 $Y=804460
X193 1029 171 1017 2 1 204 QDFFRBN $T=579080 840120 1 180 $X=567300 $Y=839740
X194 154 124 211 2 1 215 QDFFRBN $T=567920 819960 0 0 $X=567920 $Y=819580
X195 1026 171 1017 2 1 999 QDFFRBN $T=581560 850200 0 180 $X=569780 $Y=844780
X196 1036 219 211 2 1 1028 QDFFRBN $T=588380 809880 0 180 $X=576600 $Y=804460
X197 218 171 222 2 1 221 QDFFRBN $T=582180 860280 1 0 $X=582180 $Y=854860
X198 1048 219 211 2 1 1034 QDFFRBN $T=595200 819960 0 180 $X=583420 $Y=814540
X199 1047 219 211 2 1 989 QDFFRBN $T=597060 799800 1 180 $X=585280 $Y=799420
X200 1071 219 211 2 1 1039 QDFFRBN $T=602640 809880 0 180 $X=590860 $Y=804460
X201 1045 219 222 2 1 223 QDFFRBN $T=603260 860280 1 180 $X=591480 $Y=859900
X202 1059 219 1049 2 1 1027 QDFFRBN $T=605120 830040 1 180 $X=593340 $Y=829660
X203 1061 219 1049 2 1 1042 QDFFRBN $T=606360 840120 0 180 $X=594580 $Y=834700
X204 1064 219 222 2 1 1050 QDFFRBN $T=608220 860280 0 180 $X=596440 $Y=854860
X205 1069 219 1056 2 1 1044 QDFFRBN $T=611320 840120 1 180 $X=599540 $Y=839740
X206 1076 219 1056 2 1 1038 QDFFRBN $T=619380 840120 0 180 $X=607600 $Y=834700
X207 237 219 1073 2 1 1072 QDFFRBN $T=622480 860280 0 180 $X=610700 $Y=854860
X208 1078 219 1049 2 1 1062 QDFFRBN $T=623100 809880 1 180 $X=611320 $Y=809500
X209 1087 219 1049 2 1 1058 QDFFRBN $T=623720 809880 0 180 $X=611940 $Y=804460
X210 1079 219 1049 2 1 1054 QDFFRBN $T=625580 799800 0 180 $X=613800 $Y=794380
X211 1080 219 1049 2 1 1070 QDFFRBN $T=625580 819960 1 180 $X=613800 $Y=819580
X212 1082 219 1056 2 1 1024 QDFFRBN $T=626820 830040 0 180 $X=615040 $Y=824620
X213 1113 219 1073 2 1 1057 QDFFRBN $T=636120 850200 0 180 $X=624340 $Y=844780
X214 1104 219 240 2 1 1075 QDFFRBN $T=636120 860280 1 180 $X=624340 $Y=859900
X215 1511 412 417 2 1 1523 QDFFRBN $T=858080 799800 1 0 $X=858080 $Y=794380
X216 1522 412 417 2 1 1512 QDFFRBN $T=870480 809880 1 180 $X=858700 $Y=809500
X217 1518 412 417 2 1 1520 QDFFRBN $T=862420 830040 1 0 $X=862420 $Y=824620
X218 1517 412 417 2 1 1521 QDFFRBN $T=862420 840120 0 0 $X=862420 $Y=839740
X219 1506 412 417 2 1 1525 QDFFRBN $T=866140 860280 1 0 $X=866140 $Y=854860
X220 1162 1130 1 2 INV3 $T=691920 789720 0 0 $X=691920 $Y=789340
X221 19 2 561 1 INV1S $T=246760 789720 0 180 $X=245520 $Y=784300
X222 568 2 558 1 INV1S $T=250480 779640 1 180 $X=249240 $Y=779260
X223 28 2 594 1 INV1S $T=264120 799800 0 0 $X=264120 $Y=799420
X224 33 2 604 1 INV1S $T=270320 799800 1 0 $X=270320 $Y=794380
X225 614 2 618 1 INV1S $T=280860 799800 1 0 $X=280860 $Y=794380
X226 554 2 620 1 INV1S $T=282100 799800 1 0 $X=282100 $Y=794380
X227 42 2 40 1 INV1S $T=285820 840120 0 180 $X=284580 $Y=834700
X228 47 2 623 1 INV1S $T=288300 799800 0 180 $X=287060 $Y=794380
X229 45 2 608 1 INV1S $T=288300 799800 0 0 $X=288300 $Y=799420
X230 54 2 647 1 INV1S $T=296360 789720 1 0 $X=296360 $Y=784300
X231 572 2 646 1 INV1S $T=296360 819960 1 0 $X=296360 $Y=814540
X232 583 2 659 1 INV1S $T=306280 819960 1 0 $X=306280 $Y=814540
X233 59 2 624 1 INV1S $T=310000 850200 0 180 $X=308760 $Y=844780
X234 59 2 61 1 INV1S $T=318680 799800 0 180 $X=317440 $Y=794380
X235 674 2 653 1 INV1S $T=318680 809880 0 180 $X=317440 $Y=804460
X236 669 2 677 1 INV1S $T=317440 830040 1 0 $X=317440 $Y=824620
X237 673 2 681 1 INV1S $T=320540 840120 0 0 $X=320540 $Y=839740
X238 683 2 731 1 INV1S $T=326120 840120 0 0 $X=326120 $Y=839740
X239 721 2 722 1 INV1S $T=347200 789720 1 0 $X=347200 $Y=784300
X240 709 2 734 1 INV1S $T=350300 850200 0 0 $X=350300 $Y=849820
X241 726 2 757 1 INV1S $T=351540 860280 0 0 $X=351540 $Y=859900
X242 747 2 737 1 INV1S $T=359600 789720 0 180 $X=358360 $Y=784300
X243 78 2 749 1 INV1S $T=358980 779640 0 0 $X=358980 $Y=779260
X244 752 2 79 1 INV1S $T=363320 789720 0 180 $X=362080 $Y=784300
X245 756 2 762 1 INV1S $T=368280 809880 1 0 $X=368280 $Y=804460
X246 776 2 772 1 INV1S $T=377580 819960 0 180 $X=376340 $Y=814540
X247 769 2 778 1 INV1S $T=378820 799800 0 0 $X=378820 $Y=799420
X248 87 2 88 1 INV1S $T=378820 860280 0 0 $X=378820 $Y=859900
X249 786 2 784 1 INV1S $T=383780 799800 0 180 $X=382540 $Y=794380
X250 59 2 84 1 INV1S $T=383160 789720 0 0 $X=383160 $Y=789340
X251 807 2 759 1 INV1S $T=395560 789720 1 180 $X=394320 $Y=789340
X252 803 2 799 1 INV1S $T=395560 840120 1 180 $X=394320 $Y=839740
X253 804 2 806 1 INV1S $T=394940 799800 0 0 $X=394940 $Y=799420
X254 812 2 794 1 INV1S $T=399280 819960 0 180 $X=398040 $Y=814540
X255 821 2 817 1 INV1S $T=404860 809880 0 180 $X=403620 $Y=804460
X256 104 2 103 1 INV1S $T=405480 779640 1 180 $X=404240 $Y=779260
X257 823 2 830 1 INV1S $T=411680 819960 1 0 $X=411680 $Y=814540
X258 828 2 832 1 INV1S $T=412920 830040 0 0 $X=412920 $Y=829660
X259 841 2 792 1 INV1S $T=415400 799800 1 180 $X=414160 $Y=799420
X260 833 2 831 1 INV1S $T=416020 830040 0 180 $X=414780 $Y=824620
X261 117 2 110 1 INV1S $T=420980 779640 1 180 $X=419740 $Y=779260
X262 868 2 861 1 INV1S $T=434000 819960 1 180 $X=432760 $Y=819580
X263 870 2 860 1 INV1S $T=434620 779640 1 180 $X=433380 $Y=779260
X264 59 2 876 1 INV1S $T=438960 819960 0 0 $X=438960 $Y=819580
X265 877 2 881 1 INV1S $T=447640 850200 1 0 $X=447640 $Y=844780
X266 890 2 895 1 INV1S $T=450740 830040 0 0 $X=450740 $Y=829660
X267 885 2 894 1 INV1S $T=451980 850200 0 180 $X=450740 $Y=844780
X268 903 2 893 1 INV1S $T=455080 840120 0 180 $X=453840 $Y=834700
X269 138 2 143 1 INV1S $T=459420 860280 0 0 $X=459420 $Y=859900
X270 906 2 908 1 INV1S $T=462520 850200 1 0 $X=462520 $Y=844780
X271 916 2 904 1 INV1S $T=466860 850200 1 180 $X=465620 $Y=849820
X272 914 2 811 1 INV1S $T=468100 819960 1 180 $X=466860 $Y=819580
X273 922 2 879 1 INV1S $T=473680 830040 1 180 $X=472440 $Y=829660
X274 919 2 918 1 INV1S $T=476160 850200 0 180 $X=474920 $Y=844780
X275 939 2 947 1 INV1S $T=496620 850200 1 180 $X=495380 $Y=849820
X276 948 2 166 1 INV1S $T=507160 860280 0 0 $X=507160 $Y=859900
X277 980 2 932 1 INV1S $T=511500 850200 1 180 $X=510260 $Y=849820
X278 169 2 956 1 INV1S $T=511500 860280 0 180 $X=510260 $Y=854860
X279 963 2 900 1 INV1S $T=517080 850200 0 180 $X=515840 $Y=844780
X280 183 2 981 1 INV1S $T=533820 799800 0 0 $X=533820 $Y=799420
X281 999 2 1005 1 INV1S $T=558000 860280 0 0 $X=558000 $Y=859900
X282 204 2 1015 1 INV1S $T=572880 850200 0 0 $X=572880 $Y=849820
X283 208 2 1016 1 INV1S $T=575360 779640 0 0 $X=575360 $Y=779260
X284 1028 2 1018 1 INV1S $T=578460 819960 1 0 $X=578460 $Y=814540
X285 213 2 1032 1 INV1S $T=579080 779640 0 0 $X=579080 $Y=779260
X286 217 2 1035 1 INV1S $T=582180 779640 0 0 $X=582180 $Y=779260
X287 221 2 216 1 INV1S $T=586520 860280 1 180 $X=585280 $Y=859900
X288 224 2 1037 1 INV1S $T=593960 779640 1 180 $X=592720 $Y=779260
X289 232 2 1068 1 INV1S $T=608220 789720 0 0 $X=608220 $Y=789340
X290 1065 2 233 1 INV1S $T=610700 819960 0 0 $X=610700 $Y=819580
X291 239 2 1084 1 INV1S $T=626200 789720 1 0 $X=626200 $Y=784300
X292 241 2 242 1 INV1S $T=629300 779640 0 0 $X=629300 $Y=779260
X293 1098 2 1089 1 INV1S $T=633020 830040 1 180 $X=631780 $Y=829660
X294 248 2 1090 1 INV1S $T=638600 789720 0 180 $X=637360 $Y=784300
X295 1106 2 1103 1 INV1S $T=638600 830040 1 180 $X=637360 $Y=829660
X296 249 2 1092 1 INV1S $T=639220 809880 0 180 $X=637980 $Y=804460
X297 1102 2 1136 1 INV1S $T=646660 789720 0 0 $X=646660 $Y=789340
X298 1116 2 1140 1 INV1S $T=652240 799800 0 0 $X=652240 $Y=799420
X299 249 2 1137 1 INV1S $T=652240 809880 0 0 $X=652240 $Y=809500
X300 1117 2 1135 1 INV1S $T=652240 819960 1 0 $X=652240 $Y=814540
X301 259 2 1115 1 INV1S $T=661540 819960 1 0 $X=661540 $Y=814540
X302 276 2 268 1 INV1S $T=682000 830040 1 0 $X=682000 $Y=824620
X303 1188 2 1193 1 INV1S $T=685720 799800 1 180 $X=684480 $Y=799420
X304 1204 2 1183 1 INV1S $T=686340 809880 1 180 $X=685100 $Y=809500
X305 1196 2 1194 1 INV1S $T=686960 799800 1 180 $X=685720 $Y=799420
X306 1205 2 1197 1 INV1S $T=690680 799800 1 180 $X=689440 $Y=799420
X307 1237 2 1211 1 INV1S $T=696260 860280 0 180 $X=695020 $Y=854860
X308 1222 2 286 1 INV1S $T=699980 850200 1 0 $X=699980 $Y=844780
X309 275 2 1230 1 INV1S $T=701220 860280 1 180 $X=699980 $Y=859900
X310 293 2 284 1 INV1S $T=706800 840120 0 0 $X=706800 $Y=839740
X311 1177 2 1170 1 INV1S $T=709280 840120 0 180 $X=708040 $Y=834700
X312 1239 2 1241 1 INV1S $T=709280 799800 0 0 $X=709280 $Y=799420
X313 1255 2 301 1 INV1S $T=713000 840120 0 180 $X=711760 $Y=834700
X314 1250 2 299 1 INV1S $T=713000 860280 1 180 $X=711760 $Y=859900
X315 286 2 1249 1 INV1S $T=716100 850200 1 0 $X=716100 $Y=844780
X316 305 2 1258 1 INV1S $T=719200 840120 1 180 $X=717960 $Y=839740
X317 1267 2 1220 1 INV1S $T=723540 809880 0 180 $X=722300 $Y=804460
X318 312 2 1238 1 INV1S $T=724780 830040 0 180 $X=723540 $Y=824620
X319 1274 2 1264 1 INV1S $T=727260 840120 0 180 $X=726020 $Y=834700
X320 1266 2 1276 1 INV1S $T=726640 809880 1 0 $X=726640 $Y=804460
X321 1281 2 1236 1 INV1S $T=730360 799800 0 0 $X=730360 $Y=799420
X322 1177 2 317 1 INV1S $T=732840 860280 0 180 $X=731600 $Y=854860
X323 1291 2 319 1 INV1S $T=734080 850200 1 180 $X=732840 $Y=849820
X324 264 2 305 1 INV1S $T=737180 840120 1 0 $X=737180 $Y=834700
X325 1295 2 1300 1 INV1S $T=738420 789720 0 0 $X=738420 $Y=789340
X326 325 2 1177 1 INV1S $T=739660 830040 1 180 $X=738420 $Y=829660
X327 305 2 1288 1 INV1S $T=738420 840120 1 0 $X=738420 $Y=834700
X328 1273 2 328 1 INV1S $T=739040 850200 1 0 $X=739040 $Y=844780
X329 325 2 1302 1 INV1S $T=740900 809880 1 0 $X=740900 $Y=804460
X330 1287 2 1310 1 INV1S $T=744000 840120 1 0 $X=744000 $Y=834700
X331 334 2 1297 1 INV1S $T=745240 830040 0 0 $X=745240 $Y=829660
X332 1296 2 1317 1 INV1S $T=747720 799800 0 0 $X=747720 $Y=799420
X333 305 2 1315 1 INV1S $T=748340 860280 1 0 $X=748340 $Y=854860
X334 351 2 1339 1 INV1S $T=765700 789720 1 0 $X=765700 $Y=784300
X335 352 2 356 1 INV1S $T=768180 789720 0 0 $X=768180 $Y=789340
X336 364 2 365 1 INV1S $T=777480 789720 0 0 $X=777480 $Y=789340
X337 1252 2 1374 1 INV1S $T=780580 840120 0 0 $X=780580 $Y=839740
X338 1310 2 368 1 INV1S $T=780580 850200 1 0 $X=780580 $Y=844780
X339 326 2 1357 1 INV1S $T=781820 850200 1 180 $X=780580 $Y=849820
X340 1375 2 353 1 INV1S $T=784920 830040 1 180 $X=783680 $Y=829660
X341 331 2 375 1 INV1S $T=783680 850200 0 0 $X=783680 $Y=849820
X342 369 2 1375 1 INV1S $T=784300 809880 0 0 $X=784300 $Y=809500
X343 1375 2 374 1 INV1S $T=784920 840120 0 0 $X=784920 $Y=839740
X344 1374 2 1379 1 INV1S $T=788020 840120 0 0 $X=788020 $Y=839740
X345 1373 2 1382 1 INV1S $T=788640 830040 1 0 $X=788640 $Y=824620
X346 1370 2 1355 1 INV1S $T=790500 840120 0 180 $X=789260 $Y=834700
X347 1370 2 348 1 INV1S $T=789880 840120 0 0 $X=789880 $Y=839740
X348 1311 2 1354 1 INV1S $T=792360 830040 1 0 $X=792360 $Y=824620
X349 1365 2 1390 1 INV1S $T=792360 830040 0 0 $X=792360 $Y=829660
X350 1385 2 1392 1 INV1S $T=792980 799800 1 0 $X=792980 $Y=794380
X351 1404 2 1394 1 INV1S $T=798560 809880 1 180 $X=797320 $Y=809500
X352 373 2 379 1 INV1S $T=797940 779640 0 0 $X=797940 $Y=779260
X353 1376 2 1401 1 INV1S $T=798560 799800 1 0 $X=798560 $Y=794380
X354 1396 2 1412 1 INV1S $T=801660 850200 0 0 $X=801660 $Y=849820
X355 1424 2 1431 1 INV1S $T=812820 819960 1 0 $X=812820 $Y=814540
X356 307 2 391 1 INV1S $T=813440 850200 0 0 $X=813440 $Y=849820
X357 342 2 395 1 INV1S $T=826460 860280 1 0 $X=826460 $Y=854860
X358 1298 2 1484 1 INV1S $T=843820 850200 0 0 $X=843820 $Y=849820
X359 391 2 1503 1 INV1S $T=850640 789720 1 0 $X=850640 $Y=784300
X360 1302 2 1505 1 INV1S $T=854360 789720 1 0 $X=854360 $Y=784300
X361 408 2 1421 1 INV1S $T=854360 799800 1 0 $X=854360 $Y=794380
X362 382 2 1524 1 INV1S $T=869860 789720 1 0 $X=869860 $Y=784300
X363 1533 2 1535 1 INV1S $T=877920 809880 1 0 $X=877920 $Y=804460
X364 1339 2 430 1 INV1S $T=881020 860280 0 0 $X=881020 $Y=859900
X365 1551 2 431 1 INV1S $T=884120 779640 1 180 $X=882880 $Y=779260
X366 444 2 1574 1 INV1S $T=895900 799800 1 0 $X=895900 $Y=794380
X367 373 2 1587 1 INV1S $T=908300 799800 1 0 $X=908300 $Y=794380
X368 445 2 451 1 INV1S $T=910780 860280 0 0 $X=910780 $Y=859900
X369 450 2 448 1 INV1S $T=914500 860280 1 0 $X=914500 $Y=854860
X370 1563 2 1605 1 INV1S $T=918840 819960 0 0 $X=918840 $Y=819580
X371 1623 2 1624 1 INV1S $T=924420 850200 1 0 $X=924420 $Y=844780
X372 1631 2 1637 1 INV1S $T=928140 819960 0 0 $X=928140 $Y=819580
X373 1593 2 1623 1 INV1S $T=928140 840120 0 0 $X=928140 $Y=839740
X374 375 2 1629 1 INV1S $T=930000 860280 0 180 $X=928760 $Y=854860
X375 465 2 1593 1 INV1S $T=930620 840120 1 180 $X=929380 $Y=839740
X376 1623 2 470 1 INV1S $T=934340 850200 1 0 $X=934340 $Y=844780
X377 1656 2 1654 1 INV1S $T=944260 830040 1 0 $X=944260 $Y=824620
X378 1648 2 1673 1 INV1S $T=946120 819960 1 0 $X=946120 $Y=814540
X379 1663 2 1668 1 INV1S $T=949840 840120 0 0 $X=949840 $Y=839740
X380 1670 2 1680 1 INV1S $T=951080 830040 0 0 $X=951080 $Y=829660
X381 1655 2 1671 1 INV1S $T=952940 789720 1 180 $X=951700 $Y=789340
X382 1626 2 480 1 INV1S $T=961000 860280 0 0 $X=961000 $Y=859900
X383 1683 2 484 1 INV1S $T=964720 789720 0 0 $X=964720 $Y=789340
X384 1685 2 487 1 INV1S $T=969060 809880 0 0 $X=969060 $Y=809500
X385 1677 2 1691 1 INV1S $T=970300 789720 0 0 $X=970300 $Y=789340
X386 1693 2 493 1 INV1S $T=975260 809880 0 180 $X=974020 $Y=804460
X387 556 541 2 540 13 1 534 FA1 $T=237460 850200 1 180 $X=221960 $Y=849820
X388 559 9 2 8 16 1 545 FA1 $T=244280 860280 0 180 $X=228780 $Y=854860
X389 550 563 2 562 546 1 578 FA1 $T=234360 799800 1 0 $X=234360 $Y=794380
X390 579 534 2 565 559 1 555 FA1 $T=254820 840120 1 180 $X=239320 $Y=839740
X391 557 573 2 576 578 1 581 FA1 $T=241180 799800 0 0 $X=241180 $Y=799420
X392 566 567 2 23 555 1 601 FA1 $T=245520 850200 0 0 $X=245520 $Y=849820
X393 567 580 2 24 545 1 593 FA1 $T=246140 860280 1 0 $X=246140 $Y=854860
X394 627 41 2 595 38 1 37 FA1 $T=289540 860280 1 180 $X=274040 $Y=859900
X395 636 630 2 631 605 1 629 FA1 $T=293880 819960 0 0 $X=293880 $Y=819580
X396 889 137 2 901 142 1 905 FA1 $T=446400 799800 0 0 $X=446400 $Y=799420
X397 896 907 2 909 905 1 913 FA1 $T=452600 809880 1 0 $X=452600 $Y=804460
X398 902 915 2 917 913 1 925 FA1 $T=458800 809880 0 0 $X=458800 $Y=809500
X399 927 938 2 942 925 1 944 FA1 $T=479260 809880 0 0 $X=479260 $Y=809500
X400 940 950 2 953 944 1 955 FA1 $T=489800 819960 0 0 $X=489800 $Y=819580
X401 943 952 2 954 955 1 958 FA1 $T=491040 830040 1 0 $X=491040 $Y=824620
X402 959 965 2 966 958 1 972 FA1 $T=509020 830040 1 0 $X=509020 $Y=824620
X403 961 969 2 970 972 1 978 FA1 $T=512120 840120 1 0 $X=512120 $Y=834700
X404 976 982 2 985 978 1 991 FA1 $T=532580 840120 1 0 $X=532580 $Y=834700
X405 185 986 2 988 991 1 995 FA1 $T=534440 840120 0 0 $X=534440 $Y=839740
X406 197 1004 2 1009 995 1 1011 FA1 $T=551180 850200 1 0 $X=551180 $Y=844780
X407 198 1005 2 1006 1011 1 1012 FA1 $T=551800 850200 0 0 $X=551800 $Y=849820
X408 996 207 2 209 202 1 1023 FA1 $T=559860 789720 1 0 $X=559860 $Y=784300
X409 1000 1016 2 206 1023 1 1030 FA1 $T=559860 789720 0 0 $X=559860 $Y=789340
X410 214 999 2 1015 1012 1 203 FA1 $T=579700 860280 1 180 $X=564200 $Y=859900
X411 1026 1035 2 1032 1030 1 1040 FA1 $T=575980 799800 1 0 $X=575980 $Y=794380
X412 1029 1037 2 220 1040 1 226 FA1 $T=577220 789720 1 0 $X=577220 $Y=784300
X413 920 1038 2 1042 1021 1 1046 FA1 $T=579080 840120 1 0 $X=579080 $Y=834700
X414 993 1043 2 1044 1046 1 1051 FA1 $T=581560 840120 0 0 $X=581560 $Y=839740
X415 960 1050 2 1057 1051 1 1067 FA1 $T=591480 850200 0 0 $X=591480 $Y=849820
X416 1045 229 2 231 228 1 1055 FA1 $T=594580 779640 0 0 $X=594580 $Y=779260
X417 992 1075 2 1072 1067 1 236 FA1 $T=605740 860280 0 0 $X=605740 $Y=859900
X418 1076 1089 2 1093 1108 1 1099 FA1 $T=621240 840120 1 0 $X=621240 $Y=834700
X419 1064 1097 2 1105 1095 1 1109 FA1 $T=625580 860280 1 0 $X=625580 $Y=854860
X420 1082 1100 2 1107 1091 1 1108 FA1 $T=626200 819960 0 0 $X=626200 $Y=819580
X421 1104 1122 2 253 1109 1 254 FA1 $T=638600 860280 0 0 $X=638600 $Y=859900
X422 1299 1318 2 1316 1304 1 1328 FA1 $T=742140 819960 0 0 $X=742140 $Y=819580
X423 329 1300 2 1320 1307 1 1324 FA1 $T=742760 789720 0 0 $X=742760 $Y=789340
X424 347 1303 2 1314 1330 1 1307 FA1 $T=761980 789720 0 180 $X=746480 $Y=784300
X425 341 1336 2 1317 1324 1 1350 FA1 $T=752680 799800 0 0 $X=752680 $Y=799420
X426 340 1305 2 1343 344 1 1330 FA1 $T=753300 779640 0 0 $X=753300 $Y=779260
X427 355 1369 2 1364 1353 1 371 FA1 $T=769420 809880 1 0 $X=769420 $Y=804460
X428 372 1361 2 1329 1350 1 1353 FA1 $T=786160 799800 0 180 $X=770660 $Y=794380
X429 1482 1498 2 1491 1485 1 409 FA1 $T=839480 789720 0 0 $X=839480 $Y=789340
X430 1510 1497 2 1493 1490 1 1485 FA1 $T=858080 809880 1 180 $X=842580 $Y=809500
X431 416 1500 2 1501 411 1 1492 FA1 $T=859940 860280 1 180 $X=844440 $Y=859900
X432 1508 1502 2 1475 1514 1 1490 FA1 $T=861800 830040 0 180 $X=846300 $Y=824620
X433 405 1488 2 1504 1492 1 1514 FA1 $T=846920 840120 0 0 $X=846920 $Y=839740
X434 410 1512 2 1523 1516 1 427 FA1 $T=858700 809880 1 0 $X=858700 $Y=804460
X435 415 426 2 1525 420 1 1530 FA1 $T=861800 860280 0 0 $X=861800 $Y=859900
X436 429 1521 2 1520 1530 1 1516 FA1 $T=878540 840120 0 180 $X=863040 $Y=834700
X437 1515 1539 2 1536 1553 1 1557 FA1 $T=871100 819960 1 0 $X=871100 $Y=814540
X438 435 1531 2 1535 1557 1 423 FA1 $T=888460 799800 1 180 $X=872960 $Y=799420
X439 478 1659 2 1654 1675 1 472 FA1 $T=956660 819960 1 180 $X=941160 $Y=819580
X440 491 1681 2 1680 1689 1 1675 FA1 $T=974020 830040 0 180 $X=958520 $Y=824620
X441 1513 1687 2 489 486 1 1692 FA1 $T=959760 850200 1 0 $X=959760 $Y=844780
X442 479 1690 2 1686 1692 1 1689 FA1 $T=961000 830040 0 0 $X=961000 $Y=829660
X443 482 488 2 1691 483 1 497 FA1 $T=963480 789720 1 0 $X=963480 $Y=784300
X444 546 2 10 549 7 1 535 FA1S $T=234980 789720 0 180 $X=223200 $Y=784300
X445 544 2 543 532 539 1 552 FA1S $T=223820 819960 0 0 $X=223820 $Y=819580
X446 570 2 575 574 544 1 560 FA1S $T=253580 819960 1 180 $X=241800 $Y=819580
X447 588 2 599 596 581 1 577 FA1S $T=267220 809880 0 180 $X=255440 $Y=804460
X448 595 2 25 27 591 1 36 FA1S $T=260400 860280 0 0 $X=260400 $Y=859900
X449 605 2 590 615 588 1 592 FA1S $T=276520 819960 1 180 $X=264740 $Y=819580
X450 606 2 600 597 570 1 625 FA1S $T=267840 830040 1 0 $X=267840 $Y=824620
X451 609 2 612 613 606 1 621 FA1S $T=269080 840120 1 0 $X=269080 $Y=834700
X452 642 2 632 628 609 1 651 FA1S $T=292020 840120 1 0 $X=292020 $Y=834700
X453 675 2 678 658 642 1 686 FA1S $T=314960 850200 0 0 $X=314960 $Y=849820
X454 65 2 692 670 675 1 695 FA1S $T=319920 860280 1 0 $X=319920 $Y=854860
X455 1022 2 1039 1034 1041 1 921 FA1S $T=593960 819960 1 180 $X=582180 $Y=819580
X456 1053 2 230 232 1055 1 225 FA1S $T=606360 789720 1 180 $X=594580 $Y=789340
X457 1041 2 1070 1052 1060 1 934 FA1S $T=607600 819960 1 180 $X=595820 $Y=819580
X458 1060 2 1063 1058 1062 1 884 FA1S $T=609460 819960 0 180 $X=597680 $Y=814540
X459 1065 2 234 1068 1053 1 227 FA1S $T=611940 799800 0 180 $X=600160 $Y=794380
X460 1091 2 1081 1101 1094 1 1048 FA1S $T=637360 819960 0 180 $X=625580 $Y=814540
X461 1095 2 1103 1110 1099 1 1086 FA1S $T=639220 840120 1 180 $X=627440 $Y=839740
X462 1120 2 1128 1134 1123 1 1093 FA1S $T=651620 840120 0 180 $X=639840 $Y=834700
X463 1106 2 1133 1126 1121 1 1098 FA1S $T=652240 830040 1 180 $X=640460 $Y=829660
X464 1097 2 1118 1120 1124 1 1110 FA1S $T=652860 840120 1 180 $X=641080 $Y=839740
X465 1122 2 1156 1129 1131 1 1105 FA1S $T=654720 860280 0 180 $X=642940 $Y=854860
X466 1129 2 1147 1145 1138 1 1118 FA1S $T=656580 850200 1 180 $X=644800 $Y=849820
X467 1149 2 269 261 262 1 1114 FA1S $T=667740 789720 0 180 $X=655960 $Y=784300
X468 1152 2 1151 1150 1157 1 1131 FA1S $T=667740 860280 1 180 $X=655960 $Y=859900
X469 1153 2 1143 1165 1159 1 1047 FA1S $T=668360 799800 1 180 $X=656580 $Y=799420
X470 1159 2 1167 1160 1163 1 1125 FA1S $T=670840 799800 0 180 $X=659060 $Y=794380
X471 1163 2 1178 272 1166 1 256 FA1S $T=677040 779640 1 180 $X=665260 $Y=779260
X472 267 2 1176 1181 1169 1 1156 FA1S $T=677040 850200 1 180 $X=665260 $Y=849820
X473 1169 2 1184 1175 1168 1 1124 FA1S $T=680140 850200 0 180 $X=668360 $Y=844780
X474 1172 2 1180 1187 1149 1 1160 FA1S $T=680760 789720 1 180 $X=668980 $Y=789340
X475 1173 2 1179 1193 1153 1 1079 FA1S $T=682000 799800 1 180 $X=670220 $Y=799420
X476 1174 2 1183 1192 1173 1 1080 FA1S $T=682000 809880 1 180 $X=670220 $Y=809500
X477 270 2 280 1211 1152 1 265 FA1S $T=682000 860280 1 180 $X=670220 $Y=859900
X478 1179 2 1194 1197 1172 1 1165 FA1S $T=684480 799800 0 180 $X=672700 $Y=794380
X479 1182 2 1198 1200 1174 1 1071 FA1S $T=685720 819960 0 180 $X=673940 $Y=814540
X480 278 2 1215 1186 1201 1 271 FA1S $T=691300 860280 0 180 $X=679520 $Y=854860
X481 1199 2 1212 1206 1182 1 1059 FA1S $T=693160 819960 1 180 $X=681380 $Y=819580
X482 1195 2 1218 1219 1199 1 1061 FA1S $T=693160 830040 1 180 $X=681380 $Y=829660
X483 1204 2 1220 1216 1207 1 1188 FA1S $T=695020 809880 0 180 $X=683240 $Y=804460
X484 1201 2 1210 1213 1208 1 1181 FA1S $T=695020 850200 0 180 $X=683240 $Y=844780
X485 1216 2 1229 1203 1214 1 1196 FA1S $T=699360 799800 0 180 $X=687580 $Y=794380
X486 1198 2 1232 1221 1226 1 1192 FA1S $T=700600 819960 0 180 $X=688820 $Y=814540
X487 1207 2 1241 295 1236 1 1205 FA1S $T=706800 799800 1 180 $X=695020 $Y=799420
X488 1243 2 1238 1242 1235 1 1226 FA1S $T=714860 819960 0 180 $X=703080 $Y=814540
X489 1251 2 1224 1245 1234 1 1239 FA1S $T=719200 799800 0 180 $X=707420 $Y=794380
X490 1250 2 1223 1240 1259 1 296 FA1S $T=719200 850200 1 180 $X=707420 $Y=849820
X491 1255 2 1247 1278 1261 1 1237 FA1S $T=720440 830040 1 180 $X=708660 $Y=829660
X492 1265 2 303 1245 1233 1 1281 FA1S $T=717960 799800 0 0 $X=717960 $Y=799420
X493 1266 2 1251 1256 1265 1 1267 FA1S $T=718580 789720 0 0 $X=718580 $Y=789340
X494 310 2 1269 308 1248 1 316 FA1S $T=719200 860280 0 0 $X=719200 $Y=859900
X495 1273 2 1263 1268 1254 1 1291 FA1S $T=722300 840120 0 0 $X=722300 $Y=839740
X496 1296 2 1283 1289 1294 1 1295 FA1S $T=734080 799800 0 0 $X=734080 $Y=799420
X497 345 2 1319 1306 1340 1 1338 FA1S $T=752680 850200 0 0 $X=752680 $Y=849820
X498 1326 2 1344 1348 1334 1 1320 FA1S $T=765080 809880 1 180 $X=753300 $Y=809500
X499 1333 2 1346 1325 1335 1 1323 FA1S $T=766320 830040 0 180 $X=754540 $Y=824620
X500 1329 2 1299 1326 1323 1 1336 FA1S $T=755160 809880 1 0 $X=755160 $Y=804460
X501 1352 2 1327 1347 1333 1 1363 FA1S $T=765700 840120 1 0 $X=765700 $Y=834700
X502 357 2 1360 1359 1345 1 1367 FA1S $T=765700 860280 1 0 $X=765700 $Y=854860
X503 359 2 1367 361 1356 1 1341 FA1S $T=777480 860280 1 180 $X=765700 $Y=859900
X504 1340 2 1366 1358 1342 1 1347 FA1S $T=778100 850200 0 180 $X=766320 $Y=844780
X505 358 2 1338 1341 1352 1 1369 FA1S $T=766320 850200 0 0 $X=766320 $Y=849820
X506 1356 2 1368 1312 1349 1 1371 FA1S $T=770660 830040 1 0 $X=770660 $Y=824620
X507 1364 2 1363 1328 1371 1 1361 FA1S $T=773140 819960 1 0 $X=773140 $Y=814540
X508 1373 2 1378 1380 1377 1 1365 FA1S $T=789260 819960 1 180 $X=777480 $Y=819580
X509 1376 2 1362 1381 1372 1 1385 FA1S $T=781200 789720 0 0 $X=781200 $Y=789340
X510 378 2 381 1397 1389 1 370 FA1S $T=796080 860280 1 180 $X=784300 $Y=859900
X511 1393 2 1382 1402 1405 1 1407 FA1S $T=791120 819960 0 0 $X=791120 $Y=819580
X512 1400 2 1394 1392 1393 1 1418 FA1S $T=795460 809880 1 0 $X=795460 $Y=804460
X513 1404 2 1391 1398 1428 1 1424 FA1S $T=798560 819960 1 0 $X=798560 $Y=814540
X514 388 2 1395 1413 1423 1 393 FA1S $T=803520 860280 0 0 $X=803520 $Y=859900
X515 1422 2 1429 1417 1426 1 1438 FA1S $T=805380 799800 1 0 $X=805380 $Y=794380
X516 394 2 398 1419 1422 1 1460 FA1S $T=812200 779640 0 0 $X=812200 $Y=779260
X517 1440 2 1432 1435 1425 1 1451 FA1S $T=814680 799800 0 0 $X=814680 $Y=799420
X518 1405 2 1434 1436 1410 1 1453 FA1S $T=814680 819960 0 0 $X=814680 $Y=819580
X519 1452 2 1433 1449 1455 1 1467 FA1S $T=821500 819960 1 0 $X=821500 $Y=814540
X520 1455 2 1463 1443 1448 1 1468 FA1S $T=822120 830040 0 0 $X=822120 $Y=829660
X521 1458 2 1466 1447 1454 1 402 FA1S $T=823360 850200 1 0 $X=823360 $Y=844780
X522 1459 2 1451 1408 1473 1 1479 FA1S $T=823980 809880 0 0 $X=823980 $Y=809500
X523 1461 2 1456 1399 1440 1 1477 FA1S $T=825220 789720 0 0 $X=825220 $Y=789340
X524 1464 2 1438 1401 1459 1 1476 FA1S $T=825840 799800 1 0 $X=825840 $Y=794380
X525 1475 2 1470 1407 1480 1 1488 FA1S $T=832660 830040 1 0 $X=832660 $Y=824620
X526 403 2 1461 1460 1464 1 1498 FA1S $T=835140 779640 0 0 $X=835140 $Y=779260
X527 1480 2 1453 1390 1494 1 1496 FA1S $T=835140 830040 0 0 $X=835140 $Y=829660
X528 1483 2 1468 1465 1458 1 1495 FA1S $T=835140 840120 0 0 $X=835140 $Y=839740
X529 1487 2 1499 1431 1452 1 1470 FA1S $T=847540 819960 0 180 $X=835760 $Y=814540
X530 1473 2 1469 1478 1462 1 1499 FA1S $T=837000 809880 1 0 $X=837000 $Y=804460
X531 1489 2 1471 1474 1481 1 407 FA1S $T=839480 860280 1 0 $X=839480 $Y=854860
X532 1491 2 1477 1476 1400 1 1497 FA1S $T=840100 799800 1 0 $X=840100 $Y=794380
X533 1494 2 1472 1444 1486 1 1507 FA1S $T=842580 850200 1 0 $X=842580 $Y=844780
X534 1504 2 1467 1496 1483 1 1500 FA1S $T=848780 830040 0 0 $X=848780 $Y=829660
X535 1493 2 1418 1479 1487 1 1502 FA1S $T=849400 819960 0 0 $X=849400 $Y=819580
X536 1501 2 1489 1495 1507 1 422 FA1S $T=853120 860280 1 0 $X=853120 $Y=854860
X537 1517 2 1526 1508 419 1 1506 FA1S $T=866760 850200 1 180 $X=854980 $Y=849820
X538 421 2 1515 1482 1513 1 1511 FA1S $T=869860 789720 0 180 $X=858080 $Y=784300
X539 1522 2 1527 1510 424 1 1518 FA1S $T=875440 819960 1 180 $X=863660 $Y=819580
X540 1551 2 1560 1573 1565 1 1533 FA1S $T=892800 809880 0 180 $X=881020 $Y=804460
X541 453 2 1578 1592 1604 1 458 FA1S $T=907680 809880 1 0 $X=907680 $Y=804460
X542 457 2 1606 1616 1608 1 462 FA1S $T=913880 779640 0 0 $X=913880 $Y=779260
X543 1626 2 1598 1620 1622 1 469 FA1S $T=921940 860280 0 0 $X=921940 $Y=859900
X544 468 2 1627 1610 466 1 471 FA1S $T=926900 779640 0 0 $X=926900 $Y=779260
X545 1650 2 1641 1645 1636 1 1663 FA1S $T=936820 840120 0 0 $X=936820 $Y=839740
X546 1660 2 1648 1651 1632 1 475 FA1S $T=941780 809880 1 0 $X=941780 $Y=804460
X547 1661 2 1672 1614 476 1 1678 FA1S $T=942400 850200 0 0 $X=942400 $Y=849820
X548 1656 2 1650 1642 1652 1 1670 FA1S $T=943640 840120 1 0 $X=943640 $Y=834700
X549 1666 2 474 1657 1664 1 1672 FA1S $T=945500 860280 1 0 $X=945500 $Y=854860
X550 477 2 1671 1669 1676 1 481 FA1S $T=950460 789720 1 0 $X=950460 $Y=784300
X551 1676 2 1673 1667 1679 1 1684 FA1S $T=951700 809880 0 0 $X=951700 $Y=809500
X552 1677 2 1655 1682 1665 1 1683 FA1S $T=952940 789720 0 0 $X=952940 $Y=789340
X553 1681 2 1666 1668 1661 1 1690 FA1S $T=955420 840120 0 0 $X=955420 $Y=839740
X554 1685 2 1684 1643 1660 1 1693 FA1S $T=962860 819960 0 0 $X=962860 $Y=819580
X555 1686 2 1688 1678 485 1 1687 FA1S $T=962860 860280 1 0 $X=962860 $Y=854860
X556 1688 2 1646 1613 490 1 495 FA1S $T=965960 860280 0 0 $X=965960 $Y=859900
X557 6 2 536 4 1 NR2 $T=225060 860280 0 180 $X=223200 $Y=854860
X558 11 2 542 12 1 NR2 $T=234980 840120 0 0 $X=234980 $Y=839740
X559 14 2 548 12 1 NR2 $T=237460 840120 0 180 $X=235600 $Y=834700
X560 12 2 541 17 1 NR2 $T=239940 850200 0 0 $X=239940 $Y=849820
X561 15 2 18 20 1 NR2 $T=243040 860280 0 0 $X=243040 $Y=859900
X562 4 2 580 21 1 NR2 $T=251720 860280 0 0 $X=251720 $Y=859900
X563 12 2 565 26 1 NR2 $T=259160 840120 0 0 $X=259160 $Y=839740
X564 26 2 589 594 1 NR2 $T=263500 799800 1 0 $X=263500 $Y=794380
X565 12 2 591 32 1 NR2 $T=265980 860280 1 0 $X=265980 $Y=854860
X566 26 2 603 608 1 NR2 $T=269700 809880 1 0 $X=269700 $Y=804460
X567 39 2 598 604 1 NR2 $T=272800 789720 1 180 $X=270940 $Y=789340
X568 35 2 585 608 1 NR2 $T=272800 819960 1 0 $X=272800 $Y=814540
X569 35 2 611 40 1 NR2 $T=274040 809880 1 0 $X=274040 $Y=804460
X570 602 2 610 594 1 NR2 $T=277140 799800 0 180 $X=275280 $Y=794380
X571 32 2 586 40 1 NR2 $T=278380 819960 1 0 $X=278380 $Y=814540
X572 42 2 626 608 1 NR2 $T=286440 850200 0 180 $X=284580 $Y=844780
X573 46 2 630 608 1 NR2 $T=288300 819960 0 0 $X=288300 $Y=819580
X574 40 2 640 44 1 NR2 $T=289540 860280 1 0 $X=289540 $Y=854860
X575 646 2 644 653 1 NR2 $T=299460 819960 1 0 $X=299460 $Y=814540
X576 649 2 637 647 1 NR2 $T=303800 789720 0 0 $X=303800 $Y=789340
X577 680 2 682 685 1 NR2 $T=323640 830040 1 0 $X=323640 $Y=824620
X578 712 2 720 725 1 NR2 $T=346580 840120 1 0 $X=346580 $Y=834700
X579 749 2 729 752 1 NR2 $T=362080 789720 0 0 $X=362080 $Y=789340
X580 753 2 761 763 1 NR2 $T=364560 860280 1 0 $X=364560 $Y=854860
X581 81 2 747 759 1 NR2 $T=368900 789720 0 180 $X=367040 $Y=784300
X582 778 2 773 786 1 NR2 $T=381920 799800 0 0 $X=381920 $Y=799420
X583 91 2 776 792 1 NR2 $T=385020 809880 0 0 $X=385020 $Y=809500
X584 100 2 803 811 1 NR2 $T=401760 830040 0 180 $X=399900 $Y=824620
X585 806 2 805 821 1 NR2 $T=406720 799800 0 0 $X=406720 $Y=799420
X586 830 2 836 833 1 NR2 $T=414780 819960 0 0 $X=414780 $Y=819580
X587 878 2 868 879 1 NR2 $T=443920 830040 1 0 $X=443920 $Y=824620
X588 898 2 885 900 1 NR2 $T=454460 850200 0 0 $X=454460 $Y=849820
X589 895 2 892 903 1 NR2 $T=458180 840120 0 0 $X=458180 $Y=839740
X590 908 2 911 916 1 NR2 $T=468720 850200 1 0 $X=468720 $Y=844780
X591 926 2 919 932 1 NR2 $T=478640 840120 0 0 $X=478640 $Y=839740
X592 1066 2 1063 1052 1 NR2 $T=608220 809880 1 180 $X=606360 $Y=809500
X593 1054 2 1066 1058 1 NR2 $T=606980 799800 0 0 $X=606980 $Y=799420
X594 1083 2 1081 1088 1 NR2 $T=626820 799800 0 0 $X=626820 $Y=799420
X595 1115 2 1078 252 1 NR2 $T=644180 809880 1 0 $X=644180 $Y=804460
X596 249 2 1096 1115 1 NR2 $T=648520 799800 1 180 $X=646660 $Y=799420
X597 1115 2 1094 251 1 NR2 $T=646660 819960 1 0 $X=646660 $Y=814540
X598 1142 2 1123 251 1 NR2 $T=654720 840120 0 180 $X=652860 $Y=834700
X599 1139 2 1138 1144 1 NR2 $T=654100 830040 0 0 $X=654100 $Y=829660
X600 257 2 1128 252 1 NR2 $T=657200 850200 0 180 $X=655340 $Y=844780
X601 1142 2 1112 252 1 NR2 $T=658440 809880 1 180 $X=656580 $Y=809500
X602 1142 2 1127 258 1 NR2 $T=657820 840120 1 0 $X=657820 $Y=834700
X603 257 2 1145 258 1 NR2 $T=658440 840120 0 0 $X=658440 $Y=839740
X604 257 2 1151 251 1 NR2 $T=660920 850200 0 0 $X=660920 $Y=849820
X605 1146 2 260 257 1 NR2 $T=661540 809880 1 0 $X=661540 $Y=804460
X606 1155 2 1134 258 1 NR2 $T=663400 840120 0 180 $X=661540 $Y=834700
X607 1148 2 1150 1154 1 NR2 $T=664020 840120 0 0 $X=664020 $Y=839740
X608 1158 2 269 263 1 NR2 $T=667120 809880 1 0 $X=667120 $Y=804460
X609 1158 2 1166 1155 1 NR2 $T=670220 819960 1 0 $X=670220 $Y=814540
X610 1115 2 1164 1170 1 NR2 $T=673320 830040 1 0 $X=673320 $Y=824620
X611 1155 2 1157 1170 1 NR2 $T=674560 840120 1 0 $X=674560 $Y=834700
X612 1142 2 1168 1170 1 NR2 $T=678280 830040 1 180 $X=676420 $Y=829660
X613 1155 2 1175 251 1 NR2 $T=676420 840120 0 0 $X=676420 $Y=839740
X614 1171 2 1184 277 1 NR2 $T=680140 840120 0 0 $X=680140 $Y=839740
X615 279 2 1178 274 1 NR2 $T=682620 779640 1 180 $X=680760 $Y=779260
X616 1209 2 1186 1189 1 NR2 $T=691300 850200 0 0 $X=691300 $Y=849820
X617 1171 2 1210 1228 1 NR2 $T=693160 840120 1 0 $X=693160 $Y=834700
X618 258 2 1213 277 1 NR2 $T=693160 840120 0 0 $X=693160 $Y=839740
X619 1155 2 1221 1228 1 NR2 $T=693780 819960 0 0 $X=693780 $Y=819580
X620 283 2 287 1190 1 NR2 $T=696880 779640 0 0 $X=696880 $Y=779260
X621 1238 2 1227 1228 1 NR2 $T=701840 819960 1 180 $X=699980 $Y=819580
X622 1158 2 1187 289 1 NR2 $T=702460 779640 0 0 $X=702460 $Y=779260
X623 1142 2 1235 291 1 NR2 $T=702460 809880 1 0 $X=702460 $Y=804460
X624 289 2 1219 291 1 NR2 $T=703080 830040 1 0 $X=703080 $Y=824620
X625 1142 2 1208 292 1 NR2 $T=703080 840120 0 0 $X=703080 $Y=839740
X626 1171 2 1231 291 1 NR2 $T=703080 850200 0 0 $X=703080 $Y=849820
X627 1158 2 1234 293 1 NR2 $T=703700 789720 1 0 $X=703700 $Y=784300
X628 1146 2 1233 291 1 NR2 $T=705560 809880 1 0 $X=705560 $Y=804460
X629 263 2 1242 293 1 NR2 $T=707420 819960 1 180 $X=705560 $Y=819580
X630 1146 2 1240 294 1 NR2 $T=705560 850200 1 0 $X=705560 $Y=844780
X631 1146 2 290 297 1 NR2 $T=705560 860280 1 0 $X=705560 $Y=854860
X632 1244 2 1245 289 1 NR2 $T=710520 809880 0 180 $X=708660 $Y=804460
X633 298 2 1248 300 1 NR2 $T=708660 860280 1 0 $X=708660 $Y=854860
X634 1115 2 1247 1264 1 NR2 $T=709280 819960 0 0 $X=709280 $Y=819580
X635 302 2 1224 1246 1 NR2 $T=714240 779640 0 0 $X=714240 $Y=779260
X636 1158 2 1263 1264 1 NR2 $T=719200 830040 1 0 $X=719200 $Y=824620
X637 1244 2 1269 307 1 NR2 $T=722920 860280 0 180 $X=721060 $Y=854860
X638 1279 2 311 1271 1 NR2 $T=728500 860280 0 180 $X=726640 $Y=854860
X639 314 2 1285 1272 1 NR2 $T=732220 789720 1 0 $X=732220 $Y=784300
X640 1290 2 1294 1285 1 NR2 $T=734700 789720 1 180 $X=732840 $Y=789340
X641 298 2 324 304 1 NR2 $T=733460 860280 1 0 $X=733460 $Y=854860
X642 1244 2 323 297 1 NR2 $T=735320 860280 0 0 $X=735320 $Y=859900
X643 327 2 1290 1292 1 NR2 $T=739040 779640 1 180 $X=737180 $Y=779260
X644 1286 2 1304 1284 1 NR2 $T=738420 819960 1 0 $X=738420 $Y=814540
X645 1322 2 1319 1313 1 NR2 $T=751440 840120 1 180 $X=749580 $Y=839740
X646 1321 2 1312 1309 1 NR2 $T=754540 830040 1 180 $X=752680 $Y=829660
X647 343 2 338 336 1 NR2 $T=755160 860280 1 180 $X=753300 $Y=859900
X648 1337 2 1345 346 1 NR2 $T=761980 860280 0 180 $X=760120 $Y=854860
X649 1331 2 349 350 1 NR2 $T=760740 860280 0 0 $X=760740 $Y=859900
X650 1337 2 1335 1310 1 NR2 $T=763840 830040 1 180 $X=761980 $Y=829660
X651 348 2 1325 1339 1 NR2 $T=761980 840120 0 0 $X=761980 $Y=839740
X652 1337 2 1342 263 1 NR2 $T=763840 850200 0 180 $X=761980 $Y=844780
X653 1337 2 1334 1339 1 NR2 $T=763220 819960 0 0 $X=763220 $Y=819580
X654 1331 2 1318 353 1 NR2 $T=766940 830040 1 0 $X=766940 $Y=824620
X655 348 2 1349 1310 1 NR2 $T=767560 840120 0 0 $X=767560 $Y=839740
X656 1351 2 1301 1339 1 NR2 $T=770040 809880 1 180 $X=768180 $Y=809500
X657 1331 2 1344 1355 1 NR2 $T=768180 819960 0 0 $X=768180 $Y=819580
X658 1339 2 1343 1354 1 NR2 $T=769420 789720 1 0 $X=769420 $Y=784300
X659 1331 2 1358 356 1 NR2 $T=771280 840120 0 0 $X=771280 $Y=839740
X660 1354 2 363 1357 1 NR2 $T=773760 809880 0 0 $X=773760 $Y=809500
X661 1357 2 1346 356 1 NR2 $T=775620 819960 1 180 $X=773760 $Y=819580
X662 1357 2 1366 365 1 NR2 $T=776860 840120 0 0 $X=776860 $Y=839740
X663 1357 2 1348 353 1 NR2 $T=779960 809880 0 0 $X=779960 $Y=809500
X664 366 2 1368 353 1 NR2 $T=779960 840120 1 0 $X=779960 $Y=834700
X665 1357 2 1360 367 1 NR2 $T=779960 860280 0 0 $X=779960 $Y=859900
X666 1331 2 1359 365 1 NR2 $T=781200 860280 1 0 $X=781200 $Y=854860
X667 379 2 1380 1354 1 NR2 $T=790500 809880 1 180 $X=788640 $Y=809500
X668 379 2 1381 1332 1 NR2 $T=791120 799800 0 180 $X=789260 $Y=794380
X669 1384 2 1395 1388 1 NR2 $T=791740 860280 1 0 $X=791740 $Y=854860
X670 379 2 1398 1351 1 NR2 $T=794840 819960 1 0 $X=794840 $Y=814540
X671 1403 2 1397 1354 1 NR2 $T=801040 860280 1 180 $X=799180 $Y=859900
X672 379 2 384 356 1 NR2 $T=801040 789720 0 0 $X=801040 $Y=789340
X673 1427 2 389 386 1 NR2 $T=804760 779640 1 180 $X=802900 $Y=779260
X674 1420 2 1387 1332 1 NR2 $T=806000 840120 0 180 $X=804140 $Y=834700
X675 1421 2 1410 1351 1 NR2 $T=807240 819960 1 180 $X=805380 $Y=819580
X676 1421 2 1426 369 1 NR2 $T=808480 789720 1 180 $X=806620 $Y=789340
X677 1421 2 1425 1355 1 NR2 $T=809100 809880 1 0 $X=809100 $Y=804460
X678 1416 2 1408 1411 1 NR2 $T=809100 830040 0 0 $X=809100 $Y=829660
X679 1420 2 1415 1351 1 NR2 $T=809720 840120 0 0 $X=809720 $Y=839740
X680 1430 2 1417 367 1 NR2 $T=814060 799800 1 180 $X=812200 $Y=799420
X681 1457 2 1432 367 1 NR2 $T=814060 809880 0 180 $X=812200 $Y=804460
X682 395 2 1423 1354 1 NR2 $T=814060 860280 0 180 $X=812200 $Y=854860
X683 1427 2 1429 1414 1 NR2 $T=814680 789720 1 180 $X=812820 $Y=789340
X684 1420 2 1436 386 1 NR2 $T=812820 830040 1 0 $X=812820 $Y=824620
X685 1430 2 392 1354 1 NR2 $T=814680 840120 1 180 $X=812820 $Y=839740
X686 1427 2 1435 353 1 NR2 $T=817160 809880 1 180 $X=815300 $Y=809500
X687 395 2 1434 1414 1 NR2 $T=817780 830040 0 0 $X=817780 $Y=829660
X688 396 2 1443 386 1 NR2 $T=819640 840120 0 180 $X=817780 $Y=834700
X689 1430 2 1454 385 1 NR2 $T=818400 840120 0 0 $X=818400 $Y=839740
X690 1427 2 1441 1332 1 NR2 $T=819020 809880 0 0 $X=819020 $Y=809500
X691 1421 2 397 1414 1 NR2 $T=819640 789720 0 0 $X=819640 $Y=789340
X692 382 2 1448 1332 1 NR2 $T=822120 799800 0 180 $X=820260 $Y=794380
X693 395 2 1444 374 1 NR2 $T=820880 850200 1 0 $X=820880 $Y=844780
X694 396 2 1447 1414 1 NR2 $T=822120 840120 1 0 $X=822120 $Y=834700
X695 1439 2 1449 1437 1 NR2 $T=827080 840120 0 180 $X=825220 $Y=834700
X696 1457 2 1462 386 1 NR2 $T=827700 799800 0 0 $X=827700 $Y=799420
X697 1420 2 1463 1414 1 NR2 $T=827700 819960 0 0 $X=827700 $Y=819580
X698 395 2 1466 1355 1 NR2 $T=828320 850200 0 0 $X=828320 $Y=849820
X699 382 2 1456 386 1 NR2 $T=830800 779640 1 180 $X=828940 $Y=779260
X700 1420 2 401 1355 1 NR2 $T=828940 860280 1 0 $X=828940 $Y=854860
X701 1445 2 1474 1446 1 NR2 $T=831420 860280 0 0 $X=831420 $Y=859900
X702 1430 2 1469 1414 1 NR2 $T=835140 799800 1 180 $X=833280 $Y=799420
X703 396 2 404 374 1 NR2 $T=838240 860280 0 0 $X=838240 $Y=859900
X704 1430 2 1486 1355 1 NR2 $T=840720 850200 0 180 $X=838860 $Y=844780
X705 1420 2 1481 374 1 NR2 $T=840720 850200 1 180 $X=838860 $Y=849820
X706 1427 2 1478 1355 1 NR2 $T=841340 809880 1 180 $X=839480 $Y=809500
X707 432 2 1548 1484 1 NR2 $T=882260 860280 0 180 $X=880400 $Y=854860
X708 1550 2 1542 1546 1 NR2 $T=884740 789720 1 180 $X=882880 $Y=789340
X709 1540 2 1536 1547 1 NR2 $T=885360 830040 0 180 $X=883500 $Y=824620
X710 396 2 432 433 1 NR2 $T=884740 860280 0 0 $X=884740 $Y=859900
X711 433 2 1389 438 1 NR2 $T=889700 860280 0 0 $X=889700 $Y=859900
X712 1543 2 1554 1569 1 NR2 $T=897760 850200 1 180 $X=895900 $Y=849820
X713 1406 2 1602 1600 1 NR2 $T=909540 840120 1 0 $X=909540 $Y=834700
X714 1587 2 454 1581 1 NR2 $T=912640 789720 1 180 $X=910780 $Y=789340
X715 1595 2 1610 1602 1 NR2 $T=915120 830040 1 180 $X=913260 $Y=829660
X716 461 2 1620 456 1 NR2 $T=920700 860280 0 180 $X=918840 $Y=854860
X717 448 2 1646 1644 1 NR2 $T=934340 860280 1 0 $X=934340 $Y=854860
X718 461 2 1652 1644 1 NR2 $T=939300 850200 1 180 $X=937440 $Y=849820
X719 451 2 1657 1644 1 NR2 $T=941780 860280 0 180 $X=939920 $Y=854860
X720 461 2 1641 473 1 NR2 $T=939920 860280 0 0 $X=939920 $Y=859900
X721 470 2 1664 473 1 NR2 $T=947980 860280 1 180 $X=946120 $Y=859900
X722 620 635 2 1 641 OR2 $T=293260 799800 1 0 $X=293260 $Y=794380
X723 629 640 2 1 654 OR2 $T=296980 860280 1 0 $X=296980 $Y=854860
X724 668 659 2 1 657 OR2 $T=311860 819960 1 180 $X=309380 $Y=819580
X725 58 60 2 1 671 OR2 $T=316200 779640 0 0 $X=316200 $Y=779260
X726 63 671 2 1 684 OR2 $T=322400 799800 1 0 $X=322400 $Y=794380
X727 674 679 2 1 680 OR2 $T=325500 819960 1 0 $X=325500 $Y=814540
X728 67 69 2 1 696 OR2 $T=327360 789720 0 0 $X=327360 $Y=789340
X729 704 690 2 1 688 OR2 $T=330460 840120 0 180 $X=327980 $Y=834700
X730 700 705 2 1 697 OR2 $T=339760 799800 0 180 $X=337280 $Y=794380
X731 703 684 2 1 708 OR2 $T=337280 809880 1 0 $X=337280 $Y=804460
X732 731 732 2 1 742 OR2 $T=352780 840120 0 0 $X=352780 $Y=839740
X733 746 742 2 1 736 OR2 $T=360840 850200 0 180 $X=358360 $Y=844780
X734 784 769 2 1 754 OR2 $T=375720 799800 0 180 $X=373240 $Y=794380
X735 757 779 2 1 789 OR2 $T=385020 850200 0 0 $X=385020 $Y=849820
X736 93 789 2 1 89 OR2 $T=387500 860280 1 180 $X=385020 $Y=859900
X737 817 804 2 1 788 OR2 $T=402380 809880 0 180 $X=399900 $Y=804460
X738 815 781 2 1 819 OR2 $T=403000 830040 1 0 $X=403000 $Y=824620
X739 808 764 2 1 829 OR2 $T=406100 819960 1 0 $X=406100 $Y=814540
X740 831 823 2 1 825 OR2 $T=411060 830040 0 180 $X=408580 $Y=824620
X741 819 829 2 1 842 OR2 $T=414780 819960 1 0 $X=414780 $Y=814540
X742 848 842 2 1 837 OR2 $T=422840 819960 1 180 $X=420360 $Y=819580
X743 853 855 2 1 850 OR2 $T=424700 860280 0 180 $X=422220 $Y=854860
X744 850 856 2 1 848 OR2 $T=423460 830040 1 0 $X=423460 $Y=824620
X745 838 851 2 1 856 OR2 $T=423460 840120 1 0 $X=423460 $Y=834700
X746 130 128 2 1 847 OR2 $T=442680 789720 0 180 $X=440200 $Y=784300
X747 893 890 2 1 875 OR2 $T=448880 840120 0 180 $X=446400 $Y=834700
X748 904 906 2 1 139 OR2 $T=462520 860280 0 180 $X=460040 $Y=854860
X749 956 948 2 1 941 OR2 $T=501580 850200 1 180 $X=499100 $Y=849820
X750 1013 1014 2 1 1003 OR2 $T=567920 830040 1 0 $X=567920 $Y=824620
X751 1024 1027 2 1 1019 OR2 $T=574120 830040 0 0 $X=574120 $Y=829660
X752 45 617 602 2 1 ND2S $T=283340 819960 0 180 $X=281480 $Y=814540
X753 630 622 602 2 1 ND2S $T=292020 819960 0 180 $X=290160 $Y=814540
X754 653 648 646 2 1 ND2S $T=302560 809880 0 180 $X=300700 $Y=804460
X755 647 643 649 2 1 ND2S $T=310000 799800 1 0 $X=310000 $Y=794380
X756 685 672 680 2 1 ND2S $T=327980 819960 0 0 $X=327980 $Y=819580
X757 75 701 721 2 1 ND2S $T=346580 779640 0 0 $X=346580 $Y=779260
X758 725 714 712 2 1 ND2S $T=348440 850200 0 180 $X=346580 $Y=844780
X759 79 721 78 2 1 ND2S $T=352780 789720 1 0 $X=352780 $Y=784300
X760 737 730 743 2 1 ND2S $T=358360 789720 0 0 $X=358360 $Y=789340
X761 754 745 756 2 1 ND2S $T=364560 809880 1 0 $X=364560 $Y=804460
X762 759 743 81 2 1 ND2S $T=367660 789720 0 0 $X=367660 $Y=789340
X763 763 768 753 2 1 ND2S $T=372000 850200 0 0 $X=372000 $Y=849820
X764 772 758 777 2 1 ND2S $T=373240 809880 0 0 $X=373240 $Y=809500
X765 784 756 769 2 1 ND2S $T=376960 799800 1 0 $X=376960 $Y=794380
X766 792 777 91 2 1 ND2S $T=387500 809880 0 180 $X=385640 $Y=804460
X767 799 791 801 2 1 ND2S $T=391220 830040 0 0 $X=391220 $Y=829660
X768 788 783 812 2 1 ND2S $T=396800 809880 0 0 $X=396800 $Y=809500
X769 811 801 100 2 1 ND2S $T=400520 819960 0 0 $X=400520 $Y=819580
X770 817 812 804 2 1 ND2S $T=403000 819960 1 0 $X=403000 $Y=814540
X771 831 828 823 2 1 ND2S $T=411060 819960 1 180 $X=409200 $Y=819580
X772 825 820 828 2 1 ND2S $T=409820 840120 1 0 $X=409820 $Y=834700
X773 861 862 871 2 1 ND2S $T=429660 830040 1 0 $X=429660 $Y=824620
X774 847 865 870 2 1 ND2S $T=433380 789720 0 0 $X=433380 $Y=789340
X775 130 870 128 2 1 ND2S $T=434620 779640 0 0 $X=434620 $Y=779260
X776 879 871 878 2 1 ND2S $T=437100 830040 1 0 $X=437100 $Y=824620
X777 875 866 877 2 1 ND2S $T=438960 840120 0 0 $X=438960 $Y=839740
X778 893 877 890 2 1 ND2S $T=443920 830040 0 0 $X=443920 $Y=829660
X779 894 874 891 2 1 ND2S $T=447640 860280 1 0 $X=447640 $Y=854860
X780 900 891 898 2 1 ND2S $T=455700 850200 1 0 $X=455700 $Y=844780
X781 904 138 906 2 1 ND2S $T=460660 850200 0 0 $X=460660 $Y=849820
X782 918 149 923 2 1 ND2S $T=472440 850200 0 0 $X=472440 $Y=849820
X783 932 923 926 2 1 ND2S $T=481120 850200 0 0 $X=481120 $Y=849820
X784 941 935 939 2 1 ND2S $T=487320 860280 0 0 $X=487320 $Y=859900
X785 956 939 948 2 1 ND2S $T=505300 850200 0 0 $X=505300 $Y=849820
X786 997 994 998 2 1 ND2S $T=553660 830040 0 180 $X=551800 $Y=824620
X787 1003 1006 994 2 1 ND2S $T=556140 830040 1 180 $X=554280 $Y=829660
X788 998 1004 1001 2 1 ND2S $T=554280 840120 0 0 $X=554280 $Y=839740
X789 1003 1002 998 2 1 ND2S $T=561100 830040 0 180 $X=559240 $Y=824620
X790 1014 998 1013 2 1 ND2S $T=562340 819960 1 0 $X=562340 $Y=814540
X791 1007 1001 1003 2 1 ND2S $T=562340 830040 0 0 $X=562340 $Y=829660
X792 1020 1021 1025 2 1 ND2S $T=572880 840120 1 0 $X=572880 $Y=834700
X793 1024 1025 1027 2 1 ND2S $T=574740 840120 1 0 $X=574740 $Y=834700
X794 242 1083 244 2 1 ND2S $T=629920 799800 1 0 $X=629920 $Y=794380
X795 1092 1088 246 2 1 ND2S $T=633020 799800 0 0 $X=633020 $Y=799420
X796 1092 1111 244 2 1 ND2S $T=639220 809880 1 180 $X=637360 $Y=809500
X797 1114 1116 1132 2 1 ND2S $T=651000 789720 1 0 $X=651000 $Y=784300
X798 1130 1141 246 2 1 ND2S $T=661540 819960 0 0 $X=661540 $Y=819580
X799 259 1144 264 2 1 ND2S $T=664020 830040 0 0 $X=664020 $Y=829660
X800 1137 1148 264 2 1 ND2S $T=664640 840120 1 0 $X=664640 $Y=834700
X801 259 1154 266 2 1 ND2S $T=668980 840120 0 0 $X=668980 $Y=839740
X802 1137 1161 268 2 1 ND2S $T=673320 819960 0 0 $X=673320 $Y=819580
X803 1137 1139 1177 2 1 ND2S $T=677040 830040 1 0 $X=677040 $Y=824620
X804 1130 1203 281 2 1 ND2S $T=691920 789720 1 180 $X=690060 $Y=789340
X805 259 1189 288 2 1 ND2S $T=696260 850200 0 0 $X=696260 $Y=849820
X806 281 1225 1222 2 1 ND2S $T=698740 809880 0 180 $X=696880 $Y=804460
X807 1222 1191 1228 2 1 ND2S $T=696880 840120 1 0 $X=696880 $Y=834700
X808 284 1202 1222 2 1 ND2S $T=697500 840120 0 0 $X=697500 $Y=839740
X809 1230 1209 282 2 1 ND2S $T=699980 860280 1 0 $X=699980 $Y=854860
X810 302 1217 1246 2 1 ND2S $T=708660 779640 0 0 $X=708660 $Y=779260
X811 1177 1254 284 2 1 ND2S $T=713000 840120 1 180 $X=711140 $Y=839740
X812 1130 1260 1222 2 1 ND2S $T=715480 799800 1 180 $X=713620 $Y=799420
X813 1243 1253 1130 2 1 ND2S $T=716100 819960 1 180 $X=714240 $Y=819580
X814 1257 1212 1253 2 1 ND2S $T=716720 830040 0 180 $X=714860 $Y=824620
X815 303 1259 1258 2 1 ND2S $T=717340 840120 1 0 $X=717340 $Y=834700
X816 309 1272 306 2 1 ND2S $T=722300 779640 1 180 $X=720440 $Y=779260
X817 309 1246 1222 2 1 ND2S $T=721060 789720 1 0 $X=721060 $Y=784300
X818 303 1261 1177 2 1 ND2S $T=722300 840120 1 0 $X=722300 $Y=834700
X819 1242 1257 1275 2 1 ND2S $T=723540 819960 0 0 $X=723540 $Y=819580
X820 285 1271 288 2 1 ND2S $T=727260 850200 1 0 $X=727260 $Y=844780
X821 1280 1275 1276 2 1 ND2S $T=729120 819960 0 0 $X=729120 $Y=819580
X822 303 1280 1277 2 1 ND2S $T=729120 830040 1 0 $X=729120 $Y=824620
X823 1287 313 1274 2 1 ND2S $T=730980 830040 1 180 $X=729120 $Y=829660
X824 320 1292 318 2 1 ND2S $T=734080 779640 1 180 $X=732220 $Y=779260
X825 1287 1278 1288 2 1 ND2S $T=732840 840120 1 0 $X=732840 $Y=834700
X826 1288 1268 1277 2 1 ND2S $T=733460 850200 1 0 $X=733460 $Y=844780
X827 1297 1286 1287 2 1 ND2S $T=738420 819960 0 0 $X=738420 $Y=819580
X828 1293 1284 321 2 1 ND2S $T=740280 830040 0 180 $X=738420 $Y=824620
X829 1298 1279 1249 2 1 ND2S $T=740280 860280 0 180 $X=738420 $Y=854860
X830 1297 330 331 2 1 ND2S $T=744620 850200 1 180 $X=742760 $Y=849820
X831 331 1313 1293 2 1 ND2S $T=745860 840120 1 180 $X=744000 $Y=839740
X832 1249 335 1293 2 1 ND2S $T=745860 860280 0 180 $X=744000 $Y=854860
X833 1287 1308 1293 2 1 ND2S $T=744620 809880 0 0 $X=744620 $Y=809500
X834 1311 1309 1277 2 1 ND2S $T=748340 830040 0 180 $X=746480 $Y=824620
X835 1297 336 1249 2 1 ND2S $T=750200 850200 1 180 $X=748340 $Y=849820
X836 339 343 331 2 1 ND2S $T=755160 860280 0 180 $X=753300 $Y=854860
X837 1297 1322 1277 2 1 ND2S $T=758260 840120 1 0 $X=758260 $Y=834700
X838 1288 1362 352 2 1 ND2S $T=775620 789720 1 180 $X=773760 $Y=789340
X839 1302 1372 364 2 1 ND2S $T=782440 789720 0 180 $X=780580 $Y=784300
X840 1302 1377 377 2 1 ND2S $T=788640 799800 0 0 $X=788640 $Y=799420
X841 1288 1378 1370 2 1 ND2S $T=788640 819960 1 0 $X=788640 $Y=814540
X842 1252 1388 376 2 1 ND2S $T=790500 850200 1 180 $X=788640 $Y=849820
X843 1288 1391 377 2 1 ND2S $T=793600 809880 0 180 $X=791740 $Y=804460
X844 1298 1384 1311 2 1 ND2S $T=791740 850200 1 0 $X=791740 $Y=844780
X845 1274 1419 377 2 1 ND2S $T=794840 789720 0 180 $X=792980 $Y=784300
X846 1274 1399 1370 2 1 ND2S $T=794840 789720 0 0 $X=794840 $Y=789340
X847 1379 1386 1370 2 1 ND2S $T=794840 840120 0 0 $X=794840 $Y=839740
X848 332 1411 339 2 1 ND2S $T=802280 830040 0 180 $X=800420 $Y=824620
X849 1252 1409 339 2 1 ND2S $T=802280 860280 0 180 $X=800420 $Y=854860
X850 1298 1416 390 2 1 ND2S $T=809100 840120 1 0 $X=809100 $Y=834700
X851 332 1437 1311 2 1 ND2S $T=814680 840120 0 180 $X=812820 $Y=834700
X852 391 1442 1311 2 1 ND2S $T=817780 850200 1 180 $X=815920 $Y=849820
X853 1177 1445 376 2 1 ND2S $T=815920 860280 0 0 $X=815920 $Y=859900
X854 391 1439 376 2 1 ND2S $T=820260 850200 0 180 $X=818400 $Y=844780
X855 1315 1446 1311 2 1 ND2S $T=823360 850200 1 180 $X=821500 $Y=849820
X856 1315 1450 376 2 1 ND2S $T=823360 860280 0 180 $X=821500 $Y=854860
X857 1249 400 390 2 1 ND2S $T=826460 850200 1 180 $X=824600 $Y=849820
X858 428 1560 1529 2 1 ND2S $T=888460 799800 0 180 $X=886600 $Y=794380
X859 1302 1571 1568 2 1 ND2S $T=889700 819960 0 0 $X=889700 $Y=819580
X860 425 1558 1543 2 1 ND2S $T=890940 850200 0 0 $X=890940 $Y=849820
X861 437 1578 1572 2 1 ND2S $T=895280 799800 0 0 $X=895280 $Y=799420
X862 1542 447 1577 2 1 ND2S $T=903960 779640 1 180 $X=902100 $Y=779260
X863 450 1598 1277 2 1 ND2S $T=910160 860280 0 180 $X=908300 $Y=854860
X864 1609 1613 368 2 1 ND2S $T=918220 850200 1 180 $X=916360 $Y=849820
X865 1609 1614 321 2 1 ND2S $T=921320 850200 1 180 $X=919460 $Y=849820
X866 439 1622 1629 2 1 ND2S $T=925040 850200 0 0 $X=925040 $Y=849820
X867 465 1636 1629 2 1 ND2S $T=930620 850200 0 180 $X=928760 $Y=844780
X868 465 1642 406 2 1 ND2S $T=930620 830040 0 0 $X=930620 $Y=829660
X869 1617 1645 406 2 1 ND2S $T=936200 840120 0 180 $X=934340 $Y=834700
X870 1609 1659 406 2 1 ND2S $T=939920 830040 1 180 $X=938060 $Y=829660
X871 729 73 1 75 735 2 OAI12H $T=350300 789720 0 0 $X=350300 $Y=789340
X872 747 727 1 743 750 2 OAI12H $T=360220 799800 0 0 $X=360220 $Y=799420
X873 773 744 1 754 767 2 OAI12H $T=376960 799800 1 180 $X=370760 $Y=799420
X874 776 755 1 777 782 2 OAI12H $T=378820 819960 1 0 $X=378820 $Y=814540
X875 805 785 1 788 793 2 OAI12H $T=396800 809880 0 180 $X=390600 $Y=804460
X876 803 790 1 801 814 2 OAI12H $T=394320 840120 1 0 $X=394320 $Y=834700
X877 836 810 1 825 849 2 OAI12H $T=416640 830040 1 0 $X=416640 $Y=824620
X878 868 835 1 871 864 2 OAI12H $T=432140 840120 0 0 $X=432140 $Y=839740
X879 885 873 1 891 134 2 OAI12H $T=443920 860280 0 0 $X=443920 $Y=859900
X880 892 872 1 875 882 2 OAI12H $T=450740 840120 1 180 $X=444540 $Y=839740
X881 911 135 1 139 145 2 OAI12H $T=465000 860280 0 0 $X=465000 $Y=859900
X882 919 148 1 923 928 2 OAI12H $T=472440 860280 0 0 $X=472440 $Y=859900
X883 160 929 1 941 159 2 OAI12H $T=504680 860280 1 180 $X=498480 $Y=859900
X884 75 74 2 727 722 1 AOI12H $T=344100 789720 0 0 $X=344100 $Y=789340
X885 754 750 2 755 762 1 AOI12H $T=364560 809880 0 0 $X=364560 $Y=809500
X886 788 782 2 790 794 1 AOI12H $T=385640 819960 0 0 $X=385640 $Y=819580
X887 801 793 2 810 803 1 AOI12H $T=392460 830040 1 0 $X=392460 $Y=824620
X888 825 814 2 835 832 1 AOI12H $T=411060 840120 0 0 $X=411060 $Y=839740
X889 871 849 2 872 868 1 AOI12H $T=435240 840120 1 0 $X=435240 $Y=834700
X890 875 864 2 873 881 1 AOI12H $T=439580 850200 1 0 $X=439580 $Y=844780
X891 891 882 2 135 885 1 AOI12H $T=451360 860280 1 0 $X=451360 $Y=854860
X892 923 145 2 929 919 1 AOI12H $T=484220 860280 0 180 $X=478020 $Y=854860
X893 941 928 2 157 947 1 AOI12H $T=490420 860280 0 0 $X=490420 $Y=859900
X894 530 531 538 2 1 XOR2HS $T=221960 809880 0 0 $X=221960 $Y=809500
X895 626 629 634 2 1 XOR2HS $T=289540 850200 1 0 $X=289540 $Y=844780
X896 701 73 72 2 1 XOR2HS $T=337280 789720 0 180 $X=331700 $Y=784300
X897 730 727 687 2 1 XOR2HS $T=352160 799800 0 180 $X=346580 $Y=794380
X898 745 744 733 2 1 XOR2HS $T=361460 809880 0 180 $X=355880 $Y=804460
X899 758 755 739 2 1 XOR2HS $T=367660 819960 0 180 $X=362080 $Y=814540
X900 791 790 771 2 1 XOR2HS $T=388740 830040 1 180 $X=383160 $Y=829660
X901 783 785 800 2 1 XOR2HS $T=389360 809880 0 0 $X=389360 $Y=809500
X902 820 810 809 2 1 XOR2HS $T=406720 840120 0 180 $X=401140 $Y=834700
X903 112 111 109 2 1 XOR2HS $T=415400 789720 0 180 $X=409820 $Y=784300
X904 862 835 818 2 1 XOR2HS $T=430280 840120 1 180 $X=424700 $Y=839740
X905 865 121 119 2 1 XOR2HS $T=431520 799800 0 180 $X=425940 $Y=794380
X906 866 872 857 2 1 XOR2HS $T=438340 850200 0 180 $X=432760 $Y=844780
X907 874 873 839 2 1 XOR2HS $T=438960 860280 0 180 $X=433380 $Y=854860
X908 935 929 153 2 1 XOR2HS $T=486700 860280 1 0 $X=486700 $Y=854860
X909 444 1575 1588 2 1 XOR2HS $T=902720 789720 0 0 $X=902720 $Y=789340
X910 610 603 614 2 1 XNR2HS $T=274660 799800 0 0 $X=274660 $Y=799420
X911 679 674 668 2 1 XNR2HS $T=323640 819960 0 180 $X=318060 $Y=814540
X912 701 74 68 2 1 XNR2HS $T=344720 789720 0 180 $X=339140 $Y=784300
X913 732 731 725 2 1 XNR2HS $T=356500 850200 0 180 $X=350920 $Y=844780
X914 730 735 715 2 1 XNR2HS $T=358980 799800 0 180 $X=353400 $Y=794380
X915 745 750 728 2 1 XNR2HS $T=363940 809880 1 180 $X=358360 $Y=809500
X916 758 767 770 2 1 XNR2HS $T=368900 830040 1 0 $X=368900 $Y=824620
X917 779 757 763 2 1 XNR2HS $T=382540 860280 0 180 $X=376960 $Y=854860
X918 783 782 748 2 1 XNR2HS $T=383780 819960 1 180 $X=378200 $Y=819580
X919 791 793 774 2 1 XNR2HS $T=390600 830040 0 180 $X=385020 $Y=824620
X920 820 814 798 2 1 XNR2HS $T=409200 840120 1 180 $X=403620 $Y=839740
X921 866 864 844 2 1 XNR2HS $T=431520 850200 0 180 $X=425940 $Y=844780
X922 862 849 834 2 1 XNR2HS $T=428420 840120 1 0 $X=428420 $Y=834700
X923 874 882 869 2 1 XNR2HS $T=445780 860280 0 180 $X=440200 $Y=854860
X924 935 928 151 2 1 XNR2HS $T=486080 860280 1 180 $X=480500 $Y=859900
X925 1002 1007 988 2 1 XNR2HS $T=564820 840120 0 180 $X=559240 $Y=834700
X926 1002 997 1009 2 1 XNR2HS $T=567300 840120 1 0 $X=567300 $Y=834700
X927 1027 1024 1033 2 1 XNR2HS $T=576600 830040 0 0 $X=576600 $Y=829660
X928 700 697 2 1 689 67 MUX2 $T=333560 799800 0 180 $X=329220 $Y=794380
X929 689 703 2 1 693 66 MUX2 $T=334800 809880 0 180 $X=330460 $Y=804460
X930 697 703 2 1 711 63 MUX2 $T=338520 789720 0 0 $X=338520 $Y=789340
X931 715 76 2 1 705 687 MUX2 $T=345340 799800 0 180 $X=341000 $Y=794380
X932 733 723 2 1 700 728 MUX2 $T=354020 809880 0 180 $X=349680 $Y=804460
X933 770 723 2 1 764 739 MUX2 $T=373860 819960 0 180 $X=369520 $Y=814540
X934 774 723 2 1 781 771 MUX2 $T=376960 830040 0 0 $X=376960 $Y=829660
X935 800 723 2 1 808 748 MUX2 $T=393700 819960 0 0 $X=393700 $Y=819580
X936 809 723 2 1 815 798 MUX2 $T=397420 840120 0 0 $X=397420 $Y=839740
X937 815 819 2 1 824 808 MUX2 $T=404860 819960 0 0 $X=404860 $Y=819580
X938 834 106 2 1 851 818 MUX2 $T=416640 840120 1 0 $X=416640 $Y=834700
X939 853 850 2 1 843 838 MUX2 $T=422840 840120 1 180 $X=418500 $Y=839740
X940 846 837 2 1 858 711 MUX2 $T=419740 799800 0 0 $X=419740 $Y=799420
X941 850 848 2 1 846 819 MUX2 $T=424080 819960 0 180 $X=419740 $Y=814540
X942 857 106 2 1 838 844 MUX2 $T=424080 850200 0 180 $X=419740 $Y=844780
X943 843 848 2 1 859 824 MUX2 $T=422840 819960 0 0 $X=422840 $Y=819580
X944 848 837 2 1 863 703 MUX2 $T=424700 809880 1 0 $X=424700 $Y=804460
X945 859 837 2 1 867 693 MUX2 $T=425320 819960 1 0 $X=425320 $Y=814540
X946 869 106 2 1 855 839 MUX2 $T=431520 860280 0 180 $X=427180 $Y=854860
X947 126 106 2 1 853 122 MUX2 $T=437100 860280 1 180 $X=432760 $Y=859900
X948 188 177 2 1 178 867 MUX2 $T=533200 830040 0 180 $X=528860 $Y=824620
X949 181 177 2 1 187 863 MUX2 $T=530720 809880 1 0 $X=530720 $Y=804460
X950 189 177 2 1 186 837 MUX2 $T=540020 819960 1 180 $X=535680 $Y=819580
X951 193 177 2 1 190 858 MUX2 $T=543740 799800 1 180 $X=539400 $Y=799420
X952 51 1 2 55 DELB $T=292640 779640 0 0 $X=292640 $Y=779260
X953 663 1 2 662 DELB $T=311860 789720 0 0 $X=311860 $Y=789340
X954 665 1 2 666 DELB $T=312480 799800 1 0 $X=312480 $Y=794380
X955 707 1 2 706 DELB $T=339760 799800 0 0 $X=339760 $Y=799420
X956 716 1 2 713 DELB $T=344720 819960 0 0 $X=344720 $Y=819580
X957 724 1 2 717 DELB $T=349680 819960 0 0 $X=349680 $Y=819580
X958 751 1 2 740 DELB $T=362080 830040 1 0 $X=362080 $Y=824620
X959 765 1 2 766 DELB $T=369520 840120 0 0 $X=369520 $Y=839740
X960 90 1 2 780 DELB $T=383160 789720 1 0 $X=383160 $Y=784300
X961 795 1 2 802 DELB $T=389980 799800 0 0 $X=389980 $Y=799420
X962 796 1 2 787 DELB $T=389980 850200 0 0 $X=389980 $Y=849820
X963 99 1 2 102 DELB $T=399280 779640 0 0 $X=399280 $Y=779260
X964 816 1 2 813 DELB $T=401140 860280 1 0 $X=401140 $Y=854860
X965 105 1 2 108 DELB $T=405480 779640 0 0 $X=405480 $Y=779260
X966 822 1 2 826 DELB $T=409200 850200 0 0 $X=409200 $Y=849820
X967 854 1 2 852 DELB $T=423460 789720 0 0 $X=423460 $Y=789340
X968 127 1 2 129 DELB $T=437100 860280 0 0 $X=437100 $Y=859900
X969 989 1 2 883 DELB $T=546220 809880 1 0 $X=546220 $Y=804460
X970 354 1 2 362 DELB $T=769420 779640 0 0 $X=769420 $Y=779260
X971 530 531 1 2 539 AN2 $T=223200 830040 1 0 $X=223200 $Y=824620
X972 620 635 1 2 638 AN2 $T=293260 799800 0 0 $X=293260 $Y=799420
X973 668 659 1 2 661 AN2 $T=314960 819960 0 180 $X=312480 $Y=814540
X974 704 690 1 2 702 AN2 $T=341000 840120 0 180 $X=338520 $Y=834700
X975 746 742 1 2 738 AN2 $T=360840 850200 1 180 $X=358360 $Y=849820
X976 93 789 1 2 92 AN2 $T=387500 860280 0 180 $X=385020 $Y=854860
X977 118 847 1 2 845 AN2 $T=423460 789720 1 180 $X=420980 $Y=789340
X978 205 1018 1 2 212 AN2 $T=570400 819960 1 0 $X=570400 $Y=814540
X979 1019 1025 1 2 1031 AN2 $T=576600 840120 1 0 $X=576600 $Y=834700
X980 1058 1054 1 2 1052 AN2 $T=602640 799800 1 180 $X=600160 $Y=799420
X981 1234 1233 1 2 1256 AN2 $T=713620 789720 1 0 $X=713620 $Y=784300
X982 1537 1543 1 2 1549 AN2 $T=880400 850200 1 0 $X=880400 $Y=844780
X983 641 639 2 638 1 645 AOI12HS $T=296980 809880 1 180 $X=292640 $Y=809500
X984 657 650 2 661 1 667 AOI12HS $T=308140 809880 1 0 $X=308140 $Y=804460
X985 688 676 2 702 1 718 AOI12HS $T=334180 850200 1 0 $X=334180 $Y=844780
X986 736 719 2 738 1 741 AOI12HS $T=356500 860280 1 0 $X=356500 $Y=854860
X987 743 735 2 747 1 744 AOI12HS $T=367040 799800 1 0 $X=367040 $Y=794380
X988 777 767 2 776 1 785 AOI12HS $T=378200 809880 0 0 $X=378200 $Y=809500
X989 602 603 28 1 2 587 OA12 $T=272180 799800 1 180 $X=268460 $Y=799420
X990 1084 235 1077 1 2 1085 OA12 $T=628060 789720 0 0 $X=628060 $Y=789340
X991 1549 1548 1545 1 2 1526 OA12 $T=884120 850200 1 180 $X=880400 $Y=849820
X992 1563 1552 1545 1 2 1547 OA12 $T=887840 840120 1 180 $X=884120 $Y=839740
X993 1601 1653 1628 1 2 1665 OA12 $T=946740 789720 0 0 $X=946740 $Y=789340
X994 547 3 537 2 1 572 QDFFRBS $T=230640 809880 0 0 $X=230640 $Y=809500
X995 660 57 633 2 1 678 QDFFRBS $T=310000 860280 0 0 $X=310000 $Y=859900
X996 717 3 698 2 1 679 QDFFRBS $T=346580 819960 0 180 $X=334800 $Y=814540
X997 739 3 698 2 1 724 QDFFRBS $T=360220 819960 0 180 $X=348440 $Y=814540
X998 797 3 84 2 1 86 QDFFRBS $T=391840 779640 1 180 $X=380060 $Y=779260
X999 852 3 97 2 1 807 QDFFRBS $T=424700 799800 0 180 $X=412920 $Y=794380
X1000 883 124 125 2 1 841 QDFFRBS $T=445780 809880 0 180 $X=434000 $Y=804460
X1001 940 124 930 2 1 167 QDFFRBS $T=497860 830040 0 0 $X=497860 $Y=829660
X1002 1086 219 1056 2 1 1043 QDFFRBS $T=624960 840120 1 180 $X=613180 $Y=839740
X1003 552 1 2 547 BUF1CK $T=236220 819960 1 0 $X=236220 $Y=814540
X1004 560 1 2 564 BUF1CK $T=242420 819960 1 0 $X=242420 $Y=814540
X1005 625 1 2 652 BUF1CK $T=303800 830040 0 0 $X=303800 $Y=829660
X1006 621 1 2 656 BUF1CK $T=305040 840120 0 0 $X=305040 $Y=839740
X1007 651 1 2 664 BUF1CK $T=312480 830040 0 0 $X=312480 $Y=829660
X1008 686 1 2 691 BUF1CK $T=327360 850200 0 0 $X=327360 $Y=849820
X1009 695 1 2 699 BUF1CK $T=332320 860280 1 0 $X=332320 $Y=854860
X1010 1008 1 2 937 BUF1CK $T=562340 819960 0 0 $X=562340 $Y=819580
X1011 356 1 2 1414 BUF1CK $T=802900 799800 1 0 $X=802900 $Y=794380
X1012 365 1 2 386 BUF1CK $T=802900 809880 0 0 $X=802900 $Y=809500
X1013 1579 1 2 1566 BUF1CK $T=897760 819960 0 0 $X=897760 $Y=819580
X1014 1576 1 2 1591 BUF1CK $T=908920 830040 1 0 $X=908920 $Y=824620
X1015 1617 1 2 445 BUF1CK $T=921940 840120 1 180 $X=919460 $Y=839740
X1016 460 1 2 1617 BUF1CK $T=920080 799800 0 0 $X=920080 $Y=799420
X1017 71 1010 1 2 INV6CK $T=566680 830040 0 180 $X=561100 $Y=824620
X1018 62 3 1 2 INV12CK $T=318680 779640 0 0 $X=318680 $Y=779260
X1019 96 71 1 2 INV12CK $T=396180 799800 0 0 $X=396180 $Y=799420
X1020 1010 124 1 2 INV12CK $T=580320 830040 0 180 $X=570400 $Y=824620
X1021 1010 219 1 2 INV12CK $T=603260 830040 0 180 $X=593340 $Y=824620
X1022 414 412 1 2 INV12CK $T=860560 799800 0 0 $X=860560 $Y=799420
X1023 256 255 1 1132 2 OR2B1S $T=657200 779640 1 180 $X=654100 $Y=779260
X1024 1195 1202 1 1113 2 OR2B1S $T=688200 840120 1 0 $X=688200 $Y=834700
X1025 1224 1217 1 1190 2 OR2B1S $T=702460 789720 0 180 $X=699360 $Y=784300
X1026 1019 1020 1022 1 2 ND2 $T=572260 830040 0 0 $X=572260 $Y=829660
X1027 1297 1321 321 1 2 ND2 $T=754540 840120 1 0 $X=754540 $Y=834700
X1028 637 53 1 643 2 639 OAI12HS $T=294500 789720 0 0 $X=294500 $Y=789340
X1029 644 645 1 648 2 650 OAI12HS $T=298840 799800 0 0 $X=298840 $Y=799420
X1030 682 667 1 672 2 676 OAI12HS $T=321780 819960 1 180 $X=318060 $Y=819580
X1031 720 718 1 714 2 719 OAI12HS $T=347820 850200 1 180 $X=344100 $Y=849820
X1032 761 741 1 768 2 83 OAI12HS $T=368900 860280 0 0 $X=368900 $Y=859900
X1033 1224 1187 1 1217 2 1214 OAI12HS $T=698120 789720 0 180 $X=694400 $Y=784300
X1034 1674 1612 1 1662 2 496 OAI12HS $T=972780 799800 1 0 $X=972780 $Y=794380
X1035 1081 1 1088 1081 1087 1083 2 OAI22S $T=631160 809880 1 180 $X=627440 $Y=809500
X1036 1150 1 1154 1150 1147 1148 2 OAI22S $T=665260 850200 0 180 $X=661540 $Y=844780
X1037 1186 1 1189 1186 1176 1209 2 OAI22S $T=682620 850200 0 0 $X=682620 $Y=849820
X1038 1228 1 1225 1228 1218 277 2 OAI22S $T=700600 830040 1 180 $X=696880 $Y=829660
X1039 311 1 1271 311 315 1279 2 OAI22S $T=724160 850200 0 0 $X=724160 $Y=849820
X1040 1290 1 1292 1290 1305 327 2 OAI22S $T=746480 779640 1 180 $X=742760 $Y=779260
X1041 333 1 335 333 1306 330 2 OAI22S $T=747100 860280 1 180 $X=743380 $Y=859900
X1042 1312 1 1309 1312 1316 1321 2 OAI22S $T=748340 840120 1 0 $X=748340 $Y=834700
X1043 1319 1 1313 1319 1327 1322 2 OAI22S $T=755160 840120 0 0 $X=755160 $Y=839740
X1044 1395 1 1388 1395 380 1384 2 OAI22S $T=798560 850200 1 180 $X=794840 $Y=849820
X1045 1408 1 1411 1408 1402 1416 2 OAI22S $T=803520 830040 0 0 $X=803520 $Y=829660
X1046 1449 1 1437 1449 1465 1439 2 OAI22S $T=833280 840120 0 180 $X=829560 $Y=834700
X1047 1472 1 1442 1472 1471 1450 2 OAI22S $T=837620 860280 0 180 $X=833900 $Y=854860
X1048 1531 1 1534 1531 1539 1541 2 OAI22S $T=876680 819960 0 0 $X=876680 $Y=819580
X1049 1536 1 1540 1536 1527 1547 2 OAI22S $T=877920 830040 0 0 $X=877920 $Y=829660
X1050 1638 1 1615 1638 1643 1563 2 OAI22S $T=934340 830040 1 0 $X=934340 $Y=824620
X1051 1231 285 282 1223 1 2 1215 AO13S $T=699980 850200 0 180 $X=695640 $Y=844780
X1052 1441 1406 390 1428 1 2 1433 AO13S $T=819640 819960 0 180 $X=815300 $Y=814540
X1053 285 1252 1223 1249 1 282 2 AOI22S $T=716100 850200 0 180 $X=712380 $Y=844780
X1054 1406 391 1428 339 1 390 2 AOI22S $T=814060 819960 1 180 $X=810340 $Y=819580
X1055 1543 1554 1534 434 1 1559 2 AOI22S $T=884740 850200 1 0 $X=884740 $Y=844780
X1056 1567 1544 436 1538 1 1556 2 AOI22S $T=889700 789720 0 180 $X=885980 $Y=784300
X1057 1568 1566 1565 1564 1 1561 2 AOI22S $T=892180 819960 0 180 $X=888460 $Y=814540
X1058 1406 1554 1540 440 1 1570 2 AOI22S $T=890940 840120 1 0 $X=890940 $Y=834700
X1059 1543 1554 1573 442 1 1584 2 AOI22S $T=893420 860280 1 0 $X=893420 $Y=854860
X1060 1568 1566 441 1561 1 1590 2 AOI22S $T=895280 819960 1 0 $X=895280 $Y=814540
X1061 1568 1579 1541 1585 1 1564 2 AOI22S $T=900240 819960 0 0 $X=900240 $Y=819580
X1062 434 1574 1586 1582 1 1587 2 AOI22S $T=902100 809880 1 0 $X=902100 $Y=804460
X1063 1567 1544 449 1556 1 1588 2 AOI22S $T=907060 789720 0 180 $X=903340 $Y=784300
X1064 1568 1579 1604 1590 1 1594 2 AOI22S $T=912020 809880 1 180 $X=908300 $Y=809500
X1065 1543 1554 1592 451 1 1603 2 AOI22S $T=908300 850200 0 0 $X=908300 $Y=849820
X1066 1567 1601 1608 1588 1 1596 2 AOI22S $T=913260 789720 0 180 $X=909540 $Y=784300
X1067 1612 1589 1616 1599 1 1607 2 AOI22S $T=917600 799800 0 180 $X=913880 $Y=794380
X1068 1605 1579 1606 1594 1 1611 2 AOI22S $T=913880 819960 0 0 $X=913880 $Y=819580
X1069 1624 465 1630 1582 1 1597 2 AOI22S $T=928760 799800 1 180 $X=925040 $Y=799420
X1070 1567 1601 1627 1596 1 1640 2 AOI22S $T=927520 789720 1 0 $X=927520 $Y=784300
X1071 1572 1589 1632 1586 1 1635 2 AOI22S $T=930000 799800 0 0 $X=930000 $Y=799420
X1072 1653 1601 1651 1640 1 1647 2 AOI22S $T=943020 789720 0 180 $X=939300 $Y=784300
X1073 1653 1601 1655 1634 1 1628 2 AOI22S $T=945500 789720 1 180 $X=941780 $Y=789340
X1074 1653 1601 1667 1647 1 1634 2 AOI22S $T=948600 789720 0 180 $X=944880 $Y=784300
X1075 1612 1674 1669 1649 1 1658 2 AOI22S $T=952320 799800 0 0 $X=952320 $Y=799420
X1076 1612 1674 1679 1635 1 1649 2 AOI22S $T=959760 809880 0 180 $X=956040 $Y=804460
X1077 1612 1674 1682 1658 1 1630 2 AOI22S $T=961620 799800 0 0 $X=961620 $Y=799420
X1078 1674 1612 488 1662 1 1630 2 AOI22S $T=966580 809880 0 180 $X=962860 $Y=804460
X1079 106 723 1 2 BUF2 $T=406720 840120 1 0 $X=406720 $Y=834700
X1080 303 321 1 2 BUF2 $T=731600 830040 1 0 $X=731600 $Y=824620
X1081 259 326 1 2 BUF2 $T=737800 850200 0 0 $X=737800 $Y=849820
X1082 1293 1311 1 2 BUF2 $T=748340 830040 1 0 $X=748340 $Y=824620
X1083 334 1351 1 2 BUF2 $T=765080 819960 1 0 $X=765080 $Y=814540
X1084 95 94 1 2 INV2 $T=393700 860280 0 0 $X=393700 $Y=859900
X1085 261 1162 1 2 INV2 $T=666500 789720 0 0 $X=666500 $Y=789340
X1086 273 1185 1 2 INV2 $T=680140 830040 1 0 $X=680140 $Y=824620
X1087 1185 276 1 2 INV2 $T=683860 830040 1 0 $X=683860 $Y=824620
X1088 291 1222 1 2 INV2 $T=708660 789720 0 0 $X=708660 $Y=789340
X1089 1130 1244 1 2 INV2 $T=714240 809880 0 180 $X=712380 $Y=804460
X1090 312 1277 1 2 INV2 $T=724780 830040 1 0 $X=724780 $Y=824620
X1091 1244 1287 1 2 INV2 $T=732220 819960 0 0 $X=732220 $Y=819580
X1092 276 342 1 2 INV2 $T=751440 830040 1 0 $X=751440 $Y=824620
X1093 337 1332 1 2 INV2 $T=759500 789720 0 0 $X=759500 $Y=789340
X1094 360 1370 1 2 INV2 $T=773760 789720 1 0 $X=773760 $Y=784300
X1095 1288 382 1 2 INV2 $T=796700 799800 1 0 $X=796700 $Y=794380
X1096 1351 376 1 2 INV2 $T=812820 850200 1 0 $X=812820 $Y=844780
X1097 1406 396 1 2 INV2 $T=885360 830040 0 0 $X=885360 $Y=829660
X1098 437 433 1 2 INV2 $T=894660 860280 0 0 $X=894660 $Y=859900
X1099 1574 434 1 2 INV2 $T=898380 830040 0 0 $X=898380 $Y=829660
X1100 439 442 1 2 INV2 $T=900860 860280 0 0 $X=900860 $Y=859900
X1101 604 602 1 598 30 582 2 MOAI1S $T=269700 789720 1 180 $X=265980 $Y=789340
X1102 586 45 1 40 46 631 2 MOAI1S $T=285200 809880 0 0 $X=285200 $Y=809500
X1103 1090 245 1 1090 245 247 2 MOAI1S $T=635500 779640 0 0 $X=635500 $Y=779260
X1104 1112 1111 1 1112 1111 1101 2 MOAI1S $T=644800 819960 0 180 $X=641080 $Y=814540
X1105 250 1114 1 250 1114 1074 2 MOAI1S $T=646040 789720 0 180 $X=642320 $Y=784300
X1106 1119 1117 1 1119 1117 1107 2 MOAI1S $T=647900 819960 1 180 $X=644180 $Y=819580
X1107 1127 1141 1 1127 1141 1119 2 MOAI1S $T=659680 830040 0 180 $X=655960 $Y=824620
X1108 1139 1144 1 1139 1144 1133 2 MOAI1S $T=662780 830040 1 180 $X=659060 $Y=829660
X1109 1164 1161 1 1164 1161 1100 2 MOAI1S $T=670840 819960 1 180 $X=667120 $Y=819580
X1110 1187 1190 1 1187 1190 1180 2 MOAI1S $T=686960 789720 1 180 $X=683240 $Y=789340
X1111 279 1190 1 279 1190 1167 2 MOAI1S $T=691920 779640 1 180 $X=688200 $Y=779260
X1112 1227 1225 1 1227 1225 1206 2 MOAI1S $T=700600 830040 0 180 $X=696880 $Y=824620
X1113 1234 1233 1 1234 1233 1229 2 MOAI1S $T=704940 799800 0 180 $X=701220 $Y=794380
X1114 1243 1260 1 1243 1260 1262 2 MOAI1S $T=717340 809880 0 0 $X=717340 $Y=809500
X1115 1262 1257 1 1262 1257 1200 2 MOAI1S $T=721680 819960 0 180 $X=717960 $Y=814540
X1116 1242 1270 1 1242 1270 1232 2 MOAI1S $T=724160 809880 0 0 $X=724160 $Y=809500
X1117 314 1272 1 314 1272 1282 2 MOAI1S $T=726020 789720 1 0 $X=726020 $Y=784300
X1118 1280 1276 1 1280 1276 1270 2 MOAI1S $T=729120 809880 1 0 $X=729120 $Y=804460
X1119 1286 1284 1 1286 1284 1283 2 MOAI1S $T=734700 819960 0 180 $X=730980 $Y=814540
X1120 1290 1282 1 1290 1282 1303 2 MOAI1S $T=738420 789720 1 0 $X=738420 $Y=784300
X1121 1301 1308 1 1301 1308 1314 2 MOAI1S $T=745860 809880 1 0 $X=745860 $Y=804460
X1122 1387 1386 1 1387 1386 1383 2 MOAI1S $T=795460 840120 0 180 $X=791740 $Y=834700
X1123 1383 1396 1 1383 1396 383 2 MOAI1S $T=796080 850200 1 0 $X=796080 $Y=844780
X1124 1415 1409 1 1415 1409 1413 2 MOAI1S $T=809100 860280 0 180 $X=805380 $Y=854860
X1125 1445 1446 1 1445 1446 399 2 MOAI1S $T=821500 860280 0 0 $X=821500 $Y=859900
X1126 1524 1505 1 1524 1505 1529 2 MOAI1S $T=872340 799800 1 0 $X=872340 $Y=794380
X1127 1519 1484 1 1519 1484 1537 2 MOAI1S $T=874820 840120 0 0 $X=874820 $Y=839740
X1128 428 1503 1 428 1503 1538 2 MOAI1S $T=876060 779640 0 0 $X=876060 $Y=779260
X1129 439 1569 1 439 1569 1559 2 MOAI1S $T=894660 840120 1 180 $X=890940 $Y=839740
X1130 1519 1550 1 1519 1575 1556 2 MOAI1S $T=892180 789720 1 0 $X=892180 $Y=784300
X1131 1574 1569 1 1574 1569 1570 2 MOAI1S $T=895900 830040 1 180 $X=892180 $Y=829660
X1132 1576 1566 1 1571 437 1553 2 MOAI1S $T=897140 819960 1 180 $X=893420 $Y=819580
X1133 1574 1528 1 1574 1528 1561 2 MOAI1S $T=899620 809880 0 180 $X=895900 $Y=804460
X1134 1542 1577 1 1542 1577 443 2 MOAI1S $T=900240 779640 1 180 $X=896520 $Y=779260
X1135 1554 1583 1 1403 1580 1577 2 MOAI1S $T=901480 840120 0 180 $X=897760 $Y=834700
X1136 1576 1552 1 1576 1552 1585 2 MOAI1S $T=899620 830040 1 0 $X=899620 $Y=824620
X1137 1555 445 1 1555 445 1580 2 MOAI1S $T=903960 850200 0 180 $X=900240 $Y=844780
X1138 1555 1583 1 1555 1583 1584 2 MOAI1S $T=905200 850200 1 180 $X=901480 $Y=849820
X1139 446 1528 1 446 1528 1590 2 MOAI1S $T=902100 809880 0 0 $X=902100 $Y=809500
X1140 1576 1583 1 1591 1583 1594 2 MOAI1S $T=905200 830040 1 0 $X=905200 $Y=824620
X1141 1591 440 1 1591 440 1564 2 MOAI1S $T=910160 819960 1 180 $X=906440 $Y=819580
X1142 1554 1593 1 1403 1595 452 2 MOAI1S $T=907060 840120 0 0 $X=907060 $Y=839740
X1143 428 1587 1 428 1597 1599 2 MOAI1S $T=907680 799800 0 0 $X=907680 $Y=799420
X1144 1600 1593 1 1600 1593 1603 2 MOAI1S $T=917600 840120 1 180 $X=913880 $Y=839740
X1145 1600 1609 1 1600 1609 1595 2 MOAI1S $T=918220 840120 0 180 $X=914500 $Y=834700
X1146 1582 440 1 1582 440 1607 2 MOAI1S $T=915120 809880 0 0 $X=915120 $Y=809500
X1147 446 1575 1 446 1575 1596 2 MOAI1S $T=915740 789720 1 0 $X=915740 $Y=784300
X1148 1532 1591 1 1532 1591 1615 2 MOAI1S $T=917600 830040 0 0 $X=917600 $Y=829660
X1149 459 1509 1 459 1509 1628 2 MOAI1S $T=921940 789720 1 0 $X=921940 $Y=784300
X1150 1619 1621 1 1619 1621 1611 2 MOAI1S $T=922560 819960 1 0 $X=922560 $Y=814540
X1151 1621 1624 1 1621 1624 1631 2 MOAI1S $T=924420 809880 1 0 $X=924420 $Y=804460
X1152 1625 464 1 1625 464 1638 2 MOAI1S $T=925040 830040 1 0 $X=925040 $Y=824620
X1153 1509 1624 1 1509 1624 1634 2 MOAI1S $T=928140 799800 1 0 $X=928140 $Y=794380
X1154 1618 1597 1 1618 1597 1635 2 MOAI1S $T=930620 809880 1 0 $X=930620 $Y=804460
X1155 1579 1611 1 1563 1631 467 2 MOAI1S $T=934340 819960 0 180 $X=930620 $Y=814540
X1156 455 1633 1 455 1633 1640 2 MOAI1S $T=933100 789720 0 0 $X=933100 $Y=789340
X1157 455 1639 1 455 1639 1649 2 MOAI1S $T=934340 809880 1 0 $X=934340 $Y=804460
X1158 1617 1633 1 1617 1633 1647 2 MOAI1S $T=934960 799800 1 0 $X=934960 $Y=794380
X1159 1579 1637 1 1563 1638 1648 2 MOAI1S $T=934960 819960 0 0 $X=934960 $Y=819580
X1160 460 1639 1 1617 1639 1658 2 MOAI1S $T=941160 799800 1 0 $X=941160 $Y=794380
X1161 464 1639 1 464 1639 1662 2 MOAI1S $T=941160 809880 0 0 $X=941160 $Y=809500
X1162 1096 1077 245 1090 2 243 1 AOI13HS $T=634260 789720 0 180 $X=630540 $Y=784300
X1163 1127 1126 1130 246 2 1135 1 AOI13HS $T=650380 819960 0 0 $X=650380 $Y=819580
X1164 1387 387 1252 1370 2 1412 1 AOI13HS $T=809100 840120 1 180 $X=805380 $Y=839740
X1165 46 1 42 619 2 617 ND3 $T=287060 830040 1 180 $X=284580 $Y=829660
X1166 1112 1 244 1117 2 1137 ND3 $T=657200 819960 1 0 $X=657200 $Y=814540
X1167 1164 1 268 1121 2 1137 ND3 $T=671460 830040 1 180 $X=668980 $Y=829660
X1168 1301 1 1293 1289 2 1287 ND3 $T=737800 809880 1 180 $X=735320 $Y=809500
X1169 1415 1 339 1396 2 1252 ND3 $T=808480 850200 1 180 $X=806000 $Y=849820
X1170 1552 1 1555 1545 2 1558 ND3 $T=885360 860280 1 0 $X=885360 $Y=854860
X1171 1195 1191 1 1195 1069 1191 2 MOAI1 $T=688200 840120 0 180 $X=683860 $Y=834700
X1172 408 1550 1 408 1572 1550 2 MOAI1 $T=890320 799800 1 0 $X=890320 $Y=794380
X1173 1562 1532 1 1562 1563 1532 2 MOAI1 $T=904580 840120 1 0 $X=904580 $Y=834700
X1174 463 1586 1572 2 1589 1607 1 AO22 $T=925660 799800 0 180 $X=920700 $Y=794380
X1175 568 19 553 2 1 549 XOR3 $T=247380 779640 1 180 $X=236220 $Y=779260
X1176 584 582 571 2 1 563 XOR3 $T=259160 789720 1 180 $X=248000 $Y=789340
X1177 29 589 22 2 1 553 XOR3 $T=265360 779640 1 180 $X=254200 $Y=779260
X1178 585 586 587 2 1 596 XOR3 $T=258540 819960 1 0 $X=258540 $Y=814540
X1179 34 593 601 2 1 616 XOR3 $T=273420 860280 1 0 $X=273420 $Y=854860
X1180 614 611 47 2 1 573 XOR3 $T=278380 789720 0 0 $X=278380 $Y=789340
X1181 627 50 607 2 1 660 XOR3 $T=295120 860280 0 0 $X=295120 $Y=859900
X1182 888 131 897 2 1 901 XOR3 $T=445160 789720 0 0 $X=445160 $Y=789340
X1183 924 147 912 2 1 909 XOR3 $T=476160 799800 1 180 $X=465000 $Y=799420
X1184 936 933 931 2 1 917 XOR3 $T=491040 799800 1 180 $X=479880 $Y=799420
X1185 945 158 951 2 1 953 XOR3 $T=492900 799800 0 0 $X=492900 $Y=799420
X1186 957 162 949 2 1 942 XOR3 $T=510880 809880 0 180 $X=499720 $Y=804460
X1187 175 975 968 2 1 966 XOR3 $T=531340 789720 0 180 $X=520180 $Y=784300
X1188 971 974 967 2 1 954 XOR3 $T=532580 819960 1 180 $X=521420 $Y=819580
X1189 192 984 979 2 1 970 XOR3 $T=544360 789720 1 180 $X=533200 $Y=789340
X1190 983 977 987 2 1 985 XOR3 $T=537540 830040 0 0 $X=537540 $Y=829660
X1191 239 1077 235 2 1 797 XOR3 $T=623100 789720 0 180 $X=611940 $Y=784300
X1192 1125 1116 1102 2 1 827 XOR3 $T=646660 799800 0 180 $X=635500 $Y=794380
X1193 558 553 561 1 2 562 MAO222 $T=239320 789720 1 0 $X=239320 $Y=784300
X1194 582 584 571 1 2 576 MAO222 $T=260400 799800 0 180 $X=255440 $Y=794380
X1195 586 587 585 1 2 590 MAO222 $T=257920 819960 0 0 $X=257920 $Y=819580
X1196 589 22 29 1 2 571 MAO222 $T=265360 789720 1 180 $X=260400 $Y=789340
X1197 34 593 601 1 2 607 MAO222 $T=267840 860280 1 0 $X=267840 $Y=854860
X1198 611 623 618 1 2 599 MAO222 $T=287060 799800 1 180 $X=282100 $Y=799420
X1199 627 50 607 1 2 52 MAO222 $T=289540 860280 0 0 $X=289540 $Y=859900
X1200 897 888 131 1 2 907 MAO222 $T=459420 789720 0 0 $X=459420 $Y=789340
X1201 912 924 147 1 2 915 MAO222 $T=479880 809880 0 180 $X=474920 $Y=804460
X1202 931 936 933 1 2 938 MAO222 $T=482980 789720 0 0 $X=482980 $Y=789340
X1203 951 945 158 1 2 952 MAO222 $T=497860 789720 0 0 $X=497860 $Y=789340
X1204 949 957 162 1 2 950 MAO222 $T=508400 809880 1 180 $X=503440 $Y=809500
X1205 968 175 975 1 2 969 MAO222 $T=527620 799800 0 180 $X=522660 $Y=794380
X1206 967 971 974 1 2 965 MAO222 $T=527620 819960 0 180 $X=522660 $Y=814540
X1207 979 192 984 1 2 982 MAO222 $T=542500 779640 1 180 $X=537540 $Y=779260
X1208 987 983 977 1 2 986 MAO222 $T=543740 819960 0 0 $X=543740 $Y=819580
X1209 238 1074 1085 1 2 1102 MAO222 $T=636740 789720 0 0 $X=636740 $Y=789340
X1210 1125 1136 1140 1 2 1143 MAO222 $T=651620 799800 1 0 $X=651620 $Y=794380
X1211 845 115 840 1 2 114 AO12 $T=420360 789720 0 180 $X=416640 $Y=784300
X1212 847 120 860 1 2 840 AO12 $T=431520 789720 0 180 $X=427800 $Y=784300
X1213 723 1 76 2 BUF4CK $T=347820 809880 0 180 $X=342860 $Y=804460
X1214 542 536 540 1 2 551 HA1 $T=223200 840120 0 0 $X=223200 $Y=839740
X1215 694 677 690 1 2 685 HA1 $T=336660 830040 1 180 $X=328600 $Y=829660
X1216 710 681 712 1 2 704 HA1 $T=338520 830040 0 0 $X=338520 $Y=829660
X1217 760 734 753 1 2 746 HA1 $T=372000 850200 0 180 $X=363940 $Y=844780
X1218 538 1 2 533 DELA $T=224440 799800 1 0 $X=224440 $Y=794380
X1219 179 973 1 2 BUF2CK $T=528860 860280 0 0 $X=528860 $Y=859900
X1220 215 1036 1 2 BUF2CK $T=587140 809880 0 0 $X=587140 $Y=809500
X1221 1484 1420 1 2 BUF2CK $T=840720 850200 0 0 $X=840720 $Y=849820
X1222 446 439 1 2 BUF2CK $T=921940 840120 0 180 $X=918840 $Y=834700
X1223 1031 1022 1008 1033 2 1 MXL2HS $T=582180 830040 0 0 $X=582180 $Y=829660
X1224 1552 1529 1546 382 2 1 MXL2HS $T=885980 799800 0 180 $X=880400 $Y=794380
X1225 1552 1572 1581 1421 2 1 MXL2HS $T=895900 789720 0 0 $X=895900 $Y=789340
X1226 1450 2 1442 1 1472 NR2P $T=833280 850200 0 0 $X=833280 $Y=849820
X1227 1534 2 1541 1 1531 NR2P $T=882880 819960 0 0 $X=882880 $Y=819580
X1228 1605 2 1615 1 1579 NR2P $T=920700 830040 0 180 $X=916980 $Y=824620
X1229 1509 1302 1524 1528 382 1503 1 2 1544 OA222 $T=873580 789720 0 0 $X=873580 $Y=789340
X1230 1582 1509 408 1550 1421 1587 1 2 1589 OA222 $T=899620 799800 0 0 $X=899620 $Y=799420
X1231 71 62 1 2 INV8CK $T=332320 779640 0 0 $X=332320 $Y=779260
X1232 413 414 1 2 INV8CK $T=860560 789720 0 0 $X=860560 $Y=789340
X1233 1137 275 1 2 INV2CK $T=678900 840120 1 0 $X=678900 $Y=834700
X1234 30 39 33 2 1 568 XNR3 $T=279000 789720 0 180 $X=267840 $Y=784300
X1235 49 48 43 2 1 584 XNR3 $T=292640 779640 1 180 $X=281480 $Y=779260
X1236 1085 238 1074 2 1 886 XNR3 $T=624960 789720 1 180 $X=613800 $Y=789340
X1237 189 182 1 177 2 OR2T $T=535680 860280 0 180 $X=529480 $Y=854860
X1238 177 887 1 210 2 OR2T $T=567300 799800 0 0 $X=567300 $Y=799420
X1239 154 1 106 2 BUF6CK $T=494140 850200 1 180 $X=486700 $Y=849820
X1240 697 696 703 1 2 OR2P $T=332940 789720 0 0 $X=332940 $Y=789340
X1241 837 708 887 1 2 OR2P $T=427180 799800 0 0 $X=427180 $Y=799420
X1242 42 617 1 619 615 622 2 OAI112HS $T=280240 819960 0 0 $X=280240 $Y=819580
.ENDS
***************************************
.SUBCKT XNR2H I2 O I1 GND VCC
** N=6 EP=5 IP=0 FDC=0
.ENDS
***************************************
.SUBCKT BUF6 I O GND VCC
** N=5 EP=4 IP=0 FDC=0
.ENDS
***************************************
.SUBCKT OA112 A1 B1 C1 C2 VCC GND O
** N=8 EP=7 IP=0 FDC=0
.ENDS
***************************************
.SUBCKT INV3CK I GND VCC O
** N=5 EP=4 IP=0 FDC=0
.ENDS
***************************************
.SUBCKT XOR2H I1 I2 O GND VCC
** N=6 EP=5 IP=0 FDC=0
.ENDS
***************************************
.SUBCKT AOI12HP B2 B1 VCC O A1 GND
** N=7 EP=6 IP=0 FDC=0
.ENDS
***************************************
.SUBCKT OAI112H C2 C1 GND B1 O A1 VCC
** N=8 EP=7 IP=0 FDC=0
.ENDS
***************************************
.SUBCKT DFFSBN D CK SB Q GND VCC QB
** N=8 EP=7 IP=0 FDC=0
.ENDS
***************************************
.SUBCKT QDFFRSBN D CK RB SB VCC GND Q
** N=8 EP=7 IP=0 FDC=0
.ENDS
***************************************
.SUBCKT ICV_5 1 2 3 4 5 6 7 8 9 10 11 12 13 14 15 16 17 18 19 20
+ 21 22 23 24 25 26 27 28 29 30 31 32 33 34 35 36 37 38 39 40
+ 41 42 43 44 45 46 47 48 49 50 51 52 53 54 55 56 57 58 59 60
+ 61 62 63 64 65 66 67 68 69 70 71 72 73 74 75 76 77 78 79 80
+ 81 82 83 84 85 86 87 88 89 90 91 92 93 94 95 96 97 98 99 100
+ 101 102 103 104 105 106 107 108 109 110 111 112 113 114 115 116 117 118 119 120
+ 121 122 123 124 125 126 127 128 129 130 131 132 133 134 135 136 137 138 139 140
+ 141 142 143 144 145 146 147 148 149 150 151 152 153 154 155 156 157 158 159 160
+ 161 162 163 164 165 166 167 168 169 170 171 172 173 174 175 176 177 178 179 180
+ 181 182 183 184 185 186 187 188 189 190 191 192 193 194 195 196 197 198 199 200
+ 201 202 203 204 205 206 207 208 209 210 211 212 213 214 215 216 217 218 219 220
+ 221 222 223 224 225 226 227 228 229 230 231 232 233 234 235 236 237 238 239 240
+ 241 242 243 244 245 246 247 248 249 250 251 252 253 254 255 256 257 258 259 260
+ 261 262 263 264 265 266 267 268 269 270 271 272 273 274 275 276 277 278 279 280
+ 281 282 283 284 285 286 287 288 289 290 291 292 293 294 295 296 297 298 299 300
+ 301 302 303 304 305 306 307 308 309 310 311 312 313 314 315 316 317 318 319 320
+ 321 322 323 324 325 326 327 328 329 330 331 332 333 334 335 336 337 338 339 340
+ 341 342 343 344 345 346 347 348 349 350 351 352 353 354 355 356 357 358 359 360
+ 361 362 363 364 365 366 367 368 369 370 371 372 373 374 375 376 377 378 379 380
+ 381 382 383 384 385 386 387 388 389 390 391 392 393 394 395 396 397 398 399 400
+ 401 402 403 404 405 406 407 408 409 410 411 412 413 414 415 416 417 418 419 420
+ 421 422 423 424 425 426 427 428 429 430 431 432 433 434 435 436 437 438 439 440
+ 441 442 443 444 445 446 447 448 449 450 451 452 453 454 455 456 457 458 459 460
+ 461 462 463 464 465 466 467 468 469 470 471 472 473 474 475 476 477 478 479 480
+ 481 482 483 484 485 486 487 488 489 490 491 492 493 494 495 496 497 498 499 500
+ 501 502 503 504 505 506 507 508 509 510 511 512 513 514 515 516 517 518 519 520
+ 521 522 523 524 525 526 527 528 529 530 531 532 533 534 535 536 537 538 539 540
+ 541 542 543 544 545 546 547 548 549 550 551 552 553 554 555 556 557 558 559 560
+ 561 562 563 564 565 566 567 568 569 570 571 572 573 574 575 576 577 578 579 580
+ 581 582 583 584 585 586 587 588 589 590 591 592 593 594 595 596 597 598 599 600
+ 601 602 603 604 605 606 639
** N=2672 EP=607 IP=13017 FDC=0
X0 786 2 1 TIE1 $T=289540 729240 1 0 $X=289540 $Y=723820
X1 651 2 1 654 BUF1 $T=226300 688920 1 0 $X=226300 $Y=683500
X2 692 2 1 651 BUF1 $T=240560 668760 0 180 $X=238080 $Y=663340
X3 696 2 1 691 BUF1 $T=248000 658680 1 180 $X=245520 $Y=658300
X4 696 2 1 692 BUF1 $T=251720 688920 1 180 $X=249240 $Y=688540
X5 709 2 1 696 BUF1 $T=254200 699000 0 180 $X=251720 $Y=693580
X6 745 2 1 17 BUF1 $T=263500 769560 0 180 $X=261020 $Y=764140
X7 700 2 1 28 BUF1 $T=263500 769560 0 0 $X=263500 $Y=769180
X8 696 2 1 738 BUF1 $T=264120 678840 1 0 $X=264120 $Y=673420
X9 696 2 1 29 BUF1 $T=264740 648600 0 0 $X=264740 $Y=648220
X10 749 2 1 744 BUF1 $T=277140 729240 0 180 $X=274660 $Y=723820
X11 784 2 1 26 BUF1 $T=280860 749400 1 180 $X=278380 $Y=749020
X12 765 2 1 34 BUF1 $T=281480 769560 1 0 $X=281480 $Y=764140
X13 49 2 1 709 BUF1 $T=298220 729240 0 180 $X=295740 $Y=723820
X14 815 2 1 771 BUF1 $T=298840 709080 1 180 $X=296360 $Y=708700
X15 42 2 1 833 BUF1 $T=298220 668760 1 0 $X=298220 $Y=663340
X16 53 2 1 804 BUF1 $T=307520 769560 0 180 $X=305040 $Y=764140
X17 53 2 1 825 BUF1 $T=307520 779640 0 180 $X=305040 $Y=774220
X18 49 2 1 829 BUF1 $T=310000 729240 1 180 $X=307520 $Y=728860
X19 949 2 1 899 BUF1 $T=351540 729240 1 180 $X=349060 $Y=728860
X20 76 2 1 875 BUF1 $T=350300 678840 0 0 $X=350300 $Y=678460
X21 90 2 1 949 BUF1 $T=369520 759480 1 180 $X=367040 $Y=759100
X22 99 2 1 870 BUF1 $T=373240 678840 1 180 $X=370760 $Y=678460
X23 996 2 1 90 BUF1 $T=375720 769560 1 180 $X=373240 $Y=769180
X24 101 2 1 996 BUF1 $T=378200 779640 0 180 $X=375720 $Y=774220
X25 996 2 1 1049 BUF1 $T=381920 749400 1 0 $X=381920 $Y=743980
X26 112 2 1 1002 BUF1 $T=389980 668760 0 180 $X=387500 $Y=663340
X27 117 2 1 1025 BUF1 $T=393080 668760 1 180 $X=390600 $Y=668380
X28 1049 2 1 1045 BUF1 $T=393700 739320 0 0 $X=393700 $Y=738940
X29 78 2 1 1093 BUF1 $T=401760 688920 1 0 $X=401760 $Y=683500
X30 121 2 1 1092 BUF1 $T=402380 729240 0 0 $X=402380 $Y=728860
X31 1049 2 1 1074 BUF1 $T=405480 709080 0 0 $X=405480 $Y=708700
X32 1093 2 1 1108 BUF1 $T=405480 729240 0 0 $X=405480 $Y=728860
X33 1049 2 1 1134 BUF1 $T=415400 709080 1 0 $X=415400 $Y=703660
X34 138 2 1 94 BUF1 $T=419120 658680 0 180 $X=416640 $Y=653260
X35 145 2 1 95 BUF1 $T=424700 658680 1 180 $X=422220 $Y=658300
X36 153 2 1 1058 BUF1 $T=427800 668760 1 0 $X=427800 $Y=663340
X37 161 2 1 111 BUF1 $T=440820 648600 1 180 $X=438340 $Y=648220
X38 1052 2 1 1192 BUF1 $T=440200 729240 1 0 $X=440200 $Y=723820
X39 168 2 1 106 BUF1 $T=445160 648600 1 180 $X=442680 $Y=648220
X40 167 2 1 1052 BUF1 $T=445780 719160 1 0 $X=445780 $Y=713740
X41 145 2 1 1237 BUF1 $T=449500 678840 0 0 $X=449500 $Y=678460
X42 138 2 1 1251 BUF1 $T=452600 678840 0 0 $X=452600 $Y=678460
X43 182 2 1 1114 BUF1 $T=465000 719160 1 0 $X=465000 $Y=713740
X44 183 2 1 1290 BUF1 $T=466240 699000 0 0 $X=466240 $Y=698620
X45 168 2 1 1300 BUF1 $T=471200 699000 0 0 $X=471200 $Y=698620
X46 1312 2 1 1155 BUF1 $T=476780 749400 0 180 $X=474300 $Y=743980
X47 1181 2 1 195 BUF1 $T=480500 648600 0 0 $X=480500 $Y=648220
X48 1300 2 1 1337 BUF1 $T=480500 709080 1 0 $X=480500 $Y=703660
X49 64 2 1 1221 BUF1 $T=488560 688920 0 0 $X=488560 $Y=688540
X50 198 2 1 1132 BUF1 $T=491660 658680 0 180 $X=489180 $Y=653260
X51 199 2 1 1369 BUF1 $T=492280 688920 0 0 $X=492280 $Y=688540
X52 1384 2 1 1170 BUF1 $T=497860 709080 1 0 $X=497860 $Y=703660
X53 209 2 1 1097 BUF1 $T=509020 688920 1 180 $X=506540 $Y=688540
X54 215 2 1 1167 BUF1 $T=511500 709080 1 180 $X=509020 $Y=708700
X55 219 2 1 1379 BUF1 $T=515220 739320 1 180 $X=512740 $Y=738940
X56 184 2 1 1444 BUF1 $T=515840 729240 1 0 $X=515840 $Y=723820
X57 1437 2 1 1198 BUF1 $T=518320 729240 1 180 $X=515840 $Y=728860
X58 208 2 1 1448 BUF1 $T=517700 658680 0 0 $X=517700 $Y=658300
X59 198 2 1 1457 BUF1 $T=521420 668760 1 0 $X=521420 $Y=663340
X60 1482 2 1 1350 BUF1 $T=530100 709080 1 0 $X=530100 $Y=703660
X61 153 2 1 1485 BUF1 $T=531340 688920 0 0 $X=531340 $Y=688540
X62 1103 2 1 1509 BUF1 $T=536300 739320 1 0 $X=536300 $Y=733900
X63 215 2 1 1519 BUF1 $T=536920 699000 0 0 $X=536920 $Y=698620
X64 1467 2 1 1506 BUF1 $T=539400 739320 0 0 $X=539400 $Y=738940
X65 1299 2 1 1453 BUF1 $T=540020 729240 1 0 $X=540020 $Y=723820
X66 1485 2 1 1539 BUF1 $T=541880 739320 1 0 $X=541880 $Y=733900
X67 209 2 1 1478 BUF1 $T=543120 719160 1 0 $X=543120 $Y=713740
X68 243 2 1 1547 BUF1 $T=544980 648600 1 0 $X=544980 $Y=643180
X69 244 2 1 245 BUF1 $T=548080 648600 1 0 $X=548080 $Y=643180
X70 151 2 1 1555 BUF1 $T=548080 699000 0 0 $X=548080 $Y=698620
X71 241 2 1 1564 BUF1 $T=548700 709080 0 0 $X=548700 $Y=708700
X72 121 2 1 1557 BUF1 $T=553040 709080 1 0 $X=553040 $Y=703660
X73 1384 2 1 1551 BUF1 $T=553040 719160 1 0 $X=553040 $Y=713740
X74 237 2 1 1580 BUF1 $T=553660 648600 0 0 $X=553660 $Y=648220
X75 248 2 1 1592 BUF1 $T=554280 648600 1 0 $X=554280 $Y=643180
X76 1482 2 1 1583 BUF1 $T=558000 729240 1 0 $X=558000 $Y=723820
X77 1583 2 1 1584 BUF1 $T=561100 729240 1 0 $X=561100 $Y=723820
X78 1434 2 1 1556 BUF1 $T=566060 668760 1 180 $X=563580 $Y=668380
X79 1591 2 1 1312 BUF1 $T=566060 719160 1 180 $X=563580 $Y=718780
X80 252 2 1 259 BUF1 $T=567920 678840 1 180 $X=565440 $Y=678460
X81 250 2 1 1618 BUF1 $T=566680 668760 0 0 $X=566680 $Y=668380
X82 1384 2 1 1603 BUF1 $T=566680 739320 1 0 $X=566680 $Y=733900
X83 121 2 1 1613 BUF1 $T=569160 688920 0 0 $X=569160 $Y=688540
X84 1524 2 1 1633 BUF1 $T=569160 719160 1 0 $X=569160 $Y=713740
X85 245 2 1 1626 BUF1 $T=569780 699000 1 0 $X=569780 $Y=693580
X86 1627 2 1 1501 BUF1 $T=573500 739320 1 180 $X=571020 $Y=738940
X87 1555 2 1 1646 BUF1 $T=574740 688920 0 0 $X=574740 $Y=688540
X88 1657 2 1 1496 BUF1 $T=579700 749400 0 180 $X=577220 $Y=743980
X89 1571 2 1 1688 BUF1 $T=585900 709080 0 0 $X=585900 $Y=708700
X90 1583 2 1 1675 BUF1 $T=586520 709080 1 0 $X=586520 $Y=703660
X91 282 2 1 1692 BUF1 $T=598300 658680 1 180 $X=595820 $Y=658300
X92 1715 2 1 1609 BUF1 $T=598920 729240 0 180 $X=596440 $Y=723820
X93 291 2 1 281 BUF1 $T=600780 668760 0 180 $X=598300 $Y=663340
X94 1650 2 1 1702 BUF1 $T=598300 709080 0 0 $X=598300 $Y=708700
X95 1737 2 1 1642 BUF1 $T=604500 749400 0 180 $X=602020 $Y=743980
X96 294 2 1 1710 BUF1 $T=605740 658680 1 180 $X=603260 $Y=658300
X97 1650 2 1 1727 BUF1 $T=604500 729240 0 0 $X=604500 $Y=728860
X98 1519 2 1 1753 BUF1 $T=607600 709080 1 0 $X=607600 $Y=703660
X99 194 2 1 1747 BUF1 $T=607600 719160 0 0 $X=607600 $Y=718780
X100 259 2 1 1759 BUF1 $T=616280 759480 1 0 $X=616280 $Y=754060
X101 182 2 1 1769 BUF1 $T=619380 699000 0 0 $X=619380 $Y=698620
X102 251 2 1 329 BUF1 $T=619380 709080 1 0 $X=619380 $Y=703660
X103 1727 2 1 1760 BUF1 $T=620620 729240 1 0 $X=620620 $Y=723820
X104 318 2 1 310 BUF1 $T=625580 699000 1 180 $X=623100 $Y=698620
X105 1594 2 1 1765 BUF1 $T=624340 729240 0 0 $X=624340 $Y=728860
X106 1727 2 1 1787 BUF1 $T=628680 739320 1 0 $X=628680 $Y=733900
X107 1795 2 1 1673 BUF1 $T=633640 688920 1 180 $X=631160 $Y=688540
X108 289 2 1 1804 BUF1 $T=633020 658680 1 0 $X=633020 $Y=653260
X109 333 2 1 328 BUF1 $T=637980 658680 0 180 $X=635500 $Y=653260
X110 306 2 1 1814 BUF1 $T=635500 699000 1 0 $X=635500 $Y=693580
X111 337 2 1 1836 BUF1 $T=641700 688920 1 0 $X=641700 $Y=683500
X112 1722 2 1 1849 BUF1 $T=645420 688920 1 0 $X=645420 $Y=683500
X113 1803 2 1 1866 BUF1 $T=646040 729240 1 0 $X=646040 $Y=723820
X114 347 2 1 1875 BUF1 $T=654720 699000 1 0 $X=654720 $Y=693580
X115 351 2 1 354 BUF1 $T=657820 709080 0 0 $X=657820 $Y=708700
X116 336 2 1 1898 BUF1 $T=658440 688920 0 0 $X=658440 $Y=688540
X117 321 2 1 1904 BUF1 $T=660300 719160 1 0 $X=660300 $Y=713740
X118 1747 2 1 1919 BUF1 $T=665260 719160 0 0 $X=665260 $Y=718780
X119 353 2 1 362 BUF1 $T=667120 709080 1 0 $X=667120 $Y=703660
X120 1591 2 1 1947 BUF1 $T=672080 719160 0 0 $X=672080 $Y=718780
X121 1915 2 1 379 BUF1 $T=678900 769560 0 0 $X=678900 $Y=769180
X122 373 2 1 385 BUF1 $T=683860 759480 0 0 $X=683860 $Y=759100
X123 1854 2 1 367 BUF1 $T=686960 658680 0 0 $X=686960 $Y=658300
X124 1814 2 1 1976 BUF1 $T=688200 688920 1 0 $X=688200 $Y=683500
X125 1795 2 1 1994 BUF1 $T=689440 688920 0 0 $X=689440 $Y=688540
X126 1753 2 1 1988 BUF1 $T=690680 719160 1 0 $X=690680 $Y=713740
X127 1876 2 1 2003 BUF1 $T=690680 729240 1 0 $X=690680 $Y=723820
X128 1814 2 1 1955 BUF1 $T=691920 699000 0 0 $X=691920 $Y=698620
X129 2000 2 1 1892 BUF1 $T=692540 719160 0 0 $X=692540 $Y=718780
X130 366 2 1 2010 BUF1 $T=693780 678840 1 0 $X=693780 $Y=673420
X131 2022 2 1 1752 BUF1 $T=701840 709080 1 180 $X=699360 $Y=708700
X132 376 2 1 2015 BUF1 $T=699360 719160 1 0 $X=699360 $Y=713740
X133 1962 2 1 2034 BUF1 $T=701220 688920 0 0 $X=701220 $Y=688540
X134 2023 2 1 2038 BUF1 $T=702460 729240 1 0 $X=702460 $Y=723820
X135 1969 2 1 2059 BUF1 $T=707420 678840 0 0 $X=707420 $Y=678460
X136 2035 2 1 2048 BUF1 $T=708040 699000 1 0 $X=708040 $Y=693580
X137 1930 2 1 394 BUF1 $T=708660 769560 1 0 $X=708660 $Y=764140
X138 2026 2 1 2078 BUF1 $T=717960 699000 1 0 $X=717960 $Y=693580
X139 386 2 1 2094 BUF1 $T=721680 648600 1 0 $X=721680 $Y=643180
X140 1836 2 1 403 BUF1 $T=724780 699000 0 0 $X=724780 $Y=698620
X141 2099 2 1 1796 BUF1 $T=727260 749400 0 180 $X=724780 $Y=743980
X142 1995 2 1 2108 BUF1 $T=727880 719160 1 0 $X=727880 $Y=713740
X143 157 2 1 2121 BUF1 $T=729120 749400 0 0 $X=729120 $Y=749020
X144 1988 2 1 2123 BUF1 $T=734080 719160 0 0 $X=734080 $Y=718780
X145 2095 2 1 2119 BUF1 $T=734700 719160 1 0 $X=734700 $Y=713740
X146 2119 2 1 2132 BUF1 $T=737800 719160 1 0 $X=737800 $Y=713740
X147 2132 2 1 2138 BUF1 $T=740280 709080 0 0 $X=740280 $Y=708700
X148 2014 2 1 2159 BUF1 $T=743380 709080 0 0 $X=743380 $Y=708700
X149 2055 2 1 2157 BUF1 $T=744000 719160 0 0 $X=744000 $Y=718780
X150 2135 2 1 2174 BUF1 $T=750200 729240 0 0 $X=750200 $Y=728860
X151 2190 2 1 2127 BUF1 $T=764460 759480 0 0 $X=764460 $Y=759100
X152 2190 2 1 2215 BUF1 $T=771900 769560 1 0 $X=771900 $Y=764140
X153 1618 2 1 435 BUF1 $T=772520 739320 1 0 $X=772520 $Y=733900
X154 2157 2 1 2236 BUF1 $T=776860 729240 0 0 $X=776860 $Y=728860
X155 440 2 1 2190 BUF1 $T=781820 769560 0 180 $X=779340 $Y=764140
X156 2229 2 1 2169 BUF1 $T=786160 678840 1 180 $X=783680 $Y=678460
X157 2121 2 1 2200 BUF1 $T=789880 749400 0 0 $X=789880 $Y=749020
X158 2099 2 1 459 BUF1 $T=793600 779640 1 0 $X=793600 $Y=774220
X159 2087 2 1 456 BUF1 $T=794840 749400 0 0 $X=794840 $Y=749020
X160 2200 2 1 2299 BUF1 $T=809100 749400 1 0 $X=809100 $Y=743980
X161 309 2 1 470 BUF1 $T=809100 759480 0 0 $X=809100 $Y=759100
X162 2312 2 1 2229 BUF1 $T=812200 699000 0 180 $X=809720 $Y=693580
X163 2022 2 1 480 BUF1 $T=819640 759480 0 0 $X=819640 $Y=759100
X164 2299 2 1 2312 BUF1 $T=823980 739320 0 180 $X=821500 $Y=733900
X165 2299 2 1 2342 BUF1 $T=830180 739320 1 0 $X=830180 $Y=733900
X166 459 2 1 2308 BUF1 $T=830800 779640 1 0 $X=830800 $Y=774220
X167 453 2 1 493 BUF1 $T=837620 779640 1 0 $X=837620 $Y=774220
X168 2150 2 1 2358 BUF1 $T=838860 668760 0 0 $X=838860 $Y=668380
X169 2342 2 1 2362 BUF1 $T=839480 729240 1 0 $X=839480 $Y=723820
X170 2362 2 1 472 BUF1 $T=844440 668760 1 180 $X=841960 $Y=668380
X171 485 2 1 503 BUF1 $T=842580 648600 1 0 $X=842580 $Y=643180
X172 492 2 1 2375 BUF1 $T=844440 658680 1 0 $X=844440 $Y=653260
X173 2342 2 1 2376 BUF1 $T=844440 729240 1 0 $X=844440 $Y=723820
X174 2342 2 1 2368 BUF1 $T=845060 739320 0 0 $X=845060 $Y=738940
X175 485 2 1 2383 BUF1 $T=848160 658680 1 0 $X=848160 $Y=653260
X176 2390 2 1 506 BUF1 $T=855600 648600 0 180 $X=853120 $Y=643180
X177 2059 2 1 522 BUF1 $T=854980 759480 1 0 $X=854980 $Y=754060
X178 2358 2 1 2409 BUF1 $T=859320 668760 0 0 $X=859320 $Y=668380
X179 525 2 1 2414 BUF1 $T=861180 648600 1 0 $X=861180 $Y=643180
X180 2383 2 1 2421 BUF1 $T=863040 658680 1 0 $X=863040 $Y=653260
X181 2121 2 1 2423 BUF1 $T=863660 749400 1 0 $X=863660 $Y=743980
X182 501 2 1 2431 BUF1 $T=865520 648600 0 0 $X=865520 $Y=648220
X183 2375 2 1 2441 BUF1 $T=865520 668760 1 0 $X=865520 $Y=663340
X184 2390 2 1 2437 BUF1 $T=874200 658680 1 0 $X=874200 $Y=653260
X185 2431 2 1 2448 BUF1 $T=876680 648600 0 0 $X=876680 $Y=648220
X186 2423 2 1 2450 BUF1 $T=879160 729240 1 0 $X=879160 $Y=723820
X187 2421 2 1 2455 BUF1 $T=881020 668760 1 0 $X=881020 $Y=663340
X188 2423 2 1 2462 BUF1 $T=883500 749400 1 0 $X=883500 $Y=743980
X189 2414 2 1 2479 BUF1 $T=887840 648600 0 0 $X=887840 $Y=648220
X190 2409 2 1 2481 BUF1 $T=887840 678840 0 0 $X=887840 $Y=678460
X191 2441 2 1 2486 BUF1 $T=892800 678840 1 0 $X=892800 $Y=673420
X192 2437 2 1 2478 BUF1 $T=895900 668760 1 0 $X=895900 $Y=663340
X193 2448 2 1 2507 BUF1 $T=903960 648600 0 0 $X=903960 $Y=648220
X194 2462 2 1 2518 BUF1 $T=903960 749400 1 0 $X=903960 $Y=743980
X195 2479 2 1 2515 BUF1 $T=907680 648600 0 0 $X=907680 $Y=648220
X196 2507 2 1 2525 BUF1 $T=916980 648600 1 0 $X=916980 $Y=643180
X197 2478 2 1 2549 BUF1 $T=916980 668760 0 0 $X=916980 $Y=668380
X198 2481 2 1 2562 BUF1 $T=923180 678840 1 0 $X=923180 $Y=673420
X199 2486 2 1 2568 BUF1 $T=925040 668760 0 0 $X=925040 $Y=668380
X200 2565 2 1 2451 BUF1 $T=933720 688920 1 180 $X=931240 $Y=688540
X201 2581 2 1 2565 BUF1 $T=936820 688920 1 0 $X=936820 $Y=683500
X202 2450 2 1 2581 BUF1 $T=939920 709080 0 0 $X=939920 $Y=708700
X203 2518 2 1 2610 BUF1 $T=946740 749400 0 0 $X=946740 $Y=749020
X204 2581 2 1 2602 BUF1 $T=954800 678840 0 0 $X=954800 $Y=678460
X205 2581 2 1 2625 BUF1 $T=954800 699000 0 0 $X=954800 $Y=698620
X206 2602 2 1 598 BUF1 $T=960380 648600 1 0 $X=960380 $Y=643180
X207 643 3 651 2 1 661 QDFFRBN $T=221340 658680 1 0 $X=221340 $Y=653260
X208 666 3 5 2 1 641 QDFFRBN $T=233120 739320 0 180 $X=221340 $Y=733900
X209 660 3 651 2 1 645 QDFFRBN $T=233740 668760 0 180 $X=221960 $Y=663340
X210 680 3 654 2 1 647 QDFFRBN $T=234360 719160 1 180 $X=222580 $Y=718780
X211 648 3 654 2 1 683 QDFFRBN $T=222580 729240 0 0 $X=222580 $Y=728860
X212 653 3 11 2 1 672 QDFFRBN $T=225060 648600 0 0 $X=225060 $Y=648220
X213 649 3 651 2 1 671 QDFFRBN $T=225060 668760 0 0 $X=225060 $Y=668380
X214 667 3 651 2 1 640 QDFFRBN $T=236840 678840 1 180 $X=225060 $Y=678460
X215 656 3 654 2 1 675 QDFFRBN $T=226300 709080 1 0 $X=226300 $Y=703660
X216 7 3 654 2 1 676 QDFFRBN $T=226920 688920 0 0 $X=226920 $Y=688540
X217 9 3 654 2 1 669 QDFFRBN $T=226920 699000 0 0 $X=226920 $Y=698620
X218 8 3 654 2 1 677 QDFFRBN $T=226920 719160 1 0 $X=226920 $Y=713740
X219 670 3 651 2 1 697 QDFFRBN $T=235600 658680 1 0 $X=235600 $Y=653260
X220 678 3 692 2 1 705 QDFFRBN $T=237460 688920 1 0 $X=237460 $Y=683500
X221 708 3 691 2 1 659 QDFFRBN $T=254200 668760 1 180 $X=242420 $Y=668380
X222 690 3 11 2 1 719 QDFFRBN $T=244900 648600 0 0 $X=244900 $Y=648220
X223 716 3 692 2 1 673 QDFFRBN $T=256680 678840 0 180 $X=244900 $Y=673420
X224 729 3 691 2 1 702 QDFFRBN $T=261640 658680 0 180 $X=249860 $Y=653260
X225 717 3 709 2 1 699 QDFFRBN $T=262260 709080 1 180 $X=250480 $Y=708700
X226 737 3 691 2 1 706 QDFFRBN $T=264120 668760 0 180 $X=252340 $Y=663340
X227 735 3 696 2 1 710 QDFFRBN $T=264740 688920 0 180 $X=252960 $Y=683500
X228 714 3 709 2 1 741 QDFFRBN $T=253580 709080 1 0 $X=253580 $Y=703660
X229 718 3 709 2 1 747 QDFFRBN $T=255440 688920 0 0 $X=255440 $Y=688540
X230 722 3 738 2 1 748 QDFFRBN $T=256680 668760 0 0 $X=256680 $Y=668380
X231 734 3 709 2 1 743 QDFFRBN $T=261640 699000 1 0 $X=261640 $Y=693580
X232 736 3 29 2 1 759 QDFFRBN $T=262880 648600 1 0 $X=262880 $Y=643180
X233 767 3 696 2 1 730 QDFFRBN $T=277760 658680 1 180 $X=265980 $Y=658300
X234 751 3 738 2 1 780 QDFFRBN $T=270320 668760 1 0 $X=270320 $Y=663340
X235 752 3 738 2 1 781 QDFFRBN $T=270320 678840 0 0 $X=270320 $Y=678460
X236 778 3 738 2 1 742 QDFFRBN $T=282720 668760 1 180 $X=270940 $Y=668380
X237 753 3 29 2 1 40 QDFFRBN $T=271560 648600 0 0 $X=271560 $Y=648220
X238 37 3 42 2 1 45 QDFFRBN $T=279000 648600 1 0 $X=279000 $Y=643180
X239 777 3 42 2 1 807 QDFFRBN $T=280860 658680 0 0 $X=280860 $Y=658300
X240 782 3 804 2 1 808 QDFFRBN $T=281480 759480 1 0 $X=281480 $Y=754060
X241 715 3 804 2 1 806 QDFFRBN $T=283960 749400 0 0 $X=283960 $Y=749020
X242 48 3 42 2 1 791 QDFFRBN $T=298220 648600 1 180 $X=286440 $Y=648220
X243 46 4 825 2 1 51 QDFFRBN $T=292020 779640 1 0 $X=292020 $Y=774220
X244 809 3 50 2 1 52 QDFFRBN $T=293260 648600 1 0 $X=293260 $Y=643180
X245 812 3 804 2 1 836 QDFFRBN $T=293880 759480 1 0 $X=293880 $Y=754060
X246 817 3 42 2 1 54 QDFFRBN $T=295120 658680 0 0 $X=295120 $Y=658300
X247 848 4 825 2 1 814 QDFFRBN $T=310000 769560 1 180 $X=298220 $Y=769180
X248 856 3 829 2 1 776 QDFFRBN $T=310620 719160 0 180 $X=298840 $Y=713740
X249 846 3 804 2 1 822 QDFFRBN $T=310620 749400 1 180 $X=298840 $Y=749020
X250 855 3 829 2 1 824 QDFFRBN $T=311860 729240 0 180 $X=300080 $Y=723820
X251 55 3 42 2 1 827 QDFFRBN $T=313100 648600 1 180 $X=301320 $Y=648220
X252 843 3 829 2 1 770 QDFFRBN $T=313100 739320 0 180 $X=301320 $Y=733900
X253 840 3 804 2 1 831 QDFFRBN $T=314340 749400 0 180 $X=302560 $Y=743980
X254 837 3 833 2 1 864 QDFFRBN $T=305040 668760 1 0 $X=305040 $Y=663340
X255 845 3 833 2 1 883 QDFFRBN $T=308760 648600 1 0 $X=308760 $Y=643180
X256 873 4 53 2 1 844 QDFFRBN $T=320540 779640 0 180 $X=308760 $Y=774220
X257 878 3 833 2 1 851 QDFFRBN $T=322400 658680 0 180 $X=310620 $Y=653260
X258 891 63 829 2 1 858 QDFFRBN $T=325500 719160 0 180 $X=313720 $Y=713740
X259 861 3 829 2 1 862 QDFFRBN $T=313720 729240 1 0 $X=313720 $Y=723820
X260 877 3 833 2 1 898 QDFFRBN $T=319920 668760 1 0 $X=319920 $Y=663340
X261 889 3 833 2 1 906 QDFFRBN $T=322400 648600 0 0 $X=322400 $Y=648220
X262 914 63 833 2 1 884 QDFFRBN $T=337900 658680 0 180 $X=326120 $Y=653260
X263 895 63 899 2 1 912 QDFFRBN $T=327360 729240 1 0 $X=327360 $Y=723820
X264 926 63 899 2 1 887 QDFFRBN $T=339760 719160 1 180 $X=327980 $Y=718780
X265 935 63 899 2 1 900 QDFFRBN $T=344720 729240 1 180 $X=332940 $Y=728860
X266 72 63 79 2 1 80 QDFFRBN $T=337280 648600 1 0 $X=337280 $Y=643180
X267 961 63 899 2 1 923 QDFFRBN $T=353400 729240 0 180 $X=341620 $Y=723820
X268 1013 63 899 2 1 931 QDFFRBN $T=354020 719160 1 180 $X=342240 $Y=718780
X269 988 63 949 2 1 955 QDFFRBN $T=365180 759480 0 180 $X=353400 $Y=754060
X270 964 63 949 2 1 986 QDFFRBN $T=354020 749400 1 0 $X=354020 $Y=743980
X271 965 63 949 2 1 84 QDFFRBN $T=354640 729240 0 0 $X=354640 $Y=728860
X272 993 63 949 2 1 963 QDFFRBN $T=367040 739320 0 180 $X=355260 $Y=733900
X273 971 63 996 2 1 981 QDFFRBN $T=358980 749400 0 0 $X=358980 $Y=749020
X274 979 63 90 2 1 96 QDFFRBN $T=360840 769560 1 0 $X=360840 $Y=764140
X275 998 63 996 2 1 105 QDFFRBN $T=367660 739320 0 0 $X=367660 $Y=738940
X276 1039 4 90 2 1 917 QDFFRBN $T=385020 759480 1 180 $X=373240 $Y=759100
X277 1043 4 996 2 1 1001 QDFFRBN $T=388120 769560 0 180 $X=376340 $Y=764140
X278 1026 63 1045 2 1 1054 QDFFRBN $T=378820 739320 1 0 $X=378820 $Y=733900
X279 1057 4 101 2 1 104 QDFFRBN $T=391840 779640 0 180 $X=380060 $Y=774220
X280 1030 63 1049 2 1 1067 QDFFRBN $T=380680 709080 0 0 $X=380680 $Y=708700
X281 1050 63 1074 2 1 1040 QDFFRBN $T=388740 688920 0 0 $X=388740 $Y=688540
X282 119 4 116 2 1 1063 QDFFRBN $T=403620 779640 0 180 $X=391840 $Y=774220
X283 1064 63 1045 2 1 122 QDFFRBN $T=392460 739320 1 0 $X=392460 $Y=733900
X284 124 4 116 2 1 1062 QDFFRBN $T=406720 769560 1 180 $X=394940 $Y=769180
X285 1113 63 1049 2 1 1085 QDFFRBN $T=411060 719160 0 180 $X=399280 $Y=713740
X286 1091 63 1074 2 1 1096 QDFFRBN $T=417880 688920 0 180 $X=406100 $Y=683500
X287 1137 63 1074 2 1 1104 QDFFRBN $T=419120 678840 0 180 $X=407340 $Y=673420
X288 1156 63 1134 2 1 1126 QDFFRBN $T=425320 719160 0 180 $X=413540 $Y=713740
X289 1136 63 1074 2 1 1152 QDFFRBN $T=416640 688920 0 0 $X=416640 $Y=688540
X290 1144 63 1171 2 1 1129 QDFFRBN $T=420360 678840 0 0 $X=420360 $Y=678460
X291 1153 63 1134 2 1 1178 QDFFRBN $T=422220 709080 1 0 $X=422220 $Y=703660
X292 1270 162 158 2 1 156 QDFFRBN $T=444540 779640 0 180 $X=432760 $Y=774220
X293 1185 63 1171 2 1 1201 QDFFRBN $T=434620 678840 0 0 $X=434620 $Y=678460
X294 1188 63 1134 2 1 1227 QDFFRBN $T=435240 709080 1 0 $X=435240 $Y=703660
X295 1258 63 1226 2 1 1219 QDFFRBN $T=456320 688920 0 180 $X=444540 $Y=683500
X296 1213 63 1226 2 1 1182 QDFFRBN $T=458800 688920 1 180 $X=447020 $Y=688540
X297 1262 63 1226 2 1 1243 QDFFRBN $T=473060 688920 1 180 $X=461280 $Y=688540
X298 1349 63 1226 2 1 175 QDFFRBN $T=484840 699000 0 180 $X=473060 $Y=693580
X299 1292 63 1226 2 1 188 QDFFRBN $T=486700 688920 1 180 $X=474920 $Y=688540
X300 1407 162 205 2 1 202 QDFFRBN $T=507160 779640 0 180 $X=495380 $Y=774220
X301 1443 162 228 2 1 231 QDFFRBN $T=519560 779640 1 0 $X=519560 $Y=774220
X302 1487 162 228 2 1 240 QDFFRBN $T=531960 779640 1 0 $X=531960 $Y=774220
X303 270 162 267 2 1 1029 QDFFRBN $T=581560 779640 0 180 $X=569780 $Y=774220
X304 1992 384 386 2 1 389 QDFFRBN $T=690680 648600 1 0 $X=690680 $Y=643180
X305 2029 384 386 2 1 395 QDFFRBN $T=705560 648600 1 0 $X=705560 $Y=643180
X306 2082 384 2094 2 1 404 QDFFRBN $T=716100 648600 0 0 $X=716100 $Y=648220
X307 2049 384 2094 2 1 410 QDFFRBN $T=727260 648600 1 0 $X=727260 $Y=643180
X308 405 406 2127 2 1 2133 QDFFRBN $T=727260 769560 1 0 $X=727260 $Y=764140
X309 2109 384 2094 2 1 412 QDFFRBN $T=729740 648600 0 0 $X=729740 $Y=648220
X310 2153 406 2121 2 1 409 QDFFRBN $T=744620 749400 1 180 $X=732840 $Y=749020
X311 2085 384 2094 2 1 419 QDFFRBN $T=740280 648600 1 0 $X=740280 $Y=643180
X312 2151 384 2169 2 1 420 QDFFRBN $T=744620 648600 0 0 $X=744620 $Y=648220
X313 413 406 2127 2 1 2184 QDFFRBN $T=745240 759480 0 0 $X=745240 $Y=759100
X314 2154 384 2169 2 1 2179 QDFFRBN $T=745860 658680 1 0 $X=745860 $Y=653260
X315 415 406 2127 2 1 2178 QDFFRBN $T=745860 759480 1 0 $X=745860 $Y=754060
X316 2183 406 2127 2 1 414 QDFFRBN $T=758880 749400 1 180 $X=747100 $Y=749020
X317 2192 406 2121 2 1 417 QDFFRBN $T=760740 739320 1 180 $X=748960 $Y=738940
X318 426 406 2190 2 1 421 QDFFRBN $T=768180 769560 0 180 $X=756400 $Y=764140
X319 422 406 2190 2 1 429 QDFFRBN $T=758260 779640 1 0 $X=758260 $Y=774220
X320 2166 406 2127 2 1 2219 QDFFRBN $T=760120 759480 1 0 $X=760120 $Y=754060
X321 2124 384 2169 2 1 2185 QDFFRBN $T=773140 648600 1 180 $X=761360 $Y=648220
X322 2193 384 2169 2 1 2237 QDFFRBN $T=761360 658680 1 0 $X=761360 $Y=653260
X323 2208 406 2200 2 1 424 QDFFRBN $T=773140 749400 0 180 $X=761360 $Y=743980
X324 1985 384 2169 2 1 2220 QDFFRBN $T=763220 668760 1 0 $X=763220 $Y=663340
X325 2218 406 2200 2 1 425 QDFFRBN $T=775000 739320 1 180 $X=763220 $Y=738940
X326 2207 433 2229 2 1 2222 QDFFRBN $T=770660 678840 0 0 $X=770660 $Y=678460
X327 431 406 2190 2 1 2249 QDFFRBN $T=771280 779640 1 0 $X=771280 $Y=774220
X328 443 406 2190 2 1 2209 QDFFRBN $T=783680 769560 1 180 $X=771900 $Y=769180
X329 437 406 2215 2 1 2251 QDFFRBN $T=775000 749400 0 0 $X=775000 $Y=749020
X330 2248 406 2215 2 1 436 QDFFRBN $T=786780 759480 0 180 $X=775000 $Y=754060
X331 2250 406 2200 2 1 438 QDFFRBN $T=788020 749400 0 180 $X=776240 $Y=743980
X332 2227 433 2229 2 1 2253 QDFFRBN $T=777480 688920 1 0 $X=777480 $Y=683500
X333 442 406 2215 2 1 2265 QDFFRBN $T=783060 769560 1 0 $X=783060 $Y=764140
X334 2199 433 2229 2 1 2275 QDFFRBN $T=788640 678840 0 0 $X=788640 $Y=678460
X335 2295 406 2215 2 1 445 QDFFRBN $T=806000 759480 1 180 $X=794220 $Y=759100
X336 465 406 2200 2 1 2261 QDFFRBN $T=807240 749400 0 180 $X=795460 $Y=743980
X337 466 406 2200 2 1 455 QDFFRBN $T=807860 739320 1 180 $X=796080 $Y=738940
X338 2268 433 2229 2 1 2294 QDFFRBN $T=796700 688920 0 0 $X=796700 $Y=688540
X339 2254 433 2229 2 1 2293 QDFFRBN $T=796700 699000 1 0 $X=796700 $Y=693580
X340 461 406 2299 2 1 2291 QDFFRBN $T=801660 749400 0 0 $X=801660 $Y=749020
X341 467 384 472 2 1 477 QDFFRBN $T=806620 648600 1 0 $X=806620 $Y=643180
X342 2273 433 2312 2 1 2320 QDFFRBN $T=807860 699000 0 0 $X=807860 $Y=698620
X343 2281 433 2312 2 1 2327 QDFFRBN $T=811580 729240 1 0 $X=811580 $Y=723820
X344 2306 433 2312 2 1 2334 QDFFRBN $T=812820 719160 1 0 $X=812820 $Y=713740
X345 473 406 2299 2 1 485 QDFFRBN $T=814680 739320 0 0 $X=814680 $Y=738940
X346 481 406 2299 2 1 2309 QDFFRBN $T=827080 749400 0 180 $X=815300 $Y=743980
X347 474 406 2299 2 1 2332 QDFFRBN $T=815920 759480 1 0 $X=815920 $Y=754060
X348 2316 384 472 2 1 2339 QDFFRBN $T=819020 648600 0 0 $X=819020 $Y=648220
X349 2310 384 472 2 1 490 QDFFRBN $T=820260 648600 1 0 $X=820260 $Y=643180
X350 2331 433 2342 2 1 2355 QDFFRBN $T=825840 729240 1 0 $X=825840 $Y=723820
X351 487 406 2342 2 1 501 QDFFRBN $T=829560 739320 0 0 $X=829560 $Y=738940
X352 2345 384 472 2 1 2380 QDFFRBN $T=833900 658680 0 0 $X=833900 $Y=658300
X353 511 406 2368 2 1 2349 QDFFRBN $T=854360 749400 1 180 $X=842580 $Y=749020
X354 2372 384 2362 2 1 2394 QDFFRBN $T=845060 668760 0 0 $X=845060 $Y=668380
X355 508 433 2376 2 1 524 QDFFRBN $T=848780 729240 1 0 $X=848780 $Y=723820
X356 521 433 2376 2 1 2378 QDFFRBN $T=861180 739320 0 180 $X=849400 $Y=733900
X357 509 433 2368 2 1 2397 QDFFRBN $T=849400 739320 0 0 $X=849400 $Y=738940
X358 512 406 2121 2 1 2416 QDFFRBN $T=852500 769560 1 0 $X=852500 $Y=764140
X359 2395 433 2362 2 1 2419 QDFFRBN $T=854980 678840 1 0 $X=854980 $Y=673420
X360 2381 433 2362 2 1 2405 QDFFRBN $T=855600 678840 0 0 $X=855600 $Y=678460
X361 2399 406 2121 2 1 2420 QDFFRBN $T=856840 769560 0 0 $X=856840 $Y=769180
X362 2401 433 2362 2 1 2433 QDFFRBN $T=858080 699000 1 0 $X=858080 $Y=693580
X363 2391 433 2362 2 1 2426 QDFFRBN $T=858700 688920 0 0 $X=858700 $Y=688540
X364 2411 433 2423 2 1 2435 QDFFRBN $T=863040 739320 1 0 $X=863040 $Y=733900
X365 526 433 2423 2 1 2439 QDFFRBN $T=863660 729240 0 0 $X=863660 $Y=728860
X366 527 433 2376 2 1 2430 QDFFRBN $T=864280 719160 0 0 $X=864280 $Y=718780
X367 2418 406 2423 2 1 2442 QDFFRBN $T=864900 749400 0 0 $X=864900 $Y=749020
X368 2427 433 2423 2 1 2459 QDFFRBN $T=869860 749400 1 0 $X=869860 $Y=743980
X369 2434 433 2451 2 1 2468 QDFFRBN $T=873580 688920 1 0 $X=873580 $Y=683500
X370 2438 433 2451 2 1 2453 QDFFRBN $T=874820 688920 0 0 $X=874820 $Y=688540
X371 2467 433 2450 2 1 2444 QDFFRBN $T=889700 719160 1 180 $X=877920 $Y=718780
X372 2469 433 2450 2 1 2446 QDFFRBN $T=890320 709080 0 180 $X=878540 $Y=703660
X373 2445 433 2462 2 1 2473 QDFFRBN $T=878540 749400 0 0 $X=878540 $Y=749020
X374 2485 433 2450 2 1 2460 QDFFRBN $T=896520 729240 0 180 $X=884740 $Y=723820
X375 2475 433 2462 2 1 2500 QDFFRBN $T=890320 749400 1 0 $X=890320 $Y=743980
X376 2470 433 2450 2 1 2495 QDFFRBN $T=894040 719160 0 0 $X=894040 $Y=718780
X377 2487 433 2451 2 1 2492 QDFFRBN $T=895280 688920 1 0 $X=895280 $Y=683500
X378 2465 433 2451 2 1 2480 QDFFRBN $T=895280 688920 0 0 $X=895280 $Y=688540
X379 2498 433 2518 2 1 2521 QDFFRBN $T=907060 759480 1 0 $X=907060 $Y=754060
X380 2547 433 2451 2 1 2516 QDFFRBN $T=921320 688920 0 180 $X=909540 $Y=683500
X381 2513 433 2450 2 1 2523 QDFFRBN $T=924420 719160 1 180 $X=912640 $Y=718780
X382 2534 433 2451 2 1 2526 QDFFRBN $T=916360 688920 0 0 $X=916360 $Y=688540
X383 2546 433 2518 2 1 2557 QDFFRBN $T=921320 749400 0 0 $X=921320 $Y=749020
X384 2584 433 2565 2 1 2552 QDFFRBN $T=934960 688920 0 180 $X=923180 $Y=683500
X385 2554 433 2581 2 1 2560 QDFFRBN $T=924420 709080 0 0 $X=924420 $Y=708700
X386 2577 433 2518 2 1 2595 QDFFRBN $T=931240 749400 1 0 $X=931240 $Y=743980
X387 2569 433 2581 2 1 2578 QDFFRBN $T=943640 709080 0 180 $X=931860 $Y=703660
X388 2600 433 2518 2 1 2588 QDFFRBN $T=946120 759480 0 180 $X=934340 $Y=754060
X389 2611 433 2565 2 1 2591 QDFFRBN $T=948600 688920 1 180 $X=936820 $Y=688540
X390 2627 433 2602 2 1 2585 QDFFRBN $T=952320 648600 1 180 $X=940540 $Y=648220
X391 2622 433 2602 2 1 2598 QDFFRBN $T=952940 678840 0 180 $X=941160 $Y=673420
X392 2599 433 2610 2 1 2612 QDFFRBN $T=941160 739320 1 0 $X=941160 $Y=733900
X393 2633 433 2602 2 1 2592 QDFFRBN $T=956660 658680 0 180 $X=944880 $Y=653260
X394 2596 433 2581 2 1 2632 QDFFRBN $T=947360 709080 1 0 $X=947360 $Y=703660
X395 2634 433 2610 2 1 2613 QDFFRBN $T=961620 749400 0 180 $X=949840 $Y=743980
X396 2618 433 2610 2 1 2626 QDFFRBN $T=953560 749400 0 0 $X=953560 $Y=749020
X397 2659 433 598 2 1 2617 QDFFRBN $T=974640 658680 1 180 $X=962860 $Y=658300
X398 2656 433 2625 2 1 2641 QDFFRBN $T=976500 699000 0 180 $X=964720 $Y=693580
X399 2639 433 2625 2 1 2636 QDFFRBN $T=976500 699000 1 180 $X=964720 $Y=698620
X400 2661 433 2625 2 1 2645 QDFFRBN $T=976500 709080 0 180 $X=964720 $Y=703660
X401 2637 433 2610 2 1 2665 QDFFRBN $T=965340 739320 0 0 $X=965340 $Y=738940
X402 601 433 598 2 1 605 QDFFRBN $T=966580 648600 1 0 $X=966580 $Y=643180
X403 600 433 2610 2 1 2652 QDFFRBN $T=966580 749400 1 0 $X=966580 $Y=743980
X404 2664 433 2610 2 1 2648 QDFFRBN $T=978360 759480 0 180 $X=966580 $Y=754060
X405 987 1000 1 2 INV3 $T=364560 729240 1 0 $X=364560 $Y=723820
X406 1016 1018 1 2 INV3 $T=375720 739320 1 0 $X=375720 $Y=733900
X407 1098 127 1 2 INV3 $T=407340 769560 0 0 $X=407340 $Y=769180
X408 1785 318 1 2 INV3 $T=628680 699000 1 180 $X=626200 $Y=698620
X409 333 1878 1 2 INV3 $T=652860 648600 0 0 $X=652860 $Y=648220
X410 1962 1964 1 2 INV3 $T=680140 678840 0 0 $X=680140 $Y=678460
X411 1878 387 1 2 INV3 $T=696260 759480 1 0 $X=696260 $Y=754060
X412 650 2 652 1 INV1S $T=224440 749400 0 0 $X=224440 $Y=749020
X413 663 2 657 1 INV1S $T=240560 739320 1 180 $X=239320 $Y=738940
X414 675 2 698 1 INV1S $T=246140 719160 1 0 $X=246140 $Y=713740
X415 665 2 689 1 INV1S $T=249860 769560 1 180 $X=248620 $Y=769180
X416 711 2 724 1 INV1S $T=256680 729240 1 0 $X=256680 $Y=723820
X417 744 2 18 1 INV1S $T=265980 759480 0 180 $X=264740 $Y=754060
X418 750 2 700 1 INV1S $T=269080 759480 1 180 $X=267840 $Y=759100
X419 32 2 20 1 INV1S $T=270940 749400 1 180 $X=269700 $Y=749020
X420 754 2 745 1 INV1S $T=272180 739320 1 180 $X=270940 $Y=738940
X421 757 2 19 1 INV1S $T=273420 759480 1 180 $X=272180 $Y=759100
X422 741 2 769 1 INV1S $T=272800 709080 1 0 $X=272800 $Y=703660
X423 24 2 740 1 INV1S $T=275900 749400 0 0 $X=275900 $Y=749020
X424 683 2 785 1 INV1S $T=282100 739320 1 0 $X=282100 $Y=733900
X425 789 2 773 1 INV1S $T=285820 678840 0 180 $X=284580 $Y=673420
X426 795 2 801 1 INV1S $T=287680 688920 0 0 $X=287680 $Y=688540
X427 813 2 811 1 INV1S $T=295120 668760 1 180 $X=293880 $Y=668380
X428 808 2 820 1 INV1S $T=293880 759480 0 0 $X=293880 $Y=759100
X429 818 2 790 1 INV1S $T=298220 688920 0 180 $X=296980 $Y=683500
X430 832 2 810 1 INV1S $T=300700 699000 0 180 $X=299460 $Y=693580
X431 838 2 821 1 INV1S $T=301320 709080 0 180 $X=300080 $Y=703660
X432 839 2 853 1 INV1S $T=313100 688920 1 180 $X=311860 $Y=688540
X433 862 2 871 1 INV1S $T=316820 739320 1 0 $X=316820 $Y=733900
X434 888 2 847 1 INV1S $T=323640 749400 1 180 $X=322400 $Y=749020
X435 869 2 904 1 INV1S $T=329220 709080 1 0 $X=329220 $Y=703660
X436 892 2 896 1 INV1S $T=331080 749400 1 180 $X=329840 $Y=749020
X437 917 2 890 1 INV1S $T=334800 749400 0 180 $X=333560 $Y=743980
X438 900 2 920 1 INV1S $T=336660 739320 0 0 $X=336660 $Y=738940
X439 921 2 924 1 INV1S $T=345960 759480 1 180 $X=344720 $Y=759100
X440 938 2 936 1 INV1S $T=345960 769560 1 180 $X=344720 $Y=769180
X441 955 2 940 1 INV1S $T=350920 759480 1 180 $X=349680 $Y=759100
X442 953 2 960 1 INV1S $T=353400 749400 0 0 $X=353400 $Y=749020
X443 969 2 984 1 INV1S $T=358360 709080 1 0 $X=358360 $Y=703660
X444 875 2 976 1 INV1S $T=358360 719160 1 0 $X=358360 $Y=713740
X445 972 2 983 1 INV1S $T=358980 699000 0 0 $X=358980 $Y=698620
X446 962 2 975 1 INV1S $T=359600 688920 0 0 $X=359600 $Y=688540
X447 1005 2 1009 1 INV1S $T=375100 719160 0 180 $X=373860 $Y=713740
X448 985 2 1028 1 INV1S $T=378820 719160 1 0 $X=378820 $Y=713740
X449 976 2 1034 1 INV1S $T=380060 719160 1 0 $X=380060 $Y=713740
X450 1042 2 1022 1 INV1S $T=386260 719160 1 180 $X=385020 $Y=718780
X451 865 2 102 1 INV1S $T=386880 668760 1 180 $X=385640 $Y=668380
X452 1053 2 1031 1 INV1S $T=389980 739320 1 180 $X=388740 $Y=738940
X453 1062 2 919 1 INV1S $T=389980 759480 1 180 $X=388740 $Y=759100
X454 1065 2 1046 1 INV1S $T=392460 749400 1 180 $X=391220 $Y=749020
X455 1063 2 982 1 INV1S $T=392460 769560 0 180 $X=391220 $Y=764140
X456 70 2 112 1 INV1S $T=391840 668760 1 0 $X=391840 $Y=663340
X457 1084 2 1081 1 INV1S $T=399280 749400 1 180 $X=398040 $Y=749020
X458 99 2 117 1 INV1S $T=401140 668760 0 180 $X=399900 $Y=663340
X459 1079 2 1106 1 INV1S $T=400520 759480 0 0 $X=400520 $Y=759100
X460 1051 2 1095 1 INV1S $T=401140 668760 1 0 $X=401140 $Y=663340
X461 1100 2 1094 1 INV1S $T=404860 769560 0 180 $X=403620 $Y=764140
X462 1108 2 1033 1 INV1S $T=407960 729240 0 0 $X=407960 $Y=728860
X463 1119 2 1118 1 INV1S $T=412300 739320 1 180 $X=411060 $Y=738940
X464 1114 2 1123 1 INV1S $T=412300 729240 0 0 $X=412300 $Y=728860
X465 1088 2 1130 1 INV1S $T=412920 769560 1 0 $X=412920 $Y=764140
X466 1051 2 1139 1 INV1S $T=419740 668760 1 180 $X=418500 $Y=668380
X467 64 2 138 1 INV1S $T=420980 658680 1 0 $X=420980 $Y=653260
X468 1052 2 1143 1 INV1S $T=420980 709080 0 0 $X=420980 $Y=708700
X469 1148 2 1149 1 INV1S $T=423460 759480 0 0 $X=423460 $Y=759100
X470 1074 2 1169 1 INV1S $T=427180 699000 1 0 $X=427180 $Y=693580
X471 143 2 157 1 INV1S $T=430280 688920 1 0 $X=430280 $Y=683500
X472 1172 2 1173 1 INV1S $T=431520 759480 1 180 $X=430280 $Y=759100
X473 1151 2 1189 1 INV1S $T=431520 668760 1 0 $X=431520 $Y=663340
X474 1169 2 1171 1 INV1S $T=433380 688920 1 0 $X=433380 $Y=683500
X475 1157 2 1187 1 INV1S $T=434000 769560 0 0 $X=434000 $Y=769180
X476 1184 2 1195 1 INV1S $T=435240 729240 1 0 $X=435240 $Y=723820
X477 1051 2 1186 1 INV1S $T=437100 668760 0 180 $X=435860 $Y=663340
X478 85 2 1197 1 INV1S $T=436480 678840 1 0 $X=436480 $Y=673420
X479 1165 2 1210 1 INV1S $T=439580 729240 0 0 $X=439580 $Y=728860
X480 1197 2 109 1 INV1S $T=441440 668760 0 0 $X=441440 $Y=668380
X481 1169 2 1226 1 INV1S $T=444540 688920 0 0 $X=444540 $Y=688540
X482 1200 2 1222 1 INV1S $T=444540 729240 1 0 $X=444540 $Y=723820
X483 70 2 1181 1 INV1S $T=447640 648600 0 0 $X=447640 $Y=648220
X484 1234 2 1244 1 INV1S $T=450740 668760 1 0 $X=450740 $Y=663340
X485 1247 2 1233 1 INV1S $T=454460 719160 1 0 $X=454460 $Y=713740
X486 121 2 1283 1 INV1S $T=463140 709080 1 0 $X=463140 $Y=703660
X487 91 2 183 1 INV1S $T=465000 699000 0 0 $X=465000 $Y=698620
X488 1271 2 1294 1 INV1S $T=465620 749400 1 0 $X=465620 $Y=743980
X489 1284 2 1286 1 INV1S $T=467480 668760 1 0 $X=467480 $Y=663340
X490 1283 2 1247 1 INV1S $T=467480 719160 1 0 $X=467480 $Y=713740
X491 1114 2 1293 1 INV1S $T=468100 719160 0 0 $X=468100 $Y=718780
X492 1197 2 1240 1 INV1S $T=470580 699000 1 180 $X=469340 $Y=698620
X493 1247 2 1299 1 INV1S $T=469340 719160 1 0 $X=469340 $Y=713740
X494 107 2 185 1 INV1S $T=470580 668760 1 0 $X=470580 $Y=663340
X495 1291 2 1305 1 INV1S $T=471200 749400 1 0 $X=471200 $Y=743980
X496 199 2 1285 1 INV1S $T=473060 678840 1 180 $X=471820 $Y=678460
X497 167 2 1311 1 INV1S $T=478020 719160 1 0 $X=478020 $Y=713740
X498 1336 2 1351 1 INV1S $T=486700 749400 0 0 $X=486700 $Y=749020
X499 1355 2 1347 1 INV1S $T=490420 749400 1 180 $X=489180 $Y=749020
X500 200 2 1131 1 INV1S $T=492900 749400 0 180 $X=491660 $Y=743980
X501 199 2 1335 1 INV1S $T=492280 699000 1 0 $X=492280 $Y=693580
X502 1366 2 1339 1 INV1S $T=494140 719160 0 180 $X=492900 $Y=713740
X503 209 2 166 1 INV1S $T=502200 658680 0 180 $X=500960 $Y=653260
X504 200 2 1386 1 INV1S $T=502820 688920 0 180 $X=501580 $Y=683500
X505 1403 2 1387 1 INV1S $T=502820 709080 0 180 $X=501580 $Y=703660
X506 1382 2 1406 1 INV1S $T=504060 709080 0 0 $X=504060 $Y=708700
X507 153 2 1044 1 INV1S $T=508400 688920 0 180 $X=507160 $Y=683500
X508 198 2 1103 1 INV1S $T=516460 668760 0 0 $X=516460 $Y=668380
X509 1456 2 1439 1 INV1S $T=520180 709080 1 180 $X=518940 $Y=708700
X510 1449 2 1459 1 INV1S $T=521420 759480 0 0 $X=521420 $Y=759100
X511 1366 2 1463 1 INV1S $T=522040 719160 1 0 $X=522040 $Y=713740
X512 186 2 1434 1 INV1S $T=526380 658680 1 180 $X=525140 $Y=658300
X513 1475 2 1472 1 INV1S $T=528240 739320 0 0 $X=528240 $Y=738940
X514 215 2 1482 1 INV1S $T=528860 709080 1 0 $X=528860 $Y=703660
X515 1485 2 1467 1 INV1S $T=530720 739320 1 180 $X=529480 $Y=738940
X516 200 2 1481 1 INV1S $T=530100 699000 0 0 $X=530100 $Y=698620
X517 1481 2 1384 1 INV1S $T=531340 699000 0 0 $X=531340 $Y=698620
X518 200 2 1495 1 INV1S $T=531960 739320 1 0 $X=531960 $Y=733900
X519 1366 2 1497 1 INV1S $T=533200 709080 1 0 $X=533200 $Y=703660
X520 1366 2 1500 1 INV1S $T=534440 719160 1 0 $X=534440 $Y=713740
X521 185 2 237 1 INV1S $T=541260 648600 1 180 $X=540020 $Y=648220
X522 1522 2 1523 1 INV1S $T=543120 699000 1 0 $X=543120 $Y=693580
X523 241 2 1263 1 INV1S $T=546220 658680 0 180 $X=544980 $Y=653260
X524 1542 2 1548 1 INV1S $T=545600 769560 1 0 $X=545600 $Y=764140
X525 209 2 1510 1 INV1S $T=548080 719160 0 180 $X=546840 $Y=713740
X526 1600 2 1531 1 INV1S $T=549940 699000 0 180 $X=548700 $Y=693580
X527 1550 2 1552 1 INV1S $T=548700 769560 1 0 $X=548700 $Y=764140
X528 1565 2 1521 1 INV1S $T=553040 769560 0 180 $X=551800 $Y=764140
X529 1555 2 236 1 INV1S $T=554280 688920 0 0 $X=554280 $Y=688540
X530 249 2 1560 1 INV1S $T=556140 658680 0 180 $X=554900 $Y=653260
X531 1573 2 1570 1 INV1S $T=556140 759480 0 180 $X=554900 $Y=754060
X532 1585 2 1581 1 INV1S $T=558620 688920 1 180 $X=557380 $Y=688540
X533 1578 2 254 1 INV1S $T=558000 709080 1 0 $X=558000 $Y=703660
X534 1597 2 1568 1 INV1S $T=561720 769560 1 180 $X=560480 $Y=769180
X535 1587 2 260 1 INV1S $T=561100 779640 1 0 $X=561100 $Y=774220
X536 246 2 1596 1 INV1S $T=563580 668760 1 180 $X=562340 $Y=668380
X537 1599 2 1611 1 INV1S $T=563580 668760 1 0 $X=563580 $Y=663340
X538 1604 2 263 1 INV1S $T=563580 769560 0 0 $X=563580 $Y=769180
X539 1612 2 261 1 INV1S $T=566680 779640 1 0 $X=566680 $Y=774220
X540 1434 2 1620 1 INV1S $T=568540 678840 0 0 $X=568540 $Y=678460
X541 1622 2 1636 1 INV1S $T=572260 668760 0 0 $X=572260 $Y=668380
X542 1602 2 1644 1 INV1S $T=572880 658680 0 0 $X=572880 $Y=658300
X543 1444 2 1638 1 INV1S $T=573500 729240 1 0 $X=573500 $Y=723820
X544 1638 2 1650 1 INV1S $T=575980 729240 1 0 $X=575980 $Y=723820
X545 1641 2 1669 1 INV1S $T=578460 648600 0 0 $X=578460 $Y=648220
X546 1670 2 279 1 INV1S $T=584040 769560 0 0 $X=584040 $Y=769180
X547 1480 2 1627 1 INV1S $T=586520 739320 0 0 $X=586520 $Y=738940
X548 1676 2 1693 1 INV1S $T=590240 749400 1 0 $X=590240 $Y=743980
X549 1698 2 1703 1 INV1S $T=593340 769560 0 0 $X=593340 $Y=769180
X550 1716 2 1699 1 INV1S $T=597680 759480 0 180 $X=596440 $Y=754060
X551 1726 2 1711 1 INV1S $T=603880 779640 0 180 $X=602640 $Y=774220
X552 1724 2 1748 1 INV1S $T=608220 759480 1 0 $X=608220 $Y=754060
X553 1751 2 296 1 INV1S $T=609460 769560 0 180 $X=608220 $Y=764140
X554 1735 2 298 1 INV1S $T=608220 769560 0 0 $X=608220 $Y=769180
X555 1744 2 295 1 INV1S $T=609460 779640 0 180 $X=608220 $Y=774220
X556 1747 2 1437 1 INV1S $T=610700 719160 1 0 $X=610700 $Y=713740
X557 307 2 1713 1 INV1S $T=617520 658680 0 180 $X=616280 $Y=653260
X558 1727 2 219 1 INV1S $T=620620 729240 0 0 $X=620620 $Y=728860
X559 1777 2 1775 1 INV1S $T=624960 678840 1 180 $X=623720 $Y=678460
X560 320 2 1782 1 INV1S $T=626820 769560 0 180 $X=625580 $Y=764140
X561 313 2 321 1 INV1S $T=626200 699000 1 0 $X=626200 $Y=693580
X562 318 2 1784 1 INV1S $T=627440 729240 0 0 $X=627440 $Y=728860
X563 1754 2 1800 1 INV1S $T=629300 719160 1 0 $X=629300 $Y=713740
X564 320 2 1789 1 INV1S $T=630540 769560 0 180 $X=629300 $Y=764140
X565 1766 2 1794 1 INV1S $T=630540 729240 0 0 $X=630540 $Y=728860
X566 309 2 1795 1 INV1S $T=631160 699000 1 0 $X=631160 $Y=693580
X567 330 2 289 1 INV1S $T=635500 648600 0 180 $X=634260 $Y=643180
X568 1798 2 1805 1 INV1S $T=634260 668760 0 0 $X=634260 $Y=668380
X569 326 2 1803 1 INV1S $T=634880 658680 0 0 $X=634880 $Y=658300
X570 331 2 335 1 INV1S $T=634880 759480 0 0 $X=634880 $Y=759100
X571 1783 2 1813 1 INV1S $T=636740 668760 1 0 $X=636740 $Y=663340
X572 1814 2 1816 1 INV1S $T=637360 688920 0 0 $X=637360 $Y=688540
X573 1618 2 1722 1 INV1S $T=637980 688920 1 0 $X=637980 $Y=683500
X574 323 2 336 1 INV1S $T=638600 658680 1 0 $X=638600 $Y=653260
X575 1825 2 1818 1 INV1S $T=640460 668760 1 0 $X=640460 $Y=663340
X576 1827 2 1841 1 INV1S $T=640460 759480 0 0 $X=640460 $Y=759100
X577 335 2 1778 1 INV1S $T=642940 769560 0 180 $X=641700 $Y=764140
X578 1830 2 1842 1 INV1S $T=642320 658680 1 0 $X=642320 $Y=653260
X579 1816 2 1825 1 INV1S $T=642320 668760 1 0 $X=642320 $Y=663340
X580 1811 2 1840 1 INV1S $T=643560 749400 1 0 $X=643560 $Y=743980
X581 1836 2 1653 1 INV1S $T=645420 699000 1 0 $X=645420 $Y=693580
X582 1837 2 1845 1 INV1S $T=646660 739320 0 0 $X=646660 $Y=738940
X583 1825 2 1854 1 INV1S $T=650380 668760 1 0 $X=650380 $Y=663340
X584 347 2 1872 1 INV1S $T=651000 658680 0 0 $X=651000 $Y=658300
X585 335 2 348 1 INV1S $T=651620 779640 1 0 $X=651620 $Y=774220
X586 1801 2 1877 1 INV1S $T=652240 759480 1 0 $X=652240 $Y=754060
X587 1834 2 1853 1 INV1S $T=653480 759480 1 180 $X=652240 $Y=759100
X588 1747 2 1876 1 INV1S $T=652860 729240 1 0 $X=652860 $Y=723820
X589 1769 2 347 1 INV1S $T=656580 688920 1 180 $X=655340 $Y=688540
X590 323 2 355 1 INV1S $T=658440 729240 0 0 $X=658440 $Y=728860
X591 324 2 1915 1 INV1S $T=661540 759480 0 0 $X=661540 $Y=759100
X592 1525 2 1913 1 INV1S $T=662160 688920 0 0 $X=662160 $Y=688540
X593 350 2 1909 1 INV1S $T=662160 779640 1 0 $X=662160 $Y=774220
X594 320 2 1930 1 INV1S $T=666500 769560 1 0 $X=666500 $Y=764140
X595 1591 2 1826 1 INV1S $T=667120 729240 0 0 $X=667120 $Y=728860
X596 1929 2 1938 1 INV1S $T=670220 658680 1 0 $X=670220 $Y=653260
X597 1907 2 1946 1 INV1S $T=673940 658680 1 0 $X=673940 $Y=653260
X598 291 2 1969 1 INV1S $T=682000 668760 1 0 $X=682000 $Y=663340
X599 372 2 1975 1 INV1S $T=685100 648600 0 0 $X=685100 $Y=648220
X600 1913 2 1980 1 INV1S $T=685720 699000 0 0 $X=685720 $Y=698620
X601 1808 2 1985 1 INV1S $T=688200 668760 0 0 $X=688200 $Y=668380
X602 1753 2 1832 1 INV1S $T=689440 719160 0 180 $X=688200 $Y=713740
X603 1787 2 2023 1 INV1S $T=697500 739320 1 0 $X=697500 $Y=733900
X604 390 2 363 1 INV1S $T=700600 779640 0 180 $X=699360 $Y=774220
X605 1956 2 2043 1 INV1S $T=703700 678840 1 0 $X=703700 $Y=673420
X606 2056 2 2047 1 INV1S $T=707420 739320 1 180 $X=706180 $Y=738940
X607 355 2 2028 1 INV1S $T=707420 749400 1 180 $X=706180 $Y=749020
X608 1787 2 2056 1 INV1S $T=708660 739320 1 0 $X=708660 $Y=733900
X609 2077 2 391 1 INV1S $T=709900 779640 0 180 $X=708660 $Y=774220
X610 2084 2 2072 1 INV1S $T=715480 709080 1 180 $X=714240 $Y=708700
X611 2086 2 2062 1 INV1S $T=716100 739320 1 180 $X=714860 $Y=738940
X612 362 2 312 1 INV1S $T=715480 769560 1 0 $X=715480 $Y=764140
X613 1956 2 2087 1 INV1S $T=721060 709080 1 180 $X=719820 $Y=708700
X614 1956 2 2089 1 INV1S $T=721060 699000 0 0 $X=721060 $Y=698620
X615 359 2 2099 1 INV1S $T=721060 739320 0 0 $X=721060 $Y=738940
X616 355 2 397 1 INV1S $T=722300 779640 0 180 $X=721060 $Y=774220
X617 377 2 399 1 INV1S $T=726020 769560 1 180 $X=724780 $Y=769180
X618 1988 2 2095 1 INV1S $T=727260 719160 1 180 $X=726020 $Y=718780
X619 2056 2 2103 1 INV1S $T=726640 739320 0 0 $X=726640 $Y=738940
X620 387 2 2111 1 INV1S $T=728500 759480 0 0 $X=728500 $Y=759100
X621 2105 2 2093 1 INV1S $T=729120 668760 0 0 $X=729120 $Y=668380
X622 2088 2 2115 1 INV1S $T=730360 668760 0 0 $X=730360 $Y=668380
X623 387 2 407 1 INV1S $T=733460 769560 1 180 $X=732220 $Y=769180
X624 2112 2 2128 1 INV1S $T=735320 668760 0 0 $X=735320 $Y=668380
X625 2126 2 2142 1 INV1S $T=735320 739320 0 0 $X=735320 $Y=738940
X626 2131 2 2137 1 INV1S $T=738420 668760 0 0 $X=738420 $Y=668380
X627 2144 2 2160 1 INV1S $T=742140 678840 1 0 $X=742140 $Y=673420
X628 2146 2 2148 1 INV1S $T=744620 739320 0 0 $X=744620 $Y=738940
X629 2161 2 2167 1 INV1S $T=750200 688920 1 0 $X=750200 $Y=683500
X630 2145 2 2186 1 INV1S $T=753300 688920 1 0 $X=753300 $Y=683500
X631 2139 2 2181 1 INV1S $T=754540 688920 0 0 $X=754540 $Y=688540
X632 2188 2 2194 1 INV1S $T=758880 688920 0 0 $X=758880 $Y=688540
X633 2056 2 2130 1 INV1S $T=758880 729240 0 0 $X=758880 $Y=728860
X634 2168 2 2221 1 INV1S $T=765080 699000 1 0 $X=765080 $Y=693580
X635 2056 2 2202 1 INV1S $T=765080 739320 1 0 $X=765080 $Y=733900
X636 2198 2 2207 1 INV1S $T=768800 739320 1 0 $X=768800 $Y=733900
X637 2058 2 2217 1 INV1S $T=771900 719160 1 0 $X=771900 $Y=713740
X638 2216 2 2214 1 INV1S $T=775000 699000 0 0 $X=775000 $Y=698620
X639 2203 2 2223 1 INV1S $T=775620 719160 0 0 $X=775620 $Y=718780
X640 439 2 2228 1 INV1S $T=778100 648600 1 0 $X=778100 $Y=643180
X641 441 2 2244 1 INV1S $T=783060 648600 1 0 $X=783060 $Y=643180
X642 2204 2 2243 1 INV1S $T=783060 699000 0 0 $X=783060 $Y=698620
X643 2241 2 2245 1 INV1S $T=783060 709080 1 0 $X=783060 $Y=703660
X644 2099 2 449 1 INV1S $T=787400 779640 1 0 $X=787400 $Y=774220
X645 2231 2 2259 1 INV1S $T=789260 709080 0 0 $X=789260 $Y=708700
X646 329 2 2022 1 INV1S $T=789260 759480 1 0 $X=789260 $Y=754060
X647 446 2 2257 1 INV1S $T=791740 688920 1 0 $X=791740 $Y=683500
X648 452 2 2276 1 INV1S $T=794840 688920 1 0 $X=794840 $Y=683500
X649 2262 2 2269 1 INV1S $T=794840 709080 0 0 $X=794840 $Y=708700
X650 2242 2 2288 1 INV1S $T=797940 719160 0 0 $X=797940 $Y=718780
X651 2271 2 2280 1 INV1S $T=801040 648600 0 0 $X=801040 $Y=648220
X652 2260 2 2287 1 INV1S $T=803520 719160 1 0 $X=803520 $Y=713740
X653 2282 2 2284 1 INV1S $T=804140 658680 0 0 $X=804140 $Y=658300
X654 2275 2 2292 1 INV1S $T=804140 678840 1 0 $X=804140 $Y=673420
X655 2270 2 2302 1 INV1S $T=806620 729240 1 0 $X=806620 $Y=723820
X656 2264 2 2297 1 INV1S $T=807240 719160 1 0 $X=807240 $Y=713740
X657 2294 2 2301 1 INV1S $T=809720 688920 0 0 $X=809720 $Y=688540
X658 2293 2 2303 1 INV1S $T=810960 688920 0 0 $X=810960 $Y=688540
X659 2307 2 2315 1 INV1S $T=815300 759480 0 0 $X=815300 $Y=759100
X660 2313 2 2317 1 INV1S $T=815920 668760 0 0 $X=815920 $Y=668380
X661 2320 2 2329 1 INV1S $T=821500 709080 0 0 $X=821500 $Y=708700
X662 2328 2 2331 1 INV1S $T=827080 739320 1 0 $X=827080 $Y=733900
X663 2333 2 2337 1 INV1S $T=827700 668760 0 0 $X=827700 $Y=668380
X664 2334 2 2335 1 INV1S $T=827700 709080 0 0 $X=827700 $Y=708700
X665 2327 2 2343 1 INV1S $T=827700 719160 0 0 $X=827700 $Y=718780
X666 492 2 494 1 INV1S $T=833900 648600 1 0 $X=833900 $Y=643180
X667 2150 2 492 1 INV1S $T=835140 648600 1 180 $X=833900 $Y=648220
X668 2354 2 2384 1 INV1S $T=839480 688920 1 0 $X=839480 $Y=683500
X669 489 2 2366 1 INV1S $T=839480 699000 0 0 $X=839480 $Y=698620
X670 499 2 2374 1 INV1S $T=839480 709080 1 0 $X=839480 $Y=703660
X671 2353 2 2360 1 INV1S $T=839480 759480 0 0 $X=839480 $Y=759100
X672 2361 2 2363 1 INV1S $T=841960 699000 1 0 $X=841960 $Y=693580
X673 2377 2 2385 1 INV1S $T=848160 709080 1 0 $X=848160 $Y=703660
X674 2338 2 2379 1 INV1S $T=848160 759480 0 0 $X=848160 $Y=759100
X675 513 2 2400 1 INV1S $T=854360 688920 0 0 $X=854360 $Y=688540
X676 2392 2 2404 1 INV1S $T=858700 749400 0 0 $X=858700 $Y=749020
X677 2383 2 2390 1 INV1S $T=859940 658680 1 0 $X=859940 $Y=653260
X678 2396 2 2410 1 INV1S $T=859940 719160 0 0 $X=859940 $Y=718780
X679 501 2 525 1 INV1S $T=866140 648600 1 0 $X=866140 $Y=643180
X680 529 2 2432 1 INV1S $T=869240 678840 1 0 $X=869240 $Y=673420
X681 530 2 2458 1 INV1S $T=869240 678840 0 0 $X=869240 $Y=678460
X682 517 2 2425 1 INV1S $T=869240 688920 1 0 $X=869240 $Y=683500
X683 2447 2 545 1 INV1S $T=885980 648600 1 180 $X=884740 $Y=648220
X684 2454 2 2452 1 INV1S $T=888460 769560 1 180 $X=887220 $Y=769180
X685 550 2 2482 1 INV1S $T=892180 699000 0 0 $X=892180 $Y=698620
X686 2472 2 551 1 INV1S $T=894040 658680 0 180 $X=892800 $Y=653260
X687 2483 2 549 1 INV1S $T=894660 648600 0 180 $X=893420 $Y=643180
X688 2471 2 2488 1 INV1S $T=893420 769560 0 0 $X=893420 $Y=769180
X689 2490 2 2494 1 INV1S $T=898380 769560 0 0 $X=898380 $Y=769180
X690 2510 2 2508 1 INV1S $T=907680 719160 0 180 $X=906440 $Y=713740
X691 2455 2 2519 1 INV1S $T=907060 668760 1 0 $X=907060 $Y=663340
X692 2514 2 2522 1 INV1S $T=908300 769560 1 0 $X=908300 $Y=764140
X693 2519 2 2497 1 INV1S $T=908920 668760 1 0 $X=908920 $Y=663340
X694 2502 2 2528 1 INV1S $T=908920 709080 1 0 $X=908920 $Y=703660
X695 564 2 2537 1 INV1S $T=912020 688920 0 0 $X=912020 $Y=688540
X696 2519 2 2536 1 INV1S $T=912640 668760 1 0 $X=912640 $Y=663340
X697 2539 2 2524 1 INV1S $T=914500 769560 0 180 $X=913260 $Y=764140
X698 2542 2 2558 1 INV1S $T=919460 769560 1 0 $X=919460 $Y=764140
X699 2563 2 2570 1 INV1S $T=925660 769560 1 0 $X=925660 $Y=764140
X700 2585 2 2561 1 INV1S $T=934340 648600 1 180 $X=933100 $Y=648220
X701 2582 2 2607 1 INV1S $T=934340 759480 0 0 $X=934340 $Y=759100
X702 588 2 2600 1 INV1S $T=940540 769560 0 0 $X=940540 $Y=769180
X703 2595 2 2579 1 INV1S $T=942400 729240 1 180 $X=941160 $Y=728860
X704 2603 2 2605 1 INV1S $T=943640 769560 0 0 $X=943640 $Y=769180
X705 2612 2 2597 1 INV1S $T=949220 729240 1 180 $X=947980 $Y=728860
X706 590 2 589 1 INV1S $T=953560 648600 0 180 $X=952320 $Y=643180
X707 2616 2 2608 1 INV1S $T=952320 769560 0 0 $X=952320 $Y=769180
X708 592 2 2621 1 INV1S $T=954800 779640 1 0 $X=954800 $Y=774220
X709 2629 2 2627 1 INV1S $T=958520 648600 1 180 $X=957280 $Y=648220
X710 2626 2 2615 1 INV1S $T=958520 739320 0 180 $X=957280 $Y=733900
X711 594 2 2635 1 INV1S $T=957900 769560 0 0 $X=957900 $Y=769180
X712 2613 2 2624 1 INV1S $T=959760 729240 1 180 $X=958520 $Y=728860
X713 2652 2 2630 1 INV1S $T=970920 719160 0 180 $X=969680 $Y=713740
X714 2645 2 2660 1 INV1S $T=974020 678840 1 0 $X=974020 $Y=673420
X715 2631 2 2654 1 INV1S $T=974640 688920 1 0 $X=974640 $Y=683500
X716 2662 2 2664 1 INV1S $T=975260 759480 0 0 $X=975260 $Y=759100
X717 604 2 2655 1 INV1S $T=975880 779640 1 0 $X=975880 $Y=774220
X718 2665 2 2658 1 INV1S $T=977740 739320 0 180 $X=976500 $Y=733900
X719 998 1024 2 978 991 1 1037 FA1 $T=368900 668760 0 0 $X=368900 $Y=668380
X720 1060 1027 2 1012 1037 1 1014 FA1 $T=389980 658680 1 180 $X=374480 $Y=658300
X721 1050 120 2 1075 1014 1 1102 FA1 $T=392460 658680 1 0 $X=392460 $Y=653260
X722 1091 1122 2 133 1102 1 1147 FA1 $T=403000 648600 0 0 $X=403000 $Y=648220
X723 1136 1176 2 1150 1111 1 1190 FA1 $T=420360 678840 1 0 $X=420360 $Y=673420
X724 1144 155 2 1146 1147 1 1193 FA1 $T=421600 648600 0 0 $X=421600 $Y=648220
X725 149 1159 2 1199 1117 1 1208 FA1 $T=426560 699000 0 0 $X=426560 $Y=698620
X726 1185 164 2 165 1193 1 1235 FA1 $T=434000 648600 1 0 $X=434000 $Y=643180
X727 1188 1220 2 1210 1183 1 1230 FA1 $T=434620 739320 0 0 $X=434620 $Y=738940
X728 1213 1244 2 1248 1190 1 1269 FA1 $T=442680 678840 1 0 $X=442680 $Y=673420
X729 163 1224 2 1256 1230 1 1261 FA1 $T=443300 769560 1 0 $X=443300 $Y=764140
X730 180 1238 2 1239 1261 1 1228 FA1 $T=461900 769560 1 180 $X=446400 $Y=769180
X731 169 1215 2 1216 1208 1 179 FA1 $T=447020 709080 1 0 $X=447020 $Y=703660
X732 1262 1289 2 1286 1269 1 1308 FA1 $T=458800 668760 0 0 $X=458800 $Y=668380
X733 181 1307 2 1282 1228 1 1328 FA1 $T=464380 769560 0 0 $X=464380 $Y=769180
X734 1292 1326 2 1333 1304 1 1344 FA1 $T=469960 688920 1 0 $X=469960 $Y=683500
X735 1349 1317 2 1319 1308 1 1304 FA1 $T=489800 678840 0 180 $X=474300 $Y=673420
X736 193 1345 2 1327 1328 1 1380 FA1 $T=481740 769560 0 0 $X=481740 $Y=769180
X737 196 203 2 1378 1344 1 1390 FA1 $T=486080 688920 1 0 $X=486080 $Y=683500
X738 204 1416 2 1365 1380 1 1427 FA1 $T=498480 769560 0 0 $X=498480 $Y=769180
X739 206 1420 2 1392 1427 1 1425 FA1 $T=499720 759480 0 0 $X=499720 $Y=759100
X740 210 1418 2 218 1390 1 1438 FA1 $T=502820 678840 0 0 $X=502820 $Y=678460
X741 221 1412 2 1410 1438 1 1398 FA1 $T=518940 678840 0 180 $X=503440 $Y=673420
X742 216 1445 2 1455 1398 1 1464 FA1 $T=510880 688920 1 0 $X=510880 $Y=683500
X743 225 1498 2 1468 1488 1 1527 FA1 $T=524520 759480 0 0 $X=524520 $Y=759100
X744 229 1502 2 1521 1527 1 1541 FA1 $T=528860 769560 1 0 $X=528860 $Y=764140
X745 242 1568 2 1570 1538 1 255 FA1 $T=543740 779640 1 0 $X=543740 $Y=774220
X746 253 1552 2 1548 1541 1 1538 FA1 $T=559860 769560 1 180 $X=544360 $Y=769180
X747 287 1669 2 1640 1685 1 1656 FA1 $T=595820 658680 1 180 $X=580320 $Y=658300
X748 276 1703 2 1711 285 1 293 FA1 $T=585900 779640 1 0 $X=585900 $Y=774220
X749 1755 1772 2 1712 1733 1 1799 FA1 $T=615040 678840 1 0 $X=615040 $Y=673420
X750 1780 1802 2 1756 1799 1 1822 FA1 $T=624960 678840 0 0 $X=624960 $Y=678460
X751 1865 1820 2 1813 1828 1 1808 FA1 $T=651000 668760 1 180 $X=635500 $Y=668380
X752 1894 1781 2 1805 1822 1 1828 FA1 $T=655960 678840 1 180 $X=640460 $Y=678460
X753 349 1910 2 1868 360 1 1921 FA1 $T=653480 648600 1 0 $X=653480 $Y=643180
X754 357 1937 2 1946 1961 1 1957 FA1 $T=665880 668760 1 0 $X=665880 $Y=663340
X755 358 1938 2 1912 1921 1 1961 FA1 $T=666500 648600 0 0 $X=666500 $Y=648220
X756 361 1939 2 1897 1932 1 1972 FA1 $T=669600 699000 0 0 $X=669600 $Y=698620
X757 374 1927 2 1931 1940 1 1932 FA1 $T=685720 699000 0 180 $X=670220 $Y=693580
X758 378 1951 2 1916 1957 1 1940 FA1 $T=688200 668760 1 180 $X=672700 $Y=668380
X759 380 1923 2 1899 1972 1 1942 FA1 $T=688820 729240 0 180 $X=673320 $Y=723820
X760 1949 1977 2 1900 1942 1 2041 FA1 $T=675800 769560 1 0 $X=675800 $Y=764140
X761 2036 2068 2 1983 2041 1 2081 FA1 $T=703080 759480 0 0 $X=703080 $Y=759100
X762 2067 2054 2 2093 2046 1 2107 FA1 $T=712380 668760 1 0 $X=712380 $Y=663340
X763 2071 2092 2 2045 2081 1 2104 FA1 $T=713620 749400 0 0 $X=713620 $Y=749020
X764 2106 2137 2 2115 2107 1 2152 FA1 $T=729120 668760 1 0 $X=729120 $Y=663340
X765 2116 2075 2 2148 2104 1 2162 FA1 $T=731600 749400 1 0 $X=731600 $Y=743980
X766 2182 2160 2 2128 2152 1 2147 FA1 $T=758880 668760 1 180 $X=743380 $Y=668380
X767 2154 2158 2 2182 1865 1 2193 FA1 $T=745860 668760 1 0 $X=745860 $Y=663340
X768 2158 2180 2 2142 2162 1 2198 FA1 $T=747100 739320 1 0 $X=747100 $Y=733900
X769 2165 2167 2 2186 2147 1 2201 FA1 $T=750820 678840 0 0 $X=750820 $Y=678460
X770 427 2185 2 2179 423 1 2171 FA1 $T=768800 648600 0 180 $X=753300 $Y=643180
X771 2227 2194 2 2181 2201 1 2187 FA1 $T=774380 688920 0 180 $X=758880 $Y=683500
X772 2199 2214 2 2221 2187 1 2234 FA1 $T=763840 688920 0 0 $X=763840 $Y=688540
X773 450 2237 2 2238 2171 1 2225 FA1 $T=792360 648600 1 180 $X=776860 $Y=648220
X774 2268 2245 2 2243 2234 1 2233 FA1 $T=796080 699000 0 180 $X=780580 $Y=693580
X775 444 2266 2 2256 2225 1 2274 FA1 $T=786780 658680 0 0 $X=786780 $Y=658300
X776 2254 2259 2 2269 2233 1 2279 FA1 $T=788640 699000 0 0 $X=788640 $Y=698620
X777 457 2292 2 2267 2274 1 2286 FA1 $T=798560 668760 0 0 $X=798560 $Y=668380
X778 2273 2297 2 2287 2279 1 2314 FA1 $T=799800 709080 0 0 $X=799800 $Y=708700
X779 463 2275 2 2301 2286 1 2322 FA1 $T=803520 678840 0 0 $X=803520 $Y=678460
X780 2281 2302 2 2277 2289 1 2328 FA1 $T=803520 739320 1 0 $X=803520 $Y=733900
X781 2306 2270 2 2288 2314 1 2289 FA1 $T=822740 719160 1 180 $X=807240 $Y=718780
X782 483 2294 2 2303 2322 1 2305 FA1 $T=827700 688920 1 180 $X=812200 $Y=688540
X783 476 2293 2 2329 2305 1 2346 FA1 $T=818400 699000 1 0 $X=818400 $Y=693580
X784 497 2320 2 2335 2346 1 2323 FA1 $T=838240 709080 0 180 $X=822740 $Y=703660
X785 486 2343 2 2334 2323 1 2370 FA1 $T=829560 719160 1 0 $X=829560 $Y=713740
X786 2393 2319 2 2360 2367 1 2352 FA1 $T=853120 769560 1 180 $X=837620 $Y=769180
X787 2356 2350 2 2379 2352 1 2392 FA1 $T=838240 759480 1 0 $X=838240 $Y=754060
X788 2417 2336 2 505 515 1 2367 FA1 $T=858700 779640 0 180 $X=843200 $Y=774220
X789 2395 531 2 2430 2402 1 2413 FA1 $T=859940 709080 1 0 $X=859940 $Y=703660
X790 2467 2416 2 2420 536 1 2406 FA1 $T=877300 759480 0 180 $X=861800 $Y=754060
X791 2469 2366 2 2439 2422 1 2424 FA1 $T=885980 719160 0 180 $X=870480 $Y=713740
X792 2429 2452 2 543 534 1 2464 FA1 $T=871720 769560 0 0 $X=871720 $Y=769180
X793 2411 2459 2 2442 2406 1 2474 FA1 $T=876060 739320 1 0 $X=876060 $Y=733900
X794 2475 2356 2 2463 554 1 2456 FA1 $T=898380 759480 1 180 $X=882880 $Y=759100
X795 2465 2458 2 2495 2443 1 2502 FA1 $T=887220 699000 1 0 $X=887220 $Y=693580
X796 2470 2473 2 2500 2474 1 2509 FA1 $T=889080 739320 0 0 $X=889080 $Y=738940
X797 2463 2494 2 2488 2464 1 2505 FA1 $T=889080 769560 1 0 $X=889080 $Y=764140
X798 2485 2512 2 2517 2509 1 2538 FA1 $T=896520 729240 0 0 $X=896520 $Y=728860
X799 2498 2524 2 2522 2505 1 2543 FA1 $T=901480 759480 0 0 $X=901480 $Y=759100
X800 2513 2541 2 2544 2538 1 2551 FA1 $T=906440 729240 1 0 $X=906440 $Y=723820
X801 2534 2400 2 2560 2533 1 2575 FA1 $T=913880 709080 1 0 $X=913880 $Y=703660
X802 2546 2570 2 2558 2543 1 2587 FA1 $T=918840 759480 0 0 $X=918840 $Y=759100
X803 2554 2579 2 2583 2551 1 2593 FA1 $T=922560 729240 1 0 $X=922560 $Y=723820
X804 2569 2595 2 2597 2593 1 2601 FA1 $T=928760 719160 0 0 $X=928760 $Y=718780
X805 2577 2608 2 2607 2587 1 2614 FA1 $T=938680 769560 1 0 $X=938680 $Y=764140
X806 2596 2612 2 2615 2601 1 2628 FA1 $T=939920 729240 1 0 $X=939920 $Y=723820
X807 2604 2537 2 2623 2580 1 2619 FA1 $T=944260 699000 1 0 $X=944260 $Y=693580
X808 2606 2613 2 2630 2609 1 2643 FA1 $T=946740 709080 0 0 $X=946740 $Y=708700
X809 2599 595 2 2605 2614 1 2646 FA1 $T=948600 759480 1 0 $X=948600 $Y=754060
X810 2656 2626 2 2624 2628 1 2609 FA1 $T=967820 719160 1 180 $X=952320 $Y=718780
X811 2618 599 2 2635 2646 1 2651 FA1 $T=956040 769560 1 0 $X=956040 $Y=764140
X812 2634 596 2 2621 2651 1 593 FA1 $T=972160 779640 0 180 $X=956660 $Y=774220
X813 2637 2655 2 603 606 1 2662 FA1 $T=961620 769560 0 0 $X=961620 $Y=769180
X814 2639 2658 2 2652 2643 1 2653 FA1 $T=962860 729240 1 0 $X=962860 $Y=723820
X815 10 2 668 664 662 1 644 FA1S $T=236220 759480 0 180 $X=224440 $Y=754060
X816 682 2 721 686 681 1 666 FA1S $T=246140 739320 0 180 $X=234360 $Y=733900
X817 662 2 695 688 682 1 715 FA1S $T=242420 759480 1 0 $X=242420 $Y=754060
X818 910 2 922 902 894 1 926 FA1S $T=330460 699000 0 0 $X=330460 $Y=698620
X819 947 2 939 937 910 1 961 FA1S $T=344720 699000 0 0 $X=344720 $Y=698620
X820 962 2 950 957 952 1 972 FA1S $T=350300 688920 1 0 $X=350300 $Y=683500
X821 977 2 1011 954 87 1 956 FA1S $T=365800 648600 1 180 $X=354020 $Y=648220
X822 970 2 951 966 968 1 990 FA1S $T=355260 668760 0 0 $X=355260 $Y=668380
X823 978 2 83 970 956 1 995 FA1S $T=356500 658680 0 0 $X=356500 $Y=658300
X824 88 2 1004 999 989 1 967 FA1S $T=368900 658680 0 180 $X=357120 $Y=653260
X825 991 2 997 995 994 1 971 FA1S $T=370140 678840 1 180 $X=358360 $Y=678460
X826 997 2 990 1008 967 1 980 FA1S $T=373240 678840 0 180 $X=361460 $Y=673420
X827 992 2 1006 983 947 1 993 FA1S $T=361460 699000 1 0 $X=361460 $Y=693580
X828 994 2 975 980 992 1 1013 FA1S $T=363320 688920 0 0 $X=363320 $Y=688540
X829 1012 2 89 1007 93 1 1024 FA1S $T=368900 648600 1 0 $X=368900 $Y=643180
X830 1008 2 1032 1038 1036 1 1006 FA1S $T=386260 688920 0 180 $X=374480 $Y=683500
X831 1030 2 1060 1061 1035 1 1026 FA1S $T=391220 699000 1 180 $X=379440 $Y=698620
X832 1056 2 1072 110 977 1 1007 FA1S $T=396180 648600 0 180 $X=384400 $Y=643180
X833 1075 2 118 113 1056 1 1027 FA1S $T=401140 648600 1 180 $X=389360 $Y=648220
X834 1086 2 1089 1070 1080 1 1064 FA1S $T=404860 699000 1 180 $X=393080 $Y=698620
X835 1080 2 1073 1071 1067 1 123 FA1S $T=393700 709080 0 0 $X=393700 $Y=708700
X836 125 2 130 128 126 1 1072 FA1S $T=411060 648600 0 180 $X=399280 $Y=643180
X837 1111 2 1066 1101 1128 1 1137 FA1S $T=404860 668760 0 0 $X=404860 $Y=668380
X838 1117 2 1116 1099 1086 1 139 FA1S $T=406720 699000 0 0 $X=406720 $Y=698620
X839 1140 2 1059 1160 1121 1 1113 FA1S $T=423460 719160 1 180 $X=411680 $Y=718780
X840 1146 2 150 137 147 1 1122 FA1S $T=426560 648600 0 180 $X=414780 $Y=643180
X841 1165 2 1161 1180 1145 1 1184 FA1S $T=422220 739320 1 0 $X=422220 $Y=733900
X842 1179 2 1191 1163 1140 1 1156 FA1S $T=436480 719160 1 180 $X=424700 $Y=718780
X843 1183 2 1194 1195 1179 1 1153 FA1S $T=427800 719160 1 0 $X=427800 $Y=713740
X844 1239 2 1257 1265 1249 1 1224 FA1S $T=457560 759480 1 180 $X=445780 $Y=759100
X845 1241 2 1225 1229 1245 1 1249 FA1S $T=447640 749400 0 0 $X=447640 $Y=749020
X846 1250 2 1236 1231 1232 1 1248 FA1S $T=450120 658680 0 0 $X=450120 $Y=658300
X847 1256 2 1259 1272 1253 1 1220 FA1S $T=462520 739320 1 180 $X=450740 $Y=738940
X848 1254 2 172 170 1235 1 1258 FA1S $T=451360 648600 1 0 $X=451360 $Y=643180
X849 1257 2 1223 1196 1252 1 1272 FA1S $T=451360 749400 1 0 $X=451360 $Y=743980
X850 1259 2 1246 1242 1267 1 1194 FA1S $T=453840 709080 0 0 $X=453840 $Y=708700
X851 1268 2 1260 1288 1274 1 1253 FA1S $T=466860 729240 0 180 $X=455080 $Y=723820
X852 1280 2 1287 1209 1268 1 1265 FA1S $T=470580 759480 1 180 $X=458800 $Y=759100
X853 1282 2 1302 1306 1280 1 1238 FA1S $T=471820 769560 0 180 $X=460040 $Y=764140
X854 1278 2 1295 1294 1241 1 1306 FA1S $T=460660 749400 0 0 $X=460660 $Y=749020
X855 1291 2 1276 1275 1297 1 1271 FA1S $T=473680 739320 0 180 $X=461900 $Y=733900
X856 1284 2 1273 1214 1281 1 1234 FA1S $T=463140 658680 0 0 $X=463140 $Y=658300
X857 1318 2 1298 1301 1314 1 1287 FA1S $T=481740 729240 0 180 $X=469960 $Y=723820
X858 1313 2 1309 1296 1316 1 1295 FA1S $T=471200 709080 0 0 $X=471200 $Y=708700
X859 1319 2 1250 1348 1325 1 1289 FA1S $T=483600 668760 0 180 $X=471820 $Y=663340
X860 1322 2 1324 1212 1318 1 1302 FA1S $T=483600 759480 1 180 $X=471820 $Y=759100
X861 1327 2 1340 1342 1278 1 1307 FA1S $T=484840 769560 0 180 $X=473060 $Y=764140
X862 1321 2 1305 1338 1313 1 1342 FA1S $T=474300 749400 0 0 $X=474300 $Y=749020
X863 1329 2 1315 1303 1323 1 1348 FA1S $T=476160 658680 1 0 $X=476160 $Y=653260
X864 1333 2 1329 1358 1332 1 1317 FA1S $T=488560 668760 1 180 $X=476780 $Y=668380
X865 1336 2 1320 1310 1331 1 1355 FA1S $T=478640 749400 1 0 $X=478640 $Y=743980
X866 197 2 191 201 1363 1 1332 FA1S $T=496000 648600 0 180 $X=484220 $Y=643180
X867 1359 2 1346 1377 1364 1 1325 FA1S $T=496620 658680 1 180 $X=484840 $Y=658300
X868 1360 2 1376 1347 1322 1 1340 FA1S $T=496620 759480 0 180 $X=484840 $Y=754060
X869 1365 2 1394 1372 1360 1 1345 FA1S $T=497860 769560 0 180 $X=486080 $Y=764140
X870 1357 2 1373 1353 1362 1 1376 FA1S $T=486700 709080 0 0 $X=486700 $Y=708700
X871 1370 2 1385 1389 1354 1 1352 FA1S $T=500340 729240 0 180 $X=488560 $Y=723820
X872 1368 2 1351 1387 1321 1 1394 FA1S $T=490420 749400 0 0 $X=490420 $Y=749020
X873 1381 2 1431 1401 1359 1 1358 FA1S $T=502820 668760 1 180 $X=491040 $Y=668380
X874 1378 2 1367 207 1381 1 1326 FA1S $T=502820 678840 0 180 $X=491040 $Y=673420
X875 1374 2 1352 1330 1357 1 1372 FA1S $T=491660 739320 1 0 $X=491660 $Y=733900
X876 1382 2 1361 1356 1375 1 1403 FA1S $T=493520 699000 0 0 $X=493520 $Y=698620
X877 1395 2 233 1404 1402 1 1367 FA1S $T=507780 648600 1 180 $X=496000 $Y=648220
X878 1392 2 1408 1400 1368 1 1416 FA1S $T=497240 759480 1 0 $X=497240 $Y=754060
X879 1396 2 1393 1371 1370 1 1408 FA1S $T=498480 739320 0 0 $X=498480 $Y=738940
X880 1421 2 1432 1426 1413 1 1399 FA1S $T=515220 729240 0 180 $X=503440 $Y=723820
X881 1422 2 1430 1406 1374 1 1400 FA1S $T=515220 739320 0 180 $X=503440 $Y=733900
X882 1413 2 1405 1391 1397 1 1430 FA1S $T=504060 719160 1 0 $X=504060 $Y=713740
X883 1415 2 1396 1399 1422 1 1420 FA1S $T=504060 749400 0 0 $X=504060 $Y=749020
X884 1424 2 1388 1411 1417 1 1432 FA1S $T=506540 699000 1 0 $X=506540 $Y=693580
X885 1402 2 1419 1409 1423 1 1431 FA1S $T=507780 668760 1 0 $X=507780 $Y=663340
X886 1433 2 1446 220 1395 1 214 FA1S $T=520800 648600 0 180 $X=509020 $Y=643180
X887 1410 2 226 1461 1433 1 1418 FA1S $T=520800 658680 0 180 $X=509020 $Y=653260
X888 1441 2 1415 1458 1425 1 217 FA1S $T=522660 759480 0 180 $X=510880 $Y=754060
X889 1436 2 1429 1428 1473 1 1456 FA1S $T=515220 709080 1 0 $X=515220 $Y=703660
X890 222 2 1459 1435 1451 1 227 FA1S $T=515220 769560 1 0 $X=515220 $Y=764140
X891 1449 2 1436 1440 1414 1 1475 FA1S $T=516460 739320 0 0 $X=516460 $Y=738940
X892 1447 2 1424 1439 1421 1 1458 FA1S $T=517080 719160 0 0 $X=517080 $Y=718780
X893 1451 2 1472 1447 1441 1 230 FA1S $T=517700 749400 1 0 $X=517700 $Y=743980
X894 1465 2 1466 1471 1464 1 1443 FA1S $T=530720 699000 0 180 $X=518940 $Y=693580
X895 1466 2 1483 1490 1477 1 1445 FA1S $T=531340 678840 1 180 $X=519560 $Y=678460
X896 1455 2 1491 1504 223 1 1412 FA1S $T=532580 678840 0 180 $X=520800 $Y=673420
X897 1479 2 1460 232 1474 1 1446 FA1S $T=534440 648600 0 180 $X=522660 $Y=643180
X898 1486 2 1499 235 1479 1 1461 FA1S $T=536300 658680 0 180 $X=524520 $Y=653260
X899 1477 2 1470 234 1486 1 1504 FA1S $T=525140 668760 1 0 $X=525140 $Y=663340
X900 1492 2 1517 1523 1505 1 1471 FA1S $T=538780 688920 0 180 $X=527000 $Y=683500
X901 1493 2 1511 1516 1503 1 1470 FA1S $T=539400 658680 1 180 $X=527620 $Y=658300
X902 1512 2 1531 1492 1465 1 1487 FA1S $T=543120 699000 0 180 $X=531340 $Y=693580
X903 1505 2 1494 1530 1493 1 1490 FA1S $T=544360 678840 1 180 $X=532580 $Y=678460
X904 1517 2 1532 1545 1528 1 1494 FA1S $T=545600 668760 1 180 $X=533820 $Y=668380
X905 1549 2 1537 1561 1526 1 1522 FA1S $T=552420 688920 0 180 $X=540640 $Y=683500
X906 1542 2 1520 1518 1529 1 1565 FA1S $T=541260 759480 1 0 $X=541260 $Y=754060
X907 1554 2 1533 1544 1562 1 1499 FA1S $T=545600 658680 0 0 $X=545600 $Y=658300
X908 1573 2 1601 1582 1559 1 1550 FA1S $T=561100 749400 1 180 $X=549320 $Y=749020
X909 1483 2 1553 1563 1554 1 1491 FA1S $T=549940 668760 0 0 $X=549940 $Y=668380
X910 1578 2 1581 1590 1512 1 247 FA1S $T=562340 699000 1 180 $X=550560 $Y=698620
X911 1585 2 1549 1574 1569 1 1600 FA1S $T=554900 688920 1 0 $X=554900 $Y=683500
X912 1587 2 1579 1576 1593 1 1597 FA1S $T=555520 769560 1 0 $X=555520 $Y=764140
X913 1605 2 1624 1614 1615 1 1576 FA1S $T=569160 759480 0 180 $X=557380 $Y=754060
X914 1599 2 1589 1586 1595 1 1641 FA1S $T=558620 658680 1 0 $X=558620 $Y=653260
X915 1622 2 1643 1632 265 1 1602 FA1S $T=575360 648600 1 180 $X=563580 $Y=648220
X916 1628 2 1611 1644 262 1 1654 FA1S $T=567300 668760 1 0 $X=567300 $Y=663340
X917 1612 2 1617 1605 1659 1 1604 FA1S $T=567300 769560 1 0 $X=567300 $Y=764140
X918 1637 2 1625 266 1661 1 1660 FA1S $T=569780 678840 0 0 $X=569780 $Y=678460
X919 1647 2 1662 1655 1648 1 1625 FA1S $T=582180 688920 0 180 $X=570400 $Y=683500
X920 1629 2 1619 1639 1635 1 1659 FA1S $T=570400 759480 1 0 $X=570400 $Y=754060
X921 269 2 1672 1629 1651 1 264 FA1S $T=582180 759480 1 180 $X=570400 $Y=759100
X922 1661 2 1683 1668 1671 1 1640 FA1S $T=587140 668760 1 180 $X=575360 $Y=668380
X923 1664 2 1652 1679 1649 1 1651 FA1S $T=579080 719160 0 0 $X=579080 $Y=718780
X924 1670 2 1663 1664 1681 1 271 FA1S $T=592100 769560 0 180 $X=580320 $Y=764140
X925 1680 2 1666 1636 1637 1 1700 FA1S $T=582800 678840 0 0 $X=582800 $Y=678460
X926 1685 2 1631 283 1691 1 275 FA1S $T=595200 648600 1 180 $X=583420 $Y=648220
X927 1687 2 1696 1705 1694 1 1666 FA1S $T=595820 688920 0 180 $X=584040 $Y=683500
X928 1682 2 1654 1660 1656 1 1704 FA1S $T=584660 668760 1 0 $X=584660 $Y=663340
X929 1695 2 1716 1684 1697 1 1681 FA1S $T=599540 749400 1 180 $X=587760 $Y=749020
X930 1708 2 1699 1690 1701 1 1730 FA1S $T=592720 759480 0 0 $X=592720 $Y=759100
X931 1712 2 1709 1700 1628 1 1741 FA1S $T=593960 668760 0 0 $X=593960 $Y=668380
X932 1698 2 1730 1739 1695 1 284 FA1S $T=606360 769560 0 180 $X=594580 $Y=764140
X933 1719 2 290 1704 292 1 299 FA1S $T=597060 648600 1 0 $X=597060 $Y=643180
X934 1723 2 1732 1738 1706 1 1746 FA1S $T=597680 699000 1 0 $X=597680 $Y=693580
X935 1734 2 1742 1740 1647 1 1709 FA1S $T=610080 678840 1 180 $X=598300 $Y=678460
X936 1691 2 1717 1743 1720 1 302 FA1S $T=600160 648600 0 0 $X=600160 $Y=648220
X937 1733 2 1682 1741 1719 1 1749 FA1S $T=600780 668760 1 0 $X=600780 $Y=663340
X938 1735 2 1724 1721 1736 1 1744 FA1S $T=600780 749400 0 0 $X=600780 $Y=749020
X939 1751 2 1748 1718 1708 1 1726 FA1S $T=609460 759480 0 0 $X=609460 $Y=759100
X940 1756 2 1734 1764 1680 1 1772 FA1S $T=610700 678840 0 0 $X=610700 $Y=678460
X941 1757 2 1746 1750 1687 1 1764 FA1S $T=611320 688920 0 0 $X=611320 $Y=688540
X942 1766 2 1773 1786 1771 1 1754 FA1S $T=625580 719160 0 180 $X=613800 $Y=713740
X943 1779 2 1758 1770 1774 1 1777 FA1S $T=620620 658680 0 0 $X=620620 $Y=658300
X944 1781 2 1723 1775 1757 1 1802 FA1S $T=621240 688920 1 0 $X=621240 $Y=683500
X945 1783 2 1779 1768 1761 1 1798 FA1S $T=621860 668760 1 0 $X=621860 $Y=663340
X946 1801 2 1792 1788 1806 1 1827 FA1S $T=629920 749400 0 0 $X=629920 $Y=749020
X947 1811 2 1824 1797 1791 1 1837 FA1S $T=632400 739320 1 0 $X=632400 $Y=733900
X948 1831 2 1810 1843 1844 1 1857 FA1S $T=637360 709080 1 0 $X=637360 $Y=703660
X949 1835 2 1851 1815 1812 1 1861 FA1S $T=638600 719160 0 0 $X=638600 $Y=718780
X950 1844 2 1839 1860 1833 1 1881 FA1S $T=642320 699000 0 0 $X=642320 $Y=698620
X951 1850 2 1861 1800 1873 1 1871 FA1S $T=643560 719160 1 0 $X=643560 $Y=713740
X952 1852 2 1840 1841 1855 1 1880 FA1S $T=643560 749400 0 0 $X=643560 $Y=749020
X953 1855 2 1794 1817 1835 1 1883 FA1S $T=644180 739320 1 0 $X=644180 $Y=733900
X954 1863 2 1885 1845 1831 1 1889 FA1S $T=646660 749400 1 0 $X=646660 $Y=743980
X955 1869 2 1867 1856 1874 1 1906 FA1S $T=647900 688920 1 0 $X=647900 $Y=683500
X956 1888 2 1886 1859 1879 1 1912 FA1S $T=652860 668760 1 0 $X=652860 $Y=663340
X957 1905 2 1920 1821 1914 1 1884 FA1S $T=667120 759480 0 180 $X=655340 $Y=754060
X958 1897 2 1857 1871 1903 1 1927 FA1S $T=655960 699000 0 0 $X=655960 $Y=698620
X959 1899 2 1889 1883 1850 1 1939 FA1S $T=656580 729240 1 0 $X=656580 $Y=723820
X960 1900 2 1880 1884 1863 1 1923 FA1S $T=656580 749400 0 0 $X=656580 $Y=749020
X961 1907 2 1922 1848 1891 1 1929 FA1S $T=658440 658680 1 0 $X=658440 $Y=653260
X962 1903 2 1881 1887 1869 1 1924 FA1S $T=658440 699000 1 0 $X=658440 $Y=693580
X963 1916 2 1888 1901 1906 1 1937 FA1S $T=660920 668760 0 0 $X=660920 $Y=668380
X964 1914 2 1893 1902 1911 1 1885 FA1S $T=660920 749400 1 0 $X=660920 $Y=743980
X965 1928 2 1941 1945 1917 1 1901 FA1S $T=673940 678840 1 180 $X=662160 $Y=678460
X966 1873 2 1950 1934 1925 1 1908 FA1S $T=674560 719160 0 180 $X=662780 $Y=713740
X967 1931 2 1928 1924 1908 1 1951 FA1S $T=665880 688920 0 0 $X=665880 $Y=688540
X968 1943 2 1948 1877 1905 1 1963 FA1S $T=668980 759480 1 0 $X=668980 $Y=754060
X969 1944 2 1918 1954 1933 1 1920 FA1S $T=669600 749400 0 0 $X=669600 $Y=749020
X970 1966 2 1974 1952 1958 1 1948 FA1S $T=686960 749400 0 180 $X=675180 $Y=743980
X971 1986 2 1999 2025 1944 1 1967 FA1S $T=695020 749400 1 180 $X=683240 $Y=749020
X972 1983 2 1967 1963 1852 1 1977 FA1S $T=683240 759480 1 0 $X=683240 $Y=754060
X973 1992 2 2007 1949 1749 1 2029 FA1S $T=688820 648600 0 0 $X=688820 $Y=648220
X974 2012 2 1998 1991 2008 1 2039 FA1S $T=692540 729240 0 0 $X=692540 $Y=728860
X975 2018 2 2039 2006 1966 1 2033 FA1S $T=694400 739320 0 0 $X=694400 $Y=738940
X976 2045 2 1986 2033 1943 1 2068 FA1S $T=700600 759480 1 0 $X=700600 $Y=754060
X977 2046 2 2001 2053 2042 1 2063 FA1S $T=701220 658680 1 0 $X=701220 $Y=653260
X978 2049 2 2063 2036 1755 1 2082 FA1S $T=702460 648600 0 0 $X=702460 $Y=648220
X979 2075 2 2012 2062 2018 1 2092 FA1S $T=709900 749400 1 0 $X=709900 $Y=743980
X980 2079 2 2070 1981 2073 1 2090 FA1S $T=711140 688920 0 0 $X=711140 $Y=688540
X981 2080 2 2051 2060 2074 1 2086 FA1S $T=711140 739320 1 0 $X=711140 $Y=733900
X982 2085 2 2067 2071 1780 1 2109 FA1S $T=714860 658680 1 0 $X=714860 $Y=653260
X983 2088 2 2096 2004 2083 1 2105 FA1S $T=717340 668760 0 0 $X=717340 $Y=668380
X984 2112 2 2098 2100 2114 1 2131 FA1S $T=726020 678840 0 0 $X=726020 $Y=678460
X985 2124 2 2106 2116 1894 1 2151 FA1S $T=730360 658680 1 0 $X=730360 $Y=653260
X986 2126 2 2080 2110 2118 1 2146 FA1S $T=731600 739320 1 0 $X=731600 $Y=733900
X987 2134 2 2076 2125 2129 1 2155 FA1S $T=734080 699000 1 0 $X=734080 $Y=693580
X988 2139 2 2120 2079 2155 1 2161 FA1S $T=735940 688920 0 0 $X=735940 $Y=688540
X989 2145 2 2102 2090 2141 1 2144 FA1S $T=738420 678840 0 0 $X=738420 $Y=678460
X990 2156 2 2149 2021 2122 1 2172 FA1S $T=742140 699000 0 0 $X=742140 $Y=698620
X991 2168 2 2176 2134 2172 1 2188 FA1S $T=747720 699000 1 0 $X=747720 $Y=693580
X992 2204 2 2177 2156 2211 1 2216 FA1S $T=762600 699000 0 0 $X=762600 $Y=698620
X993 2205 2 2058 2196 2197 1 2211 FA1S $T=763220 709080 1 0 $X=763220 $Y=703660
X994 2231 2 2247 2050 2205 1 2241 FA1S $T=775620 709080 0 0 $X=775620 $Y=708700
X995 2232 2 2217 2212 2224 1 2247 FA1S $T=775620 719160 1 0 $X=775620 $Y=713740
X996 2242 2 2203 2235 2213 1 2264 FA1S $T=778720 719160 0 0 $X=778720 $Y=718780
X997 2260 2 2223 2255 2232 1 2262 FA1S $T=789260 719160 1 0 $X=789260 $Y=713740
X998 2278 2 460 2290 2272 1 2307 FA1S $T=797940 769560 1 0 $X=797940 $Y=764140
X999 2318 2 2300 468 479 1 482 FA1S $T=814680 779640 1 0 $X=814680 $Y=774220
X1000 2319 2 2318 2315 475 1 2336 FA1S $T=815300 769560 0 0 $X=815300 $Y=769180
X1001 2338 2 2278 2348 2296 1 2353 FA1S $T=826460 759480 0 0 $X=826460 $Y=759100
X1002 2427 2 541 2417 532 1 2399 FA1S $T=876060 779640 0 180 $X=864280 $Y=774220
X1003 2445 2 2429 2393 538 1 2418 FA1S $T=882880 769560 0 180 $X=871100 $Y=764140
X1004 2440 2 2444 2257 2424 1 2457 FA1S $T=872340 699000 0 0 $X=872340 $Y=698620
X1005 2443 2 2435 2276 2440 1 2434 FA1S $T=872960 699000 1 0 $X=872960 $Y=693580
X1006 2471 2 553 552 547 1 2454 FA1S $T=894040 779640 0 180 $X=882260 $Y=774220
X1007 2514 2 561 562 559 1 2490 FA1S $T=911400 769560 1 180 $X=899620 $Y=769180
X1008 2533 2 2523 2425 2530 1 2548 FA1S $T=909540 699000 1 0 $X=909540 $Y=693580
X1009 2542 2 2532 569 575 1 2539 FA1S $T=912640 769560 0 0 $X=912640 $Y=769180
X1010 2580 2 2578 2432 2575 1 2590 FA1S $T=928140 699000 1 0 $X=928140 $Y=693580
X1011 2582 2 2567 580 586 1 2563 FA1S $T=928140 769560 0 0 $X=928140 $Y=769180
X1012 2603 2 2564 587 591 1 2616 FA1S $T=941160 779640 1 0 $X=941160 $Y=774220
X1013 2638 2 2649 2244 2644 1 2622 FA1S $T=967820 678840 0 180 $X=956040 $Y=673420
X1014 2650 2 2640 597 2638 1 2659 FA1S $T=963480 668760 1 0 $X=963480 $Y=663340
X1015 2629 2 2660 602 2650 1 2633 FA1S $T=975880 648600 1 180 $X=964100 $Y=648220
X1016 687 2 681 684 1 NR2 $T=243660 729240 0 0 $X=243660 $Y=728860
X1017 17 2 685 700 1 NR2 $T=250480 769560 0 180 $X=248620 $Y=764140
X1018 704 2 684 713 1 NR2 $T=251100 729240 1 0 $X=251100 $Y=723820
X1019 18 2 693 20 1 NR2 $T=251100 779640 1 0 $X=251100 $Y=774220
X1020 19 2 703 20 1 NR2 $T=251720 749400 0 0 $X=251720 $Y=749020
X1021 726 2 694 655 1 NR2 $T=256680 749400 0 180 $X=254820 $Y=743980
X1022 19 2 723 700 1 NR2 $T=255440 759480 0 0 $X=255440 $Y=759100
X1023 24 2 732 20 1 NR2 $T=260400 749400 1 0 $X=260400 $Y=743980
X1024 28 2 27 20 1 NR2 $T=265360 779640 0 180 $X=263500 $Y=774220
X1025 18 2 701 745 1 NR2 $T=264120 749400 0 0 $X=264120 $Y=749020
X1026 24 2 746 745 1 NR2 $T=268460 739320 1 180 $X=266600 $Y=738940
X1027 665 2 31 33 1 NR2 $T=269080 779640 1 0 $X=269080 $Y=774220
X1028 758 2 646 31 1 NR2 $T=271560 769560 0 180 $X=269700 $Y=764140
X1029 776 2 760 769 1 NR2 $T=280240 719160 0 180 $X=278380 $Y=713740
X1030 795 2 818 813 1 NR2 $T=293260 678840 1 0 $X=293260 $Y=673420
X1031 822 2 787 785 1 NR2 $T=298220 739320 0 180 $X=296360 $Y=733900
X1032 823 2 838 839 1 NR2 $T=305040 699000 1 0 $X=305040 $Y=693580
X1033 867 2 795 865 1 NR2 $T=316820 688920 0 0 $X=316820 $Y=688540
X1034 882 2 894 886 1 NR2 $T=323020 699000 1 0 $X=323020 $Y=693580
X1035 900 2 866 890 1 NR2 $T=325500 729240 1 180 $X=323640 $Y=728860
X1036 921 2 905 892 1 NR2 $T=334800 759480 0 180 $X=332940 $Y=754060
X1037 901 2 909 903 1 NR2 $T=334800 688920 1 0 $X=334800 $Y=683500
X1038 912 2 892 919 1 NR2 $T=335420 749400 0 0 $X=335420 $Y=749020
X1039 916 2 933 934 1 NR2 $T=340380 678840 0 0 $X=340380 $Y=678460
X1040 909 2 952 933 1 NR2 $T=340380 688920 1 0 $X=340380 $Y=683500
X1041 920 2 879 917 1 NR2 $T=340380 749400 1 0 $X=340380 $Y=743980
X1042 953 2 921 940 1 NR2 $T=349680 759480 0 180 $X=347820 $Y=754060
X1043 941 2 954 942 1 NR2 $T=348440 648600 0 0 $X=348440 $Y=648220
X1044 928 2 968 943 1 NR2 $T=351540 668760 0 180 $X=349680 $Y=663340
X1045 960 2 959 955 1 NR2 $T=357740 769560 1 180 $X=355880 $Y=769180
X1046 986 2 938 982 1 NR2 $T=363320 769560 1 180 $X=361460 $Y=769180
X1047 1002 2 1011 95 1 NR2 $T=370760 658680 1 0 $X=370760 $Y=653260
X1048 94 2 999 1002 1 NR2 $T=370760 668760 1 0 $X=370760 $Y=663340
X1049 1002 2 922 1015 1 NR2 $T=373240 699000 0 0 $X=373240 $Y=698620
X1050 1015 2 958 1025 1 NR2 $T=375100 709080 0 0 $X=375100 $Y=708700
X1051 102 2 966 95 1 NR2 $T=378200 678840 0 180 $X=376340 $Y=673420
X1052 1033 2 948 1002 1 NR2 $T=378200 699000 0 180 $X=376340 $Y=693580
X1053 1025 2 1004 106 1 NR2 $T=379440 648600 0 0 $X=379440 $Y=648220
X1054 102 2 1032 94 1 NR2 $T=379440 668760 1 0 $X=379440 $Y=663340
X1055 1025 2 1038 95 1 NR2 $T=381300 678840 0 180 $X=379440 $Y=673420
X1056 107 2 1005 103 1 NR2 $T=381300 688920 1 180 $X=379440 $Y=688540
X1057 109 2 989 111 1 NR2 $T=385020 648600 0 0 $X=385020 $Y=648220
X1058 109 2 1036 1002 1 NR2 $T=385020 678840 1 0 $X=385020 $Y=673420
X1059 1044 2 1035 1025 1 NR2 $T=386880 688920 1 180 $X=385020 $Y=688540
X1060 1040 2 1055 1048 1 NR2 $T=385640 699000 1 0 $X=385640 $Y=693580
X1061 1055 2 1073 1070 1 NR2 $T=391840 699000 1 0 $X=391840 $Y=693580
X1062 1044 2 1082 112 1 NR2 $T=396800 668760 0 180 $X=394940 $Y=663340
X1063 1083 2 1066 1069 1 NR2 $T=401760 678840 0 180 $X=399900 $Y=673420
X1064 1087 2 1059 1068 1 NR2 $T=399900 719160 0 0 $X=399900 $Y=718780
X1065 1092 2 1065 1097 1 NR2 $T=403000 749400 0 0 $X=403000 $Y=749020
X1066 1065 2 1088 1084 1 NR2 $T=403000 759480 1 0 $X=403000 $Y=754060
X1067 1114 2 1084 1103 1 NR2 $T=407960 749400 0 180 $X=406100 $Y=743980
X1068 1143 2 1061 1015 1 NR2 $T=412920 709080 1 180 $X=411060 $Y=708700
X1069 1123 2 1121 1015 1 NR2 $T=413540 729240 0 180 $X=411680 $Y=723820
X1070 1132 2 1128 117 1 NR2 $T=414160 658680 0 180 $X=412300 $Y=653260
X1071 1100 2 1105 1119 1 NR2 $T=414160 759480 0 180 $X=412300 $Y=754060
X1072 135 2 1100 1131 1 NR2 $T=414160 749400 0 0 $X=414160 $Y=749020
X1073 1100 2 1120 1130 1 NR2 $T=415400 779640 1 0 $X=415400 $Y=774220
X1074 1148 2 1135 136 1 NR2 $T=418500 759480 0 180 $X=416640 $Y=754060
X1075 1141 2 142 136 1 NR2 $T=419740 779640 0 180 $X=417880 $Y=774220
X1076 1155 2 1119 141 1 NR2 $T=422220 749400 1 180 $X=420360 $Y=749020
X1077 1170 2 1133 1015 1 NR2 $T=425940 729240 0 180 $X=424080 $Y=723820
X1078 1167 2 1148 151 1 NR2 $T=426560 749400 0 0 $X=426560 $Y=749020
X1079 1181 2 152 154 1 NR2 $T=430900 648600 0 180 $X=429040 $Y=643180
X1080 1158 2 1196 1166 1 NR2 $T=434620 749400 0 180 $X=432760 $Y=743980
X1081 1204 2 1212 1211 1 NR2 $T=440820 759480 1 0 $X=440820 $Y=754060
X1082 166 2 1168 1181 1 NR2 $T=445780 658680 1 180 $X=443920 $Y=658300
X1083 1203 2 1225 1207 1 NR2 $T=444540 749400 0 0 $X=444540 $Y=749020
X1084 166 2 1231 161 1 NR2 $T=447020 658680 1 0 $X=447020 $Y=653260
X1085 1132 2 1232 1181 1 NR2 $T=449500 658680 1 180 $X=447640 $Y=658300
X1086 1233 2 1177 1033 1 NR2 $T=449500 729240 0 180 $X=447640 $Y=723820
X1087 1143 2 1246 1237 1 NR2 $T=450120 709080 0 0 $X=450120 $Y=708700
X1088 1123 2 1229 1237 1 NR2 $T=450120 729240 0 0 $X=450120 $Y=728860
X1089 1044 2 1236 171 1 NR2 $T=450740 658680 1 0 $X=450740 $Y=653260
X1090 1233 2 1217 1240 1 NR2 $T=450740 719160 0 0 $X=450740 $Y=718780
X1091 1170 2 1245 1251 1 NR2 $T=453220 729240 1 0 $X=453220 $Y=723820
X1092 1233 2 1242 1251 1 NR2 $T=453840 719160 0 0 $X=453840 $Y=718780
X1093 1233 2 1252 1237 1 NR2 $T=453840 729240 0 0 $X=453840 $Y=728860
X1094 1263 2 1206 117 1 NR2 $T=456940 668760 0 180 $X=455080 $Y=663340
X1095 1123 2 1260 1251 1 NR2 $T=458800 729240 1 180 $X=456940 $Y=728860
X1096 1123 2 1267 1240 1 NR2 $T=459420 719160 0 0 $X=459420 $Y=718780
X1097 173 2 1266 1254 1 NR2 $T=461900 648600 1 180 $X=460040 $Y=648220
X1098 1266 2 178 1264 1 NR2 $T=460660 688920 1 0 $X=460660 $Y=683500
X1099 1170 2 1274 1240 1 NR2 $T=462520 719160 0 0 $X=462520 $Y=718780
X1100 184 2 1275 1015 1 NR2 $T=467480 729240 1 180 $X=465620 $Y=728860
X1101 1283 2 1296 1290 1 NR2 $T=468100 709080 1 0 $X=468100 $Y=703660
X1102 1279 2 1303 1277 1 NR2 $T=471200 648600 0 0 $X=471200 $Y=648220
X1103 1299 2 1298 1300 1 NR2 $T=471200 719160 1 0 $X=471200 $Y=713740
X1104 1311 2 1288 1300 1 NR2 $T=473060 719160 1 180 $X=471200 $Y=718780
X1105 1311 2 1301 1290 1 NR2 $T=473060 729240 1 180 $X=471200 $Y=728860
X1106 1293 2 1309 1300 1 NR2 $T=474300 719160 1 0 $X=474300 $Y=713740
X1107 166 2 1323 171 1 NR2 $T=474920 648600 0 0 $X=474920 $Y=648220
X1108 194 2 1316 1033 1 NR2 $T=479260 699000 1 180 $X=477400 $Y=698620
X1109 190 2 1314 1240 1 NR2 $T=479260 719160 1 180 $X=477400 $Y=718780
X1110 184 2 1310 1033 1 NR2 $T=479260 729240 1 180 $X=477400 $Y=728860
X1111 1132 2 1346 161 1 NR2 $T=487940 648600 1 180 $X=486080 $Y=648220
X1112 1350 2 1341 1240 1 NR2 $T=488560 719160 1 180 $X=486700 $Y=718780
X1113 184 2 1356 1240 1 NR2 $T=489180 699000 0 180 $X=487320 $Y=693580
X1114 1293 2 1362 1290 1 NR2 $T=487940 719160 1 0 $X=487940 $Y=713740
X1115 1343 2 1330 1334 1 NR2 $T=489800 739320 0 180 $X=487940 $Y=733900
X1116 1350 2 1353 1251 1 NR2 $T=488560 699000 0 0 $X=488560 $Y=698620
X1117 194 2 1354 1251 1 NR2 $T=493520 719160 1 180 $X=491660 $Y=718780
X1118 1263 2 1363 161 1 NR2 $T=494140 648600 1 180 $X=492280 $Y=648220
X1119 1263 2 1364 195 1 NR2 $T=493520 658680 1 0 $X=493520 $Y=653260
X1120 1293 2 1385 1369 1 NR2 $T=495380 719160 0 0 $X=495380 $Y=718780
X1121 1170 2 1373 1337 1 NR2 $T=496000 709080 1 0 $X=496000 $Y=703660
X1122 1044 2 1377 208 1 NR2 $T=499100 668760 1 0 $X=499100 $Y=663340
X1123 190 2 1388 1369 1 NR2 $T=502200 688920 1 180 $X=500340 $Y=688540
X1124 1170 2 1391 1369 1 NR2 $T=502820 709080 1 180 $X=500960 $Y=708700
X1125 194 2 1397 1237 1 NR2 $T=502820 719160 0 180 $X=500960 $Y=713740
X1126 1350 2 1389 1237 1 NR2 $T=502820 719160 1 180 $X=500960 $Y=718780
X1127 190 2 1393 1290 1 NR2 $T=500960 729240 0 0 $X=500960 $Y=728860
X1128 1383 2 1404 211 1 NR2 $T=505920 658680 1 0 $X=505920 $Y=653260
X1129 1044 2 1409 212 1 NR2 $T=505920 668760 1 0 $X=505920 $Y=663340
X1130 1350 2 1405 1337 1 NR2 $T=506540 709080 1 0 $X=506540 $Y=703660
X1131 184 2 1414 1290 1 NR2 $T=509020 729240 1 180 $X=507160 $Y=728860
X1132 166 2 1419 208 1 NR2 $T=507780 658680 0 0 $X=507780 $Y=658300
X1133 1350 2 1411 1290 1 NR2 $T=511500 709080 0 180 $X=509640 $Y=703660
X1134 194 2 1417 1337 1 NR2 $T=510260 699000 0 0 $X=510260 $Y=698620
X1135 1434 2 1423 195 1 NR2 $T=514600 658680 1 180 $X=512740 $Y=658300
X1136 184 2 1429 1337 1 NR2 $T=515220 709080 1 180 $X=513360 $Y=708700
X1137 1263 2 1460 1448 1 NR2 $T=520180 658680 0 0 $X=520180 $Y=658300
X1138 224 2 1452 1453 1 NR2 $T=521420 729240 1 0 $X=521420 $Y=723820
X1139 1311 2 224 1467 1 NR2 $T=524520 729240 1 0 $X=524520 $Y=723820
X1140 1469 2 1468 1462 1 NR2 $T=532580 759480 0 180 $X=530720 $Y=754060
X1141 236 2 238 195 1 NR2 $T=538780 648600 0 180 $X=536920 $Y=643180
X1142 1457 2 1474 212 1 NR2 $T=537540 658680 1 0 $X=537540 $Y=653260
X1143 1500 2 1508 1299 1 NR2 $T=538160 719160 1 0 $X=538160 $Y=713740
X1144 236 2 1511 1448 1 NR2 $T=541260 668760 0 180 $X=539400 $Y=663340
X1145 1263 2 1516 185 1 NR2 $T=540020 658680 0 0 $X=540020 $Y=658300
X1146 1434 2 1532 185 1 NR2 $T=544360 668760 0 180 $X=542500 $Y=663340
X1147 1457 2 1533 185 1 NR2 $T=544980 648600 1 180 $X=543120 $Y=648220
X1148 245 2 1528 1448 1 NR2 $T=547460 678840 0 180 $X=545600 $Y=673420
X1149 1547 2 1537 1448 1 NR2 $T=547460 678840 1 180 $X=545600 $Y=678460
X1150 236 2 1545 212 1 NR2 $T=548080 668760 0 180 $X=546220 $Y=663340
X1151 244 2 1562 1560 1 NR2 $T=548080 648600 0 0 $X=548080 $Y=648220
X1152 236 2 1544 246 1 NR2 $T=548700 658680 1 0 $X=548700 $Y=653260
X1153 245 2 1503 246 1 NR2 $T=551180 668760 1 0 $X=551180 $Y=663340
X1154 1556 2 1553 212 1 NR2 $T=551180 678840 1 0 $X=551180 $Y=673420
X1155 1547 2 1569 212 1 NR2 $T=551180 678840 0 0 $X=551180 $Y=678460
X1156 1584 2 1588 1572 1 NR2 $T=559240 739320 1 180 $X=557380 $Y=738940
X1157 251 2 1586 257 1 NR2 $T=558000 648600 0 0 $X=558000 $Y=648220
X1158 1444 2 1623 1616 1 NR2 $T=571640 729240 0 180 $X=569780 $Y=723820
X1159 251 2 1632 268 1 NR2 $T=574120 648600 1 0 $X=574120 $Y=643180
X1160 1653 2 1610 268 1 NR2 $T=579700 658680 0 180 $X=577840 $Y=653260
X1161 1653 2 1668 273 1 NR2 $T=580940 668760 1 0 $X=580940 $Y=663340
X1162 1653 2 1655 274 1 NR2 $T=580940 688920 0 0 $X=580940 $Y=688540
X1163 1673 2 1648 273 1 NR2 $T=585900 688920 1 180 $X=584040 $Y=688540
X1164 1630 2 1679 1674 1 NR2 $T=584040 699000 0 0 $X=584040 $Y=698620
X1165 1677 2 1663 1667 1 NR2 $T=585900 749400 1 180 $X=584040 $Y=749020
X1166 1673 2 277 257 1 NR2 $T=586520 648600 0 180 $X=584660 $Y=643180
X1167 278 2 280 282 1 NR2 $T=587760 648600 1 0 $X=587760 $Y=643180
X1168 1673 2 1706 1692 1 NR2 $T=589620 699000 1 0 $X=589620 $Y=693580
X1169 281 2 1683 1692 1 NR2 $T=590240 668760 0 0 $X=590240 $Y=668380
X1170 1653 2 1696 1692 1 NR2 $T=590240 688920 0 0 $X=590240 $Y=688540
X1171 281 2 288 268 1 NR2 $T=591480 648600 1 0 $X=591480 $Y=643180
X1172 289 2 286 1713 1 NR2 $T=595820 648600 0 0 $X=595820 $Y=648220
X1173 281 2 1705 1710 1 NR2 $T=595820 678840 0 0 $X=595820 $Y=678460
X1174 1673 2 1694 274 1 NR2 $T=595820 688920 0 0 $X=595820 $Y=688540
X1175 1627 2 1657 1731 1 NR2 $T=595820 739320 0 0 $X=595820 $Y=738940
X1176 289 2 1717 282 1 NR2 $T=598300 658680 0 180 $X=596440 $Y=653260
X1177 278 2 1671 1713 1 NR2 $T=597060 688920 1 0 $X=597060 $Y=683500
X1178 1722 2 1720 268 1 NR2 $T=602640 658680 1 180 $X=600780 $Y=658300
X1179 278 2 1662 1710 1 NR2 $T=601400 688920 1 0 $X=601400 $Y=683500
X1180 1722 2 1732 1710 1 NR2 $T=606360 688920 0 180 $X=604500 $Y=683500
X1181 1653 2 1738 1713 1 NR2 $T=606360 688920 1 0 $X=606360 $Y=683500
X1182 301 2 1743 1713 1 NR2 $T=610080 658680 1 180 $X=608220 $Y=658300
X1183 1722 2 1742 1713 1 NR2 $T=610700 688920 0 180 $X=608840 $Y=683500
X1184 301 2 304 282 1 NR2 $T=613180 648600 1 0 $X=613180 $Y=643180
X1185 1525 2 1674 306 1 NR2 $T=613800 709080 1 0 $X=613800 $Y=703660
X1186 251 2 1758 282 1 NR2 $T=616900 658680 1 180 $X=615040 $Y=658300
X1187 251 2 1761 1713 1 NR2 $T=617520 668760 0 180 $X=615660 $Y=663340
X1188 289 2 317 268 1 NR2 $T=620000 648600 0 180 $X=618140 $Y=643180
X1189 1776 2 314 1762 1 NR2 $T=621860 769560 0 180 $X=620000 $Y=764140
X1190 1760 2 1786 315 1 NR2 $T=625580 709080 0 0 $X=625580 $Y=708700
X1191 1787 2 1788 1784 1 NR2 $T=628680 739320 0 180 $X=626820 $Y=733900
X1192 322 2 1270 324 1 NR2 $T=629920 769560 0 0 $X=629920 $Y=769180
X1193 1747 2 1812 328 1 NR2 $T=632400 719160 0 0 $X=632400 $Y=718780
X1194 1787 2 1797 328 1 NR2 $T=636120 729240 1 180 $X=634260 $Y=728860
X1195 314 2 1807 1819 1 NR2 $T=634880 769560 0 0 $X=634880 $Y=769180
X1196 1818 2 334 328 1 NR2 $T=639220 648600 0 180 $X=637360 $Y=643180
X1197 1816 2 1815 321 1 NR2 $T=639220 699000 1 180 $X=637360 $Y=698620
X1198 1809 2 1821 1823 1 NR2 $T=637980 729240 0 0 $X=637980 $Y=728860
X1199 1826 2 1833 1785 1 NR2 $T=641080 699000 1 180 $X=639220 $Y=698620
X1200 1818 2 1838 1785 1 NR2 $T=640460 658680 0 0 $X=640460 $Y=658300
X1201 1832 2 1793 1785 1 NR2 $T=642320 719160 0 180 $X=640460 $Y=713740
X1202 1816 2 1839 1803 1 NR2 $T=641080 688920 0 0 $X=641080 $Y=688540
X1203 1834 2 332 1829 1 NR2 $T=642940 769560 1 180 $X=641080 $Y=769180
X1204 1829 2 342 1862 1 NR2 $T=646660 769560 0 0 $X=646660 $Y=769180
X1205 1854 2 1859 336 1 NR2 $T=648520 668760 1 0 $X=648520 $Y=663340
X1206 346 2 1860 321 1 NR2 $T=651000 699000 0 180 $X=649140 $Y=693580
X1207 1870 2 1874 1785 1 NR2 $T=651620 688920 1 180 $X=649760 $Y=688540
X1208 347 2 1879 1785 1 NR2 $T=654100 668760 1 180 $X=652240 $Y=668380
X1209 1875 2 1867 336 1 NR2 $T=654100 699000 0 180 $X=652240 $Y=693580
X1210 1864 2 1843 1882 1 NR2 $T=652240 709080 1 0 $X=652240 $Y=703660
X1211 1875 2 1851 1803 1 NR2 $T=654100 719160 1 180 $X=652240 $Y=718780
X1212 346 2 1856 1803 1 NR2 $T=655960 678840 0 180 $X=654100 $Y=673420
X1213 346 2 1886 353 1 NR2 $T=657820 668760 0 0 $X=657820 $Y=668380
X1214 1892 2 1893 1866 1 NR2 $T=659680 739320 0 180 $X=657820 $Y=733900
X1215 1895 2 1834 1926 1 NR2 $T=660920 769560 0 0 $X=660920 $Y=769180
X1216 1832 2 1902 1898 1 NR2 $T=661540 739320 1 0 $X=661540 $Y=733900
X1217 1875 2 1911 1904 1 NR2 $T=662160 729240 0 0 $X=662160 $Y=728860
X1218 1870 2 1890 315 1 NR2 $T=666500 678840 0 180 $X=664640 $Y=673420
X1219 1854 2 1917 353 1 NR2 $T=666500 678840 1 0 $X=666500 $Y=673420
X1220 1875 2 1918 359 1 NR2 $T=666500 739320 1 0 $X=666500 $Y=733900
X1221 1909 2 356 1858 1 NR2 $T=666500 779640 1 0 $X=666500 $Y=774220
X1222 1892 2 1925 1898 1 NR2 $T=669600 719160 1 180 $X=667740 $Y=718780
X1223 1919 2 1933 1898 1 NR2 $T=670220 739320 0 180 $X=668360 $Y=733900
X1224 1875 2 1934 362 1 NR2 $T=670840 709080 1 0 $X=670840 $Y=703660
X1225 1832 2 1954 362 1 NR2 $T=670840 729240 0 0 $X=670840 $Y=728860
X1226 1936 2 1945 1935 1 NR2 $T=677660 678840 1 180 $X=675800 $Y=678460
X1227 364 2 368 371 1 NR2 $T=677660 779640 1 0 $X=677660 $Y=774220
X1228 1892 2 1952 359 1 NR2 $T=678900 729240 0 0 $X=678900 $Y=728860
X1229 1919 2 1958 362 1 NR2 $T=678900 739320 1 0 $X=678900 $Y=733900
X1230 370 2 1970 367 1 NR2 $T=681380 648600 1 0 $X=681380 $Y=643180
X1231 1959 2 1950 1953 1 NR2 $T=684480 719160 0 180 $X=682620 $Y=713740
X1232 1979 2 1973 1854 1 NR2 $T=686960 678840 1 180 $X=685100 $Y=678460
X1233 1832 2 1974 1866 1 NR2 $T=685100 739320 1 0 $X=685100 $Y=733900
X1234 1832 2 1991 1904 1 NR2 $T=687580 729240 0 0 $X=687580 $Y=728860
X1235 1980 2 1987 1955 1 NR2 $T=690060 699000 0 0 $X=690060 $Y=698620
X1236 1826 2 1998 359 1 NR2 $T=690680 739320 1 0 $X=690680 $Y=733900
X1237 1826 2 1999 1904 1 NR2 $T=690680 749400 1 0 $X=690680 $Y=743980
X1238 1989 2 381 383 1 NR2 $T=692540 779640 1 0 $X=692540 $Y=774220
X1239 1919 2 2008 1866 1 NR2 $T=696880 729240 1 0 $X=696880 $Y=723820
X1240 2017 2 2021 1987 1 NR2 $T=699360 699000 0 180 $X=697500 $Y=693580
X1241 1996 2 2001 2016 1 NR2 $T=698120 658680 0 0 $X=698120 $Y=658300
X1242 2047 2 2051 1866 1 NR2 $T=704940 739320 0 180 $X=703080 $Y=733900
X1243 2013 2 1989 2024 1 NR2 $T=706800 769560 1 180 $X=704940 $Y=769180
X1244 1989 2 392 388 1 NR2 $T=706800 779640 0 180 $X=704940 $Y=774220
X1245 1997 2 2054 2052 1 NR2 $T=710520 668760 1 180 $X=708660 $Y=668380
X1246 1787 2 2064 2061 1 NR2 $T=711760 709080 0 0 $X=711760 $Y=708700
X1247 2095 2 2091 2005 1 NR2 $T=725400 719160 0 180 $X=723540 $Y=713740
X1248 2103 2 2118 1904 1 NR2 $T=728500 739320 0 180 $X=726640 $Y=733900
X1249 2136 2 418 2164 1 NR2 $T=747100 769560 0 0 $X=747100 $Y=769180
X1250 2097 2 2177 2173 1 NR2 $T=756400 709080 1 0 $X=756400 $Y=703660
X1251 458 2 2296 464 1 NR2 $T=802280 779640 1 0 $X=802280 $Y=774220
X1252 2291 2 2282 462 1 NR2 $T=805380 668760 0 180 $X=803520 $Y=663340
X1253 469 2 2300 449 1 NR2 $T=810960 779640 0 180 $X=809100 $Y=774220
X1254 2332 2 2333 484 1 NR2 $T=827080 678840 1 0 $X=827080 $Y=673420
X1255 2349 2 2361 496 1 NR2 $T=836380 699000 1 0 $X=836380 $Y=693580
X1256 2460 2 2510 2482 1 NR2 $T=895280 719160 0 180 $X=893420 $Y=713740
X1257 582 2 2564 577 1 NR2 $T=934960 779640 1 0 $X=934960 $Y=774220
X1258 698 770 2 1 772 OR2 $T=277760 729240 1 0 $X=277760 $Y=723820
X1259 820 814 2 1 792 OR2 $T=295740 769560 1 180 $X=293260 $Y=769180
X1260 874 857 2 1 62 OR2 $T=319920 769560 0 0 $X=319920 $Y=769180
X1261 870 875 2 1 800 OR2 $T=327980 709080 1 180 $X=325500 $Y=708700
X1262 73 75 2 1 834 OR2 $T=339760 709080 0 180 $X=337280 $Y=703660
X1263 86 84 2 1 82 OR2 $T=357740 779640 0 180 $X=355260 $Y=774220
X1264 92 91 2 1 944 OR2 $T=370760 709080 1 180 $X=368280 $Y=708700
X1265 1058 1052 2 1 1023 OR2 $T=390600 729240 0 180 $X=388120 $Y=723820
X1266 1198 160 2 1 1164 OR2 $T=441440 769560 1 180 $X=438960 $Y=769180
X1267 2220 2222 2 1 2226 OR2 $T=774380 668760 0 0 $X=774380 $Y=668380
X1268 454 2261 2 1 2283 OR2 $T=794220 648600 1 0 $X=794220 $Y=643180
X1269 478 2309 2 1 2326 OR2 $T=822120 678840 0 0 $X=822120 $Y=678460
X1270 500 2365 2 1 2371 OR2 $T=843200 678840 1 0 $X=843200 $Y=673420
X1271 2374 2378 2 1 2412 OR2 $T=849400 719160 1 0 $X=849400 $Y=713740
X1272 504 2397 2 1 2388 OR2 $T=856840 699000 0 0 $X=856840 $Y=698620
X1273 2531 570 2 1 563 OR2 $T=915740 648600 0 180 $X=913260 $Y=643180
X1274 2588 2573 2 1 2555 OR2 $T=939300 739320 1 180 $X=936820 $Y=738940
X1275 2228 2641 2 1 2642 OR2 $T=963480 688920 1 0 $X=963480 $Y=683500
X1276 712 650 725 2 1 ND2S $T=257300 759480 1 0 $X=257300 $Y=754060
X1277 723 711 746 2 1 ND2S $T=257920 739320 0 0 $X=257920 $Y=738940
X1278 723 712 26 2 1 ND2S $T=260400 759480 1 0 $X=260400 $Y=754060
X1279 701 731 740 2 1 ND2S $T=263500 739320 0 0 $X=263500 $Y=738940
X1280 750 733 740 2 1 ND2S $T=268460 749400 0 180 $X=266600 $Y=743980
X1281 32 728 754 2 1 ND2S $T=269700 769560 0 0 $X=269700 $Y=769180
X1282 749 739 757 2 1 ND2S $T=270940 719160 1 0 $X=270940 $Y=713740
X1283 34 36 744 2 1 ND2S $T=274660 779640 0 180 $X=272800 $Y=774220
X1284 765 665 740 2 1 ND2S $T=275280 769560 1 0 $X=275280 $Y=764140
X1285 35 33 757 2 1 ND2S $T=275900 769560 0 0 $X=275900 $Y=769180
X1286 769 755 776 2 1 ND2S $T=278380 709080 1 0 $X=278380 $Y=703660
X1287 754 756 757 2 1 ND2S $T=280240 729240 1 180 $X=278380 $Y=728860
X1288 35 39 744 2 1 ND2S $T=280240 779640 0 180 $X=278380 $Y=774220
X1289 26 38 750 2 1 ND2S $T=279620 769560 1 0 $X=279620 $Y=764140
X1290 34 41 754 2 1 ND2S $T=283340 769560 1 180 $X=281480 $Y=769180
X1291 811 783 797 2 1 ND2S $T=286440 668760 0 0 $X=286440 $Y=668380
X1292 768 802 47 2 1 ND2S $T=288920 739320 1 0 $X=288920 $Y=733900
X1293 801 775 805 2 1 ND2S $T=289540 699000 1 0 $X=289540 $Y=693580
X1294 785 798 822 2 1 ND2S $T=296360 749400 1 0 $X=296360 $Y=743980
X1295 834 799 841 2 1 ND2S $T=305040 709080 0 0 $X=305040 $Y=708700
X1296 853 819 849 2 1 ND2S $T=311240 699000 1 0 $X=311240 $Y=693580
X1297 58 849 59 2 1 ND2S $T=312480 668760 0 0 $X=312480 $Y=668380
X1298 835 764 868 2 1 ND2S $T=316200 688920 1 0 $X=316200 $Y=683500
X1299 865 882 875 2 1 ND2S $T=323020 688920 0 0 $X=323020 $Y=688540
X1300 896 850 881 2 1 ND2S $T=327980 749400 1 180 $X=326120 $Y=749020
X1301 870 886 867 2 1 ND2S $T=327980 699000 1 0 $X=327980 $Y=693580
X1302 865 903 867 2 1 ND2S $T=331080 688920 0 180 $X=329220 $Y=683500
X1303 870 901 68 2 1 ND2S $T=333560 678840 1 180 $X=331700 $Y=678460
X1304 68 916 865 2 1 ND2S $T=336040 678840 0 180 $X=334180 $Y=673420
X1305 867 928 885 2 1 ND2S $T=337900 668760 0 180 $X=336040 $Y=663340
X1306 73 841 75 2 1 ND2S $T=337900 709080 0 0 $X=337900 $Y=708700
X1307 76 942 73 2 1 ND2S $T=342860 648600 1 180 $X=341000 $Y=648220
X1308 924 880 925 2 1 ND2S $T=341000 769560 1 0 $X=341000 $Y=764140
X1309 936 915 932 2 1 ND2S $T=341000 769560 0 0 $X=341000 $Y=769180
X1310 867 941 59 2 1 ND2S $T=341620 658680 0 0 $X=341620 $Y=658300
X1311 76 943 59 2 1 ND2S $T=344720 668760 0 180 $X=342860 $Y=663340
X1312 885 945 875 2 1 ND2S $T=348440 688920 0 180 $X=346580 $Y=683500
X1313 940 925 953 2 1 ND2S $T=347820 749400 1 0 $X=347820 $Y=743980
X1314 944 907 969 2 1 ND2S $T=348440 709080 1 0 $X=348440 $Y=703660
X1315 870 934 64 2 1 ND2S $T=355880 678840 0 0 $X=355880 $Y=678460
X1316 955 946 960 2 1 ND2S $T=355880 769560 1 0 $X=355880 $Y=764140
X1317 92 969 91 2 1 ND2S $T=365800 709080 1 0 $X=365800 $Y=703660
X1318 1009 1010 985 2 1 ND2S $T=372000 719160 1 180 $X=370140 $Y=718780
X1319 103 985 107 2 1 ND2S $T=379440 699000 1 0 $X=379440 $Y=693580
X1320 1023 974 1042 2 1 ND2S $T=383160 729240 0 0 $X=383160 $Y=728860
X1321 1058 1042 1052 2 1 ND2S $T=388120 729240 0 0 $X=388120 $Y=728860
X1322 1046 1021 1053 2 1 ND2S $T=388120 749400 1 0 $X=388120 $Y=743980
X1323 1081 1020 1077 2 1 ND2S $T=394320 749400 0 0 $X=394320 $Y=749020
X1324 1058 1069 1095 2 1 ND2S $T=399900 668760 0 0 $X=399900 $Y=668380
X1325 1094 1078 1090 2 1 ND2S $T=399900 769560 1 0 $X=399900 $Y=764140
X1326 1092 1087 1034 2 1 ND2S $T=402380 729240 1 180 $X=400520 $Y=728860
X1327 1097 1083 99 2 1 ND2S $T=404860 678840 0 180 $X=403000 $Y=673420
X1328 1097 1053 1092 2 1 ND2S $T=404860 739320 1 180 $X=403000 $Y=738940
X1329 1097 1110 1095 2 1 ND2S $T=407960 668760 0 180 $X=406100 $Y=663340
X1330 1052 1068 1093 2 1 ND2S $T=406100 719160 0 0 $X=406100 $Y=718780
X1331 1103 1077 1114 2 1 ND2S $T=406100 739320 1 0 $X=406100 $Y=733900
X1332 1114 1138 1108 2 1 ND2S $T=413540 739320 0 180 $X=411680 $Y=733900
X1333 1118 1109 1125 2 1 ND2S $T=412300 739320 0 0 $X=412300 $Y=738940
X1334 1088 136 1105 2 1 ND2S $T=414160 759480 1 180 $X=412300 $Y=759100
X1335 1131 1090 135 2 1 ND2S $T=415400 739320 0 0 $X=415400 $Y=738940
X1336 1131 1158 1108 2 1 ND2S $T=422840 739320 1 180 $X=420980 $Y=738940
X1337 141 1125 1155 2 1 ND2S $T=420980 749400 1 0 $X=420980 $Y=743980
X1338 1164 1141 1149 2 1 ND2S $T=423460 769560 1 180 $X=421600 $Y=769180
X1339 1149 148 1157 2 1 ND2S $T=424080 779640 1 0 $X=424080 $Y=774220
X1340 1058 1162 885 2 1 ND2S $T=425940 668760 1 0 $X=425940 $Y=663340
X1341 1164 1124 1172 2 1 ND2S $T=426560 759480 0 0 $X=426560 $Y=759100
X1342 151 1157 1167 2 1 ND2S $T=428420 759480 1 0 $X=428420 $Y=754060
X1343 1155 1166 1034 2 1 ND2S $T=432760 749400 0 0 $X=432760 $Y=749020
X1344 1155 1203 1108 2 1 ND2S $T=434620 759480 0 180 $X=432760 $Y=754060
X1345 1198 1172 160 2 1 ND2S $T=435240 759480 0 0 $X=435240 $Y=759100
X1346 1103 1205 1186 2 1 ND2S $T=437720 668760 1 180 $X=435860 $Y=668380
X1347 1192 1174 1197 2 1 ND2S $T=435860 739320 1 0 $X=435860 $Y=733900
X1348 1167 1204 1108 2 1 ND2S $T=438340 759480 0 180 $X=436480 $Y=754060
X1349 1198 1211 1034 2 1 ND2S $T=440200 749400 1 180 $X=438340 $Y=749020
X1350 1167 1207 1034 2 1 ND2S $T=440820 749400 0 180 $X=438960 $Y=743980
X1351 1052 1218 1221 2 1 ND2S $T=443920 719160 1 0 $X=443920 $Y=713740
X1352 135 1279 176 2 1 ND2S $T=465620 648600 1 0 $X=465620 $Y=643180
X1353 1155 1276 1221 2 1 ND2S $T=467480 739320 1 180 $X=465620 $Y=738940
X1354 107 1264 1285 2 1 ND2S $T=466240 678840 0 0 $X=466240 $Y=678460
X1355 186 1277 99 2 1 ND2S $T=473060 648600 0 180 $X=471200 $Y=643180
X1356 1131 1297 187 2 1 ND2S $T=471820 739320 0 0 $X=471820 $Y=738940
X1357 1312 1320 187 2 1 ND2S $T=479260 739320 0 180 $X=477400 $Y=733900
X1358 1198 1334 1197 2 1 ND2S $T=485460 729240 1 180 $X=483600 $Y=728860
X1359 1312 1361 75 2 1 ND2S $T=486700 709080 0 180 $X=484840 $Y=703660
X1360 1092 1343 1335 2 1 ND2S $T=489180 729240 0 0 $X=489180 $Y=728860
X1361 1379 1371 1221 2 1 ND2S $T=496620 739320 1 180 $X=494760 $Y=738940
X1362 1386 1375 91 2 1 ND2S $T=497240 688920 0 0 $X=497240 $Y=688540
X1363 151 1383 176 2 1 ND2S $T=499720 658680 0 180 $X=497860 $Y=653260
X1364 1379 1426 187 2 1 ND2S $T=514600 729240 1 180 $X=512740 $Y=728860
X1365 215 1428 1335 2 1 ND2S $T=515840 699000 0 0 $X=515840 $Y=698620
X1366 1198 1440 1335 2 1 ND2S $T=515840 739320 1 0 $X=515840 $Y=733900
X1367 219 1435 1335 2 1 ND2S $T=515840 759480 0 0 $X=515840 $Y=759100
X1368 1437 1473 91 2 1 ND2S $T=527000 699000 1 180 $X=525140 $Y=698620
X1369 1478 1484 1500 2 1 ND2S $T=530720 719160 0 0 $X=530720 $Y=718780
X1370 1495 1489 1501 2 1 ND2S $T=533820 739320 0 0 $X=533820 $Y=738940
X1371 1539 1520 1524 2 1 ND2S $T=540020 739320 1 0 $X=540020 $Y=733900
X1372 160 1526 239 2 1 ND2S $T=544360 648600 0 180 $X=542500 $Y=643180
X1373 1555 1561 237 2 1 ND2S $T=550560 688920 1 180 $X=548700 $Y=688540
X1374 252 1563 249 2 1 ND2S $T=554900 668760 1 0 $X=554900 $Y=663340
X1375 160 1574 237 2 1 ND2S $T=556760 678840 0 0 $X=556760 $Y=678460
X1376 250 1589 1596 2 1 ND2S $T=559860 668760 1 0 $X=559860 $Y=663340
X1377 259 1590 237 2 1 ND2S $T=562340 688920 1 180 $X=560480 $Y=688540
X1378 1588 1593 1598 2 1 ND2S $T=560480 749400 1 0 $X=560480 $Y=743980
X1379 252 1530 1596 2 1 ND2S $T=561100 678840 0 0 $X=561100 $Y=678460
X1380 1539 1624 1609 2 1 ND2S $T=568540 739320 1 180 $X=566680 $Y=738940
X1381 1623 1649 1621 2 1 ND2S $T=577220 719160 1 180 $X=575360 $Y=718780
X1382 1618 1643 272 2 1 ND2S $T=580940 648600 1 0 $X=580940 $Y=643180
X1383 1752 1740 249 2 1 ND2S $T=611320 668760 1 180 $X=609460 $Y=668380
X1384 1752 1750 1596 2 1 ND2S $T=616900 688920 0 180 $X=615040 $Y=683500
X1385 309 1774 307 2 1 ND2S $T=621860 658680 0 180 $X=620000 $Y=653260
X1386 309 1768 1580 2 1 ND2S $T=621860 668760 0 180 $X=620000 $Y=663340
X1387 1765 1771 312 2 1 ND2S $T=622480 729240 0 0 $X=622480 $Y=728860
X1388 256 1770 1580 2 1 ND2S $T=624960 658680 1 0 $X=624960 $Y=653260
X1389 1591 1773 323 2 1 ND2S $T=625580 719160 0 0 $X=625580 $Y=718780
X1390 1765 1806 313 2 1 ND2S $T=627440 739320 1 180 $X=625580 $Y=738940
X1391 1789 1762 316 2 1 ND2S $T=625580 769560 0 0 $X=625580 $Y=769180
X1392 248 1790 249 2 1 ND2S $T=629920 648600 1 180 $X=628060 $Y=648220
X1393 311 1776 1778 2 1 ND2S $T=629300 759480 0 0 $X=629300 $Y=759100
X1394 1591 1792 326 2 1 ND2S $T=632400 749400 1 0 $X=632400 $Y=743980
X1395 306 1809 1796 2 1 ND2S $T=636740 719160 0 180 $X=634880 $Y=713740
X1396 1591 1824 312 2 1 ND2S $T=637980 749400 1 0 $X=637980 $Y=743980
X1397 1752 1820 1580 2 1 ND2S $T=640460 668760 0 180 $X=638600 $Y=663340
X1398 339 338 310 2 1 ND2S $T=643560 648600 1 0 $X=643560 $Y=643180
X1399 1580 343 1796 2 1 ND2S $T=644800 668760 1 0 $X=644800 $Y=663340
X1400 339 1847 323 2 1 ND2S $T=647900 648600 1 180 $X=646040 $Y=648220
X1401 1853 1862 348 2 1 ND2S $T=652240 769560 1 0 $X=652240 $Y=764140
X1402 1876 1882 354 2 1 ND2S $T=655340 719160 1 0 $X=655340 $Y=713740
X1403 1872 1896 1878 2 1 ND2S $T=658440 648600 1 180 $X=656580 $Y=648220
X1404 1876 1823 318 2 1 ND2S $T=658440 719160 0 0 $X=658440 $Y=718780
X1405 1915 1895 316 2 1 ND2S $T=661540 769560 1 0 $X=661540 $Y=764140
X1406 1753 1864 1878 2 1 ND2S $T=662160 709080 0 0 $X=662160 $Y=708700
X1407 1930 1926 363 2 1 ND2S $T=670220 769560 1 0 $X=670220 $Y=764140
X1408 1930 1858 377 2 1 ND2S $T=673320 769560 0 0 $X=673320 $Y=769180
X1409 1947 1935 354 2 1 ND2S $T=675800 709080 0 0 $X=675800 $Y=708700
X1410 1753 1953 354 2 1 ND2S $T=677660 719160 1 180 $X=675800 $Y=718780
X1411 1962 1936 1878 2 1 ND2S $T=680140 678840 1 180 $X=678280 $Y=678460
X1412 369 1971 1975 2 1 ND2S $T=684480 658680 1 0 $X=684480 $Y=653260
X1413 364 383 1984 2 1 ND2S $T=684480 779640 1 0 $X=684480 $Y=774220
X1414 2023 2006 312 2 1 ND2S $T=698740 749400 1 180 $X=696880 $Y=749020
X1415 2013 1984 2024 2 1 ND2S $T=697500 769560 0 0 $X=697500 $Y=769180
X1416 2023 2025 2028 2 1 ND2S $T=700600 749400 0 0 $X=700600 $Y=749020
X1417 2034 2037 2048 2 1 ND2S $T=703080 688920 1 0 $X=703080 $Y=683500
X1418 1988 2060 1796 2 1 ND2S $T=709900 729240 0 180 $X=708040 $Y=723820
X1419 2003 2074 313 2 1 ND2S $T=715480 729240 1 0 $X=715480 $Y=723820
X1420 394 2013 2077 2 1 ND2S $T=720440 769560 0 0 $X=720440 $Y=769180
X1421 2087 2070 2055 2 1 ND2S $T=721060 719160 0 0 $X=721060 $Y=718780
X1422 2089 2096 1995 2 1 ND2S $T=723540 699000 1 0 $X=723540 $Y=693580
X1423 2003 2110 1796 2 1 ND2S $T=726020 729240 1 180 $X=724160 $Y=728860
X1424 400 2077 398 2 1 ND2S $T=725400 759480 0 0 $X=725400 $Y=759100
X1425 318 401 379 2 1 ND2S $T=726640 779640 1 0 $X=726640 $Y=774220
X1426 2064 2122 2027 2 1 ND2S $T=730980 699000 0 180 $X=729120 $Y=693580
X1427 2091 2141 2020 2 1 ND2S $T=733460 688920 0 180 $X=731600 $Y=683500
X1428 379 2136 351 2 1 ND2S $T=737180 769560 1 180 $X=735320 $Y=769180
X1429 394 2164 2111 2 1 ND2S $T=743380 769560 0 180 $X=741520 $Y=764140
X1430 2038 2180 2099 2 1 ND2S $T=755780 729240 0 0 $X=755780 $Y=728860
X1431 2210 2239 2226 2 1 ND2S $T=779960 668760 0 180 $X=778100 $Y=663340
X1432 2222 2246 2220 2 1 ND2S $T=783060 668760 1 180 $X=781200 $Y=668380
X1433 2226 2230 2246 2 1 ND2S $T=783680 668760 1 0 $X=783680 $Y=663340
X1434 2253 2263 2246 2 1 ND2S $T=789260 668760 1 180 $X=787400 $Y=668380
X1435 453 2272 313 2 1 ND2S $T=789260 769560 1 180 $X=787400 $Y=769180
X1436 2263 2267 2226 2 1 ND2S $T=795460 668760 1 180 $X=793600 $Y=668380
X1437 454 2271 2261 2 1 ND2S $T=796700 648600 1 180 $X=794840 $Y=648220
X1438 2239 2266 2246 2 1 ND2S $T=797320 668760 1 0 $X=797320 $Y=663340
X1439 2283 2285 2271 2 1 ND2S $T=802900 648600 0 180 $X=801040 $Y=643180
X1440 2284 2311 2304 2 1 ND2S $T=809720 658680 0 0 $X=809720 $Y=658300
X1441 462 2304 2291 2 1 ND2S $T=811580 668760 0 180 $X=809720 $Y=663340
X1442 471 2290 2308 2 1 ND2S $T=809720 769560 0 0 $X=809720 $Y=769180
X1443 478 2313 2309 2 1 ND2S $T=814060 678840 1 0 $X=814060 $Y=673420
X1444 2326 2330 2313 2 1 ND2S $T=822740 678840 0 180 $X=820880 $Y=673420
X1445 484 2341 2332 2 1 ND2S $T=829560 678840 1 180 $X=827700 $Y=678460
X1446 2337 2340 2341 2 1 ND2S $T=831420 678840 1 0 $X=831420 $Y=673420
X1447 491 2350 2308 2 1 ND2S $T=833900 759480 0 180 $X=832040 $Y=754060
X1448 493 2348 2308 2 1 ND2S $T=833900 769560 1 180 $X=832040 $Y=769180
X1449 496 2357 2349 2 1 ND2S $T=838240 688920 1 180 $X=836380 $Y=688540
X1450 500 2354 2365 2 1 ND2S $T=837620 678840 1 0 $X=837620 $Y=673420
X1451 2371 2359 2354 2 1 ND2S $T=843820 678840 1 180 $X=841960 $Y=678460
X1452 2363 2369 2357 2 1 ND2S $T=843820 688920 1 180 $X=841960 $Y=688540
X1453 504 2377 2397 2 1 ND2S $T=844440 699000 0 0 $X=844440 $Y=698620
X1454 2388 2386 2377 2 1 ND2S $T=852500 699000 1 180 $X=850640 $Y=698620
X1455 2374 2396 2378 2 1 ND2S $T=855600 719160 1 180 $X=853740 $Y=718780
X1456 2412 2407 2396 2 1 ND2S $T=859320 719160 0 180 $X=857460 $Y=713740
X1457 2482 2491 2460 2 1 ND2S $T=896520 709080 0 180 $X=894660 $Y=703660
X1458 2508 2504 2491 2 1 ND2S $T=903960 709080 1 180 $X=902100 $Y=708700
X1459 2540 2541 2550 2 1 ND2S $T=916360 739320 1 0 $X=916360 $Y=733900
X1460 2521 2540 2555 2 1 ND2S $T=916360 739320 0 0 $X=916360 $Y=738940
X1461 566 574 567 2 1 ND2S $T=920080 779640 0 180 $X=918220 $Y=774220
X1462 2555 2520 2550 2 1 ND2S $T=922560 739320 0 0 $X=922560 $Y=738940
X1463 578 579 576 2 1 ND2S $T=930000 648600 0 180 $X=928140 $Y=643180
X1464 2557 2574 2550 2 1 ND2S $T=930000 739320 1 180 $X=928140 $Y=738940
X1465 2574 2583 2555 2 1 ND2S $T=931240 739320 1 0 $X=931240 $Y=733900
X1466 2573 2550 2588 2 1 ND2S $T=936820 739320 1 0 $X=936820 $Y=733900
X1467 581 2594 576 2 1 ND2S $T=939300 648600 1 180 $X=937440 $Y=648220
X1468 2642 2620 2631 2 1 ND2S $T=957900 688920 1 0 $X=957900 $Y=683500
X1469 2228 2631 2641 2 1 ND2S $T=963480 688920 0 0 $X=963480 $Y=688540
X1470 839 828 1 849 832 2 OAI12H $T=305660 688920 0 0 $X=305660 $Y=688540
X1471 959 893 1 946 918 2 OAI12H $T=354020 769560 0 180 $X=347820 $Y=764140
X1472 428 430 1 432 434 2 OAI12H $T=768800 648600 1 0 $X=768800 $Y=643180
X1473 451 448 1 447 2252 2 OAI12H $T=794220 648600 0 180 $X=788020 $Y=643180
X1474 2282 2298 1 2304 2325 2 OAI12H $T=815300 668760 1 0 $X=815300 $Y=663340
X1475 2333 2321 1 2341 2351 2 OAI12H $T=831420 688920 1 0 $X=831420 $Y=683500
X1476 835 789 2 828 842 1 AOI12H $T=304420 688920 1 0 $X=304420 $Y=683500
X1477 932 918 2 81 938 1 AOI12H $T=348440 779640 1 0 $X=348440 $Y=774220
X1478 2283 2252 2 2298 2280 1 AOI12H $T=804140 648600 0 0 $X=804140 $Y=648220
X1479 2326 2325 2 2321 2317 1 AOI12H $T=825840 668760 1 180 $X=819640 $Y=668380
X1480 2371 2351 2 2373 2384 1 AOI12H $T=846300 678840 0 0 $X=846300 $Y=678460
X1481 711 707 687 2 1 XOR2HS $T=254200 729240 1 180 $X=248620 $Y=728860
X1482 723 732 707 2 1 XOR2HS $T=262260 729240 0 0 $X=262260 $Y=728860
X1483 763 746 768 2 1 XOR2HS $T=274040 739320 0 0 $X=274040 $Y=738940
X1484 775 771 757 2 1 XOR2HS $T=281480 699000 1 180 $X=275900 $Y=698620
X1485 850 847 840 2 1 XOR2HS $T=311240 759480 0 180 $X=305660 $Y=754060
X1486 866 862 854 2 1 XOR2HS $T=317440 729240 1 180 $X=311860 $Y=728860
X1487 879 862 872 2 1 XOR2HS $T=322400 749400 0 180 $X=316820 $Y=743980
X1488 880 893 897 2 1 XOR2HS $T=324260 769560 1 0 $X=324260 $Y=764140
X1489 907 904 784 2 1 XOR2HS $T=335420 709080 1 180 $X=329840 $Y=708700
X1490 915 913 873 2 1 XOR2HS $T=337900 769560 1 180 $X=332320 $Y=769180
X1491 1020 1017 97 2 1 XOR2HS $T=378200 759480 0 180 $X=372620 $Y=754060
X1492 1078 1076 114 2 1 XOR2HS $T=398040 759480 1 180 $X=392460 $Y=759100
X1493 1109 1107 1098 2 1 XOR2HS $T=409200 779640 0 180 $X=403620 $Y=774220
X1494 2311 2298 2316 2 1 XOR2HS $T=815300 658680 1 0 $X=815300 $Y=653260
X1495 2340 2321 2345 2 1 XOR2HS $T=832040 668760 0 0 $X=832040 $Y=668380
X1496 2369 2373 2381 2 1 XOR2HS $T=845680 688920 0 0 $X=845680 $Y=688540
X1497 756 733 720 2 1 XNR2HS $T=274660 739320 0 180 $X=269080 $Y=733900
X1498 764 762 754 2 1 XNR2HS $T=276520 688920 0 180 $X=270940 $Y=683500
X1499 783 779 749 2 1 XNR2HS $T=283340 699000 0 180 $X=277760 $Y=693580
X1500 799 796 32 2 1 XNR2HS $T=290160 709080 0 180 $X=284580 $Y=703660
X1501 819 816 750 2 1 XNR2HS $T=296980 688920 1 180 $X=291400 $Y=688540
X1502 850 859 852 2 1 XNR2HS $T=315580 769560 0 180 $X=310000 $Y=764140
X1503 880 876 812 2 1 XNR2HS $T=322400 769560 0 180 $X=316820 $Y=764140
X1504 900 890 47 2 1 XNR2HS $T=332320 739320 0 180 $X=326740 $Y=733900
X1505 915 918 908 2 1 XNR2HS $T=340380 779640 0 180 $X=334800 $Y=774220
X1506 974 973 35 2 1 XNR2HS $T=361460 729240 0 180 $X=355880 $Y=723820
X1507 1010 1000 765 2 1 XNR2HS $T=373240 739320 0 180 $X=367660 $Y=733900
X1508 1021 1018 98 2 1 XNR2HS $T=378820 749400 1 180 $X=373240 $Y=749020
X1509 2285 2252 2310 2 1 XNR2HS $T=811580 648600 0 0 $X=811580 $Y=648220
X1510 2330 2325 2324 2 1 XNR2HS $T=825840 668760 1 0 $X=825840 $Y=663340
X1511 2359 2351 2372 2 1 XNR2HS $T=848160 678840 1 0 $X=848160 $Y=673420
X1512 2386 2382 2391 2 1 XNR2HS $T=850640 699000 1 0 $X=850640 $Y=693580
X1513 2504 2502 2487 2 1 XNR2HS $T=904580 699000 1 180 $X=899000 $Y=698620
X1514 2620 2619 2611 2 1 XNR2HS $T=956040 688920 1 180 $X=950460 $Y=688540
X1515 852 60 2 1 857 840 MUX2 $T=317440 769560 1 180 $X=313100 $Y=769180
X1516 872 60 2 1 57 854 MUX2 $T=318680 749400 1 180 $X=314340 $Y=749020
X1517 874 62 2 1 65 57 MUX2 $T=321160 779640 1 0 $X=321160 $Y=774220
X1518 897 60 2 1 874 812 MUX2 $T=329840 769560 1 180 $X=325500 $Y=769180
X1519 69 60 2 1 67 66 MUX2 $T=329840 779640 0 180 $X=325500 $Y=774220
X1520 908 60 2 1 71 873 MUX2 $T=334180 779640 0 180 $X=329840 $Y=774220
X1521 640 1 2 649 DELB $T=220100 678840 0 0 $X=220100 $Y=678460
X1522 645 1 2 643 DELB $T=221960 658680 0 0 $X=221960 $Y=658300
X1523 641 1 2 648 DELB $T=223200 729240 1 0 $X=223200 $Y=723820
X1524 6 1 2 653 DELB $T=225680 648600 1 0 $X=225680 $Y=643180
X1525 647 1 2 656 DELB $T=226920 709080 0 0 $X=226920 $Y=708700
X1526 659 1 2 678 DELB $T=232500 688920 1 0 $X=232500 $Y=683500
X1527 661 1 2 670 DELB $T=236220 658680 0 0 $X=236220 $Y=658300
X1528 671 1 2 660 DELB $T=236840 668760 0 0 $X=236840 $Y=668380
X1529 673 1 2 667 DELB $T=236840 678840 0 0 $X=236840 $Y=678460
X1530 672 1 2 690 DELB $T=245520 648600 1 0 $X=245520 $Y=643180
X1531 699 1 2 714 DELB $T=248620 709080 1 0 $X=248620 $Y=703660
X1532 702 1 2 22 DELB $T=249860 658680 0 0 $X=249860 $Y=658300
X1533 710 1 2 718 DELB $T=252960 678840 0 0 $X=252960 $Y=678460
X1534 719 1 2 25 DELB $T=256680 648600 0 0 $X=256680 $Y=648220
X1535 706 1 2 708 DELB $T=256680 678840 1 0 $X=256680 $Y=673420
X1536 23 1 2 736 DELB $T=257920 648600 1 0 $X=257920 $Y=643180
X1537 705 1 2 716 DELB $T=257920 678840 0 0 $X=257920 $Y=678460
X1538 730 1 2 722 DELB $T=261020 658680 0 0 $X=261020 $Y=658300
X1539 697 1 2 729 DELB $T=261640 658680 1 0 $X=261640 $Y=653260
X1540 742 1 2 751 DELB $T=265360 668760 1 0 $X=265360 $Y=663340
X1541 743 1 2 752 DELB $T=265360 678840 0 0 $X=265360 $Y=678460
X1542 30 1 2 737 DELB $T=266600 658680 1 0 $X=266600 $Y=653260
X1543 747 1 2 734 DELB $T=267220 688920 0 0 $X=267220 $Y=688540
X1544 748 1 2 735 DELB $T=269080 678840 1 0 $X=269080 $Y=673420
X1545 759 1 2 767 DELB $T=275280 658680 1 0 $X=275280 $Y=653260
X1546 780 1 2 753 DELB $T=282100 668760 1 0 $X=282100 $Y=663340
X1547 781 1 2 778 DELB $T=282100 678840 0 0 $X=282100 $Y=678460
X1548 791 1 2 777 DELB $T=286440 658680 1 0 $X=286440 $Y=653260
X1549 806 1 2 782 DELB $T=291400 749400 1 0 $X=291400 $Y=743980
X1550 807 1 2 817 DELB $T=295740 658680 1 0 $X=295740 $Y=653260
X1551 827 1 2 809 DELB $T=301320 658680 1 0 $X=301320 $Y=653260
X1552 830 1 2 826 DELB $T=302560 719160 0 0 $X=302560 $Y=718780
X1553 831 1 2 843 DELB $T=304420 739320 0 0 $X=304420 $Y=738940
X1554 824 1 2 856 DELB $T=308760 709080 0 0 $X=308760 $Y=708700
X1555 844 1 2 848 DELB $T=308760 759480 0 0 $X=308760 $Y=759100
X1556 836 1 2 846 DELB $T=309380 739320 0 0 $X=309380 $Y=738940
X1557 851 1 2 837 DELB $T=310620 658680 0 0 $X=310620 $Y=658300
X1558 56 1 2 845 DELB $T=313100 648600 0 0 $X=313100 $Y=648220
X1559 858 1 2 861 DELB $T=313720 719160 0 0 $X=313720 $Y=718780
X1560 864 1 2 877 DELB $T=316200 658680 0 0 $X=316200 $Y=658300
X1561 884 1 2 889 DELB $T=323020 648600 1 0 $X=323020 $Y=643180
X1562 887 1 2 895 DELB $T=323020 719160 0 0 $X=323020 $Y=718780
X1563 883 1 2 878 DELB $T=327980 648600 1 0 $X=327980 $Y=643180
X1564 898 1 2 914 DELB $T=331080 658680 0 0 $X=331080 $Y=658300
X1565 906 1 2 74 DELB $T=334180 648600 0 0 $X=334180 $Y=648220
X1566 923 1 2 929 DELB $T=340380 739320 1 0 $X=340380 $Y=733900
X1567 930 1 2 935 DELB $T=342240 709080 1 0 $X=342240 $Y=703660
X1568 931 1 2 965 DELB $T=342240 719160 1 0 $X=342240 $Y=713740
X1569 963 1 2 964 DELB $T=354640 739320 0 0 $X=354640 $Y=738940
X1570 981 1 2 979 DELB $T=361460 759480 0 0 $X=361460 $Y=759100
X1571 1001 1 2 988 DELB $T=369520 779640 1 0 $X=369520 $Y=774220
X1572 100 1 2 108 DELB $T=376340 769560 0 0 $X=376340 $Y=769180
X1573 1029 1 2 1039 DELB $T=380060 759480 1 0 $X=380060 $Y=754060
X1574 1054 1 2 1057 DELB $T=389980 769560 0 0 $X=389980 $Y=769180
X1575 2133 1 2 2153 DELB $T=740900 759480 1 0 $X=740900 $Y=754060
X1576 2178 1 2 2192 DELB $T=756400 749400 1 0 $X=756400 $Y=743980
X1577 2184 1 2 2183 DELB $T=758880 749400 0 0 $X=758880 $Y=749020
X1578 2209 1 2 2208 DELB $T=774380 769560 1 0 $X=774380 $Y=764140
X1579 2219 1 2 2218 DELB $T=775000 739320 0 0 $X=775000 $Y=738940
X1580 2251 1 2 2250 DELB $T=788020 749400 1 0 $X=788020 $Y=743980
X1581 2249 1 2 2248 DELB $T=790500 759480 1 0 $X=790500 $Y=754060
X1582 2265 1 2 2295 DELB $T=804760 759480 1 0 $X=804760 $Y=754060
X1583 698 770 1 2 788 AN2 $T=283960 729240 0 0 $X=283960 $Y=728860
X1584 820 814 1 2 803 AN2 $T=295740 769560 0 180 $X=293260 $Y=764140
X1585 1023 1009 1 2 1003 AN2 $T=372620 729240 0 180 $X=370140 $Y=723820
X1586 1048 1040 1 2 1070 AN2 $T=398660 699000 1 0 $X=398660 $Y=693580
X1587 1476 1463 1 2 1454 AN2 $T=527000 709080 1 180 $X=524520 $Y=708700
X1588 1776 1762 1 2 1763 AN2 $T=621860 769560 1 180 $X=619380 $Y=769180
X1589 1858 1853 1 2 340 AN2 $T=649140 769560 0 180 $X=646660 $Y=764140
X1590 365 339 1 2 1960 AN2 $T=675800 648600 1 0 $X=675800 $Y=643180
X1591 687 684 2 681 1 680 AOI12HS $T=244280 719160 1 180 $X=239940 $Y=718780
X1592 739 720 2 731 1 713 AOI12HS $T=264740 729240 0 180 $X=260400 $Y=723820
X1593 772 761 2 788 1 793 AOI12HS $T=282720 729240 1 0 $X=282720 $Y=723820
X1594 792 794 2 803 1 44 AOI12HS $T=286440 769560 1 0 $X=286440 $Y=764140
X1595 886 882 2 894 1 891 AOI12HS $T=323020 699000 0 0 $X=323020 $Y=698620
X1596 881 859 2 892 1 893 AOI12HS $T=324880 759480 1 0 $X=324880 $Y=754060
X1597 888 905 2 911 1 913 AOI12HS $T=332320 769560 1 0 $X=332320 $Y=764140
X1598 1046 1018 2 1031 1 1017 AOI12HS $T=385640 749400 1 180 $X=381300 $Y=749020
X1599 1088 115 2 1079 1 1076 AOI12HS $T=400520 759480 0 180 $X=396180 $Y=754060
X1600 1105 1079 2 1115 1 131 AOI12HS $T=406720 749400 0 0 $X=406720 $Y=749020
X1601 1120 115 2 1112 1 1107 AOI12HS $T=412300 769560 0 180 $X=407960 $Y=764140
X1602 132 115 2 129 1 134 AOI12HS $T=413540 779640 0 180 $X=409200 $Y=774220
X1603 1135 115 2 1142 1 1127 AOI12HS $T=416640 769560 1 0 $X=416640 $Y=764140
X1604 142 115 2 144 1 146 AOI12HS $T=419740 779640 1 0 $X=419740 $Y=774220
X1605 1187 1164 2 1173 1 1175 AOI12HS $T=432140 769560 0 180 $X=427800 $Y=764140
X1606 732 724 723 1 2 721 OA12 $T=260400 729240 1 180 $X=256680 $Y=728860
X1607 1454 1452 1450 1 2 1442 OA12 $T=523900 739320 0 180 $X=520180 $Y=733900
X1608 1480 1467 1450 1 2 1462 OA12 $T=530100 739320 0 180 $X=526380 $Y=733900
X1609 1688 1633 1725 1 2 1736 OA12 $T=601400 729240 1 0 $X=601400 $Y=723820
X1610 1960 1970 1978 1 2 375 OA12 $T=689440 648600 0 180 $X=685720 $Y=643180
X1611 2009 376 1978 1 2 2016 OA12 $T=695640 668760 1 0 $X=695640 $Y=663340
X1612 2159 2108 2189 1 2 2213 OA12 $T=768800 719160 0 0 $X=768800 $Y=718780
X1613 644 4 5 2 1 16 QDFFRBS $T=221340 779640 1 0 $X=221340 $Y=774220
X1614 929 63 949 2 1 953 QDFFRBS $T=341620 739320 0 0 $X=341620 $Y=738940
X1615 958 63 899 2 1 930 QDFFRBS $T=354020 709080 1 180 $X=342240 $Y=708700
X1616 1041 63 1049 2 1 1071 QDFFRBS $T=384400 719160 1 0 $X=384400 $Y=713740
X1617 1047 63 1074 2 1 1048 QDFFRBS $T=387500 678840 0 0 $X=387500 $Y=678460
X1618 1442 162 205 2 1 213 QDFFRBS $T=519560 779640 0 180 $X=507780 $Y=774220
X1619 408 406 2127 2 1 2150 QDFFRBS $T=730980 759480 0 0 $X=730980 $Y=759100
X1620 2165 384 2169 2 1 2210 QDFFRBS $T=760120 668760 0 0 $X=760120 $Y=668380
X1621 2324 384 472 2 1 2347 QDFFRBS $T=822740 658680 1 0 $X=822740 $Y=653260
X1622 488 406 2342 2 1 514 QDFFRBS $T=829560 749400 1 0 $X=829560 $Y=743980
X1623 495 406 2368 2 1 2365 QDFFRBS $T=835140 739320 1 0 $X=835140 $Y=733900
X1624 2456 433 2462 2 1 2512 QDFFRBS $T=893420 749400 0 0 $X=893420 $Y=749020
X1625 2404 433 2518 2 1 2573 QDFFRBS $T=909540 749400 1 0 $X=909540 $Y=743980
X1626 2604 433 2602 2 1 2572 QDFFRBS $T=952940 678840 1 180 $X=941160 $Y=678460
X1627 2606 433 2625 2 1 2647 QDFFRBS $T=977120 678840 1 180 $X=965340 $Y=678460
X1628 669 1 2 674 BUF1CK $T=235600 699000 1 0 $X=235600 $Y=693580
X1629 676 1 2 679 BUF1CK $T=238080 699000 1 0 $X=238080 $Y=693580
X1630 854 1 2 855 BUF1CK $T=310620 719160 0 0 $X=310620 $Y=718780
X1631 1495 1 2 1543 BUF1CK $T=548080 749400 1 0 $X=548080 $Y=743980
X1632 1803 1 2 327 BUF1CK $T=636120 648600 1 180 $X=633640 $Y=648220
X1633 1594 1 2 1982 BUF1CK $T=683860 709080 1 0 $X=683860 $Y=703660
X1634 1962 1 2 2011 BUF1CK $T=700600 668760 0 0 $X=700600 $Y=668380
X1635 2457 1 2 2438 BUF1CK $T=884120 699000 0 0 $X=884120 $Y=698620
X1636 2548 1 2 2547 BUF1CK $T=921320 699000 1 0 $X=921320 $Y=693580
X1637 2590 1 2 2584 BUF1CK $T=934340 688920 0 0 $X=934340 $Y=688540
X1638 2632 1 2 2623 BUF1CK $T=958520 699000 0 0 $X=958520 $Y=698620
X1639 2636 1 2 2640 BUF1CK $T=961000 668760 1 0 $X=961000 $Y=663340
X1640 2647 1 2 2649 BUF1CK $T=967820 678840 1 0 $X=967820 $Y=673420
X1641 2663 1 2 2661 BUF1CK $T=976500 709080 1 0 $X=976500 $Y=703660
X1642 61 3 1 2 INV12CK $T=321160 759480 0 180 $X=311240 $Y=754060
X1643 61 63 1 2 INV12CK $T=363320 769560 0 0 $X=363320 $Y=769180
X1644 560 433 1 2 INV12CK $T=906440 729240 0 180 $X=896520 $Y=723820
X1645 26 727 744 1 2 ND2 $T=265980 769560 1 0 $X=265980 $Y=764140
X1646 800 24 771 1 2 ND2 $T=288920 709080 0 0 $X=288920 $Y=708700
X1647 818 823 835 1 2 ND2 $T=301320 678840 0 0 $X=301320 $Y=678460
X1648 838 863 834 1 2 ND2 $T=306900 699000 1 180 $X=305040 $Y=698620
X1649 832 860 834 1 2 ND2 $T=311240 709080 1 0 $X=311240 $Y=703660
X1650 865 805 867 1 2 ND2 $T=316200 678840 1 0 $X=316200 $Y=673420
X1651 870 815 875 1 2 ND2 $T=317440 699000 0 0 $X=317440 $Y=698620
X1652 866 888 871 1 2 ND2 $T=323020 739320 0 180 $X=321160 $Y=733900
X1653 885 868 64 1 2 ND2 $T=323020 678840 1 0 $X=323020 $Y=673420
X1654 68 797 70 1 2 ND2 $T=329220 668760 0 0 $X=329220 $Y=668380
X1655 919 881 912 1 2 ND2 $T=342240 749400 0 0 $X=342240 $Y=749020
X1656 982 932 986 1 2 ND2 $T=361460 779640 1 0 $X=361460 $Y=774220
X1657 1947 1959 1878 1 2 ND2 $T=685100 719160 0 0 $X=685100 $Y=718780
X1658 379 2024 377 1 2 ND2 $T=697500 759480 1 180 $X=695640 $Y=759100
X1659 379 393 2077 1 2 ND2 $T=716100 779640 1 0 $X=716100 $Y=774220
X1660 400 402 398 1 2 ND2 $T=722920 769560 0 180 $X=721060 $Y=764140
X1661 394 411 416 1 2 ND2 $T=741520 769560 0 0 $X=741520 $Y=769180
X1662 740 19 1 744 2 763 OAI12HS $T=272180 749400 1 0 $X=272180 $Y=743980
X1663 766 760 1 755 2 761 OAI12HS $T=276520 719160 1 180 $X=272800 $Y=718780
X1664 790 771 1 773 2 762 OAI12HS $T=283340 688920 0 180 $X=279620 $Y=683500
X1665 787 793 1 798 2 794 OAI12HS $T=286440 749400 1 0 $X=286440 $Y=743980
X1666 795 771 1 805 2 779 OAI12HS $T=287680 688920 1 0 $X=287680 $Y=683500
X1667 821 815 1 810 2 796 OAI12HS $T=296980 709080 0 180 $X=293260 $Y=703660
X1668 823 771 1 828 2 816 OAI12HS $T=299460 688920 0 0 $X=299460 $Y=688540
X1669 805 813 1 797 2 789 OAI12HS $T=302560 668760 0 0 $X=302560 $Y=668380
X1670 892 847 1 881 2 876 OAI12HS $T=324880 759480 0 180 $X=321160 $Y=754060
X1671 881 921 1 925 2 911 OAI12HS $T=338520 759480 1 0 $X=338520 $Y=754060
X1672 938 913 1 932 2 77 OAI12HS $T=345960 779640 0 180 $X=342240 $Y=774220
X1673 1005 987 1 985 2 973 OAI12HS $T=365800 719160 0 180 $X=362080 $Y=713740
X1674 1053 1084 1 1077 2 1079 OAI12HS $T=400520 739320 1 180 $X=396800 $Y=738940
X1675 1100 1106 1 1090 2 1112 OAI12HS $T=406100 759480 0 0 $X=406100 $Y=759100
X1676 1090 1119 1 1125 2 1115 OAI12HS $T=411060 749400 1 0 $X=411060 $Y=743980
X1677 1148 131 1 1157 2 1142 OAI12HS $T=421600 759480 1 0 $X=421600 $Y=754060
X1678 1141 131 1 1175 2 144 OAI12HS $T=427800 779640 1 0 $X=427800 $Y=774220
X1679 1737 1715 1 1745 2 308 OAI12HS $T=618140 739320 0 0 $X=618140 $Y=738940
X1680 1834 1858 1 350 2 344 OAI12HS $T=654720 779640 1 0 $X=654720 $Y=774220
X1681 2174 2236 1 2258 2 2277 OAI12HS $T=799180 729240 1 0 $X=799180 $Y=723820
X1682 2361 2373 1 2357 2 2382 OAI12HS $T=845060 699000 1 0 $X=845060 $Y=693580
X1683 2510 2528 1 2491 2 2530 OAI12HS $T=913260 709080 0 0 $X=913260 $Y=708700
X1684 745 1 749 720 704 739 2 OAI22S $T=271560 729240 0 180 $X=267840 $Y=723820
X1685 909 1 903 909 902 901 2 OAI22S $T=337280 699000 0 180 $X=333560 $Y=693580
X1686 954 1 942 954 951 941 2 OAI22S $T=352780 658680 1 180 $X=349060 $Y=658300
X1687 1059 1 1068 1059 1041 1087 2 OAI22S $T=392460 719160 0 0 $X=392460 $Y=718780
X1688 1066 1 1069 1066 1047 1083 2 OAI22S $T=393080 678840 1 0 $X=393080 $Y=673420
X1689 1212 1 1211 1212 1209 1204 2 OAI22S $T=444540 759480 1 180 $X=440820 $Y=759100
X1690 1225 1 1207 1225 1223 1203 2 OAI22S $T=448260 749400 0 180 $X=444540 $Y=743980
X1691 191 1 192 191 1315 189 2 OAI22S $T=481740 648600 0 180 $X=478020 $Y=643180
X1692 1330 1 1334 1330 1338 1343 2 OAI22S $T=481120 739320 1 0 $X=481120 $Y=733900
X1693 1404 1 211 1404 1401 1383 2 OAI22S $T=507160 658680 1 180 $X=503440 $Y=658300
X1694 1468 1 1469 1468 1407 1462 2 OAI22S $T=528860 759480 0 180 $X=525140 $Y=754060
X1695 1502 1 1507 1502 1498 1514 2 OAI22S $T=535680 759480 1 0 $X=535680 $Y=754060
X1696 1663 1 1667 1663 1672 1677 2 OAI22S $T=589000 759480 1 180 $X=585280 $Y=759100
X1697 1714 1 1731 1714 1739 1480 2 OAI22S $T=608840 739320 0 0 $X=608840 $Y=738940
X1698 1821 1 1823 1821 1817 1809 2 OAI22S $T=642320 729240 0 180 $X=638600 $Y=723820
X1699 1843 1 1882 1843 1887 1864 2 OAI22S $T=654100 709080 0 0 $X=654100 $Y=708700
X1700 1950 1 1953 1950 1941 1959 2 OAI22S $T=676420 719160 1 0 $X=676420 $Y=713740
X1701 2001 1 1996 2001 2007 2016 2 OAI22S $T=693160 658680 1 0 $X=693160 $Y=653260
X1702 2030 1 2040 2030 2050 2009 2 OAI22S $T=704320 709080 1 0 $X=704320 $Y=703660
X1703 2054 1 1997 2054 2053 2052 2 OAI22S $T=711140 668760 0 180 $X=707420 $Y=663340
X1704 418 1 2164 418 2166 2136 2 OAI22S $T=754540 769560 1 180 $X=750820 $Y=769180
X1705 2177 1 2173 2177 2176 2097 2 OAI22S $T=758880 699000 1 180 $X=755160 $Y=698620
X1706 2564 1 577 2564 2567 582 2 OAI22S $T=925660 779640 1 0 $X=925660 $Y=774220
X1707 581 1 576 583 585 2594 2 OAI22S $T=934960 648600 1 0 $X=934960 $Y=643180
X1708 1341 1339 1335 1331 1 2 1324 AO13S $T=485460 719160 1 180 $X=481120 $Y=718780
X1709 1610 1592 1580 1595 1 2 1631 AO13S $T=565440 648600 1 0 $X=565440 $Y=643180
X1710 1793 1525 1796 1791 1 2 1810 AO13S $T=631160 709080 0 0 $X=631160 $Y=708700
X1711 765 35 758 740 1 757 2 AOI22S $T=275280 759480 0 0 $X=275280 $Y=759100
X1712 744 774 726 740 1 750 2 AOI22S $T=279000 749400 1 0 $X=279000 $Y=743980
X1713 167 1167 1331 1197 1 1335 2 AOI22S $T=482360 719160 1 0 $X=482360 $Y=713740
X1714 1497 1508 1507 1457 1 1515 2 AOI22S $T=536300 709080 1 0 $X=536300 $Y=703660
X1715 1500 1508 1469 1510 1 1513 2 AOI22S $T=536300 719160 0 0 $X=536300 $Y=718780
X1716 1525 1508 1518 1263 1 1546 2 AOI22S $T=541260 699000 0 0 $X=541260 $Y=698620
X1717 1501 1496 1514 1534 1 1536 2 AOI22S $T=542500 749400 1 0 $X=542500 $Y=743980
X1718 1501 1496 1529 1536 1 1540 2 AOI22S $T=542500 749400 0 0 $X=542500 $Y=749020
X1719 1457 1509 1535 1379 1 1444 2 AOI22S $T=543740 729240 1 0 $X=543740 $Y=723820
X1720 1501 1496 1582 1540 1 1567 2 AOI22S $T=556760 749400 0 180 $X=553040 $Y=743980
X1721 1524 1571 1559 1575 1 1577 2 AOI22S $T=554280 729240 1 0 $X=554280 $Y=723820
X1722 1524 1571 1579 1577 1 1566 2 AOI22S $T=556760 719160 0 0 $X=556760 $Y=718780
X1723 1592 256 1595 258 1 1580 2 AOI22S $T=561100 648600 1 0 $X=561100 $Y=643180
X1724 1525 1508 1614 236 1 1606 2 AOI22S $T=567920 699000 0 180 $X=564200 $Y=693580
X1725 1501 1496 1615 1567 1 1608 2 AOI22S $T=567920 749400 1 180 $X=564200 $Y=749020
X1726 1627 1496 1619 1608 1 1634 2 AOI22S $T=571020 749400 1 0 $X=571020 $Y=743980
X1727 1633 1571 1635 1566 1 1658 2 AOI22S $T=573500 719160 1 0 $X=573500 $Y=713740
X1728 1609 1642 1639 1645 1 1558 2 AOI22S $T=574740 739320 0 0 $X=574740 $Y=738940
X1729 1626 160 1678 1379 1 1650 2 AOI22S $T=582180 729240 1 180 $X=578460 $Y=728860
X1730 1633 1571 1652 1658 1 1665 2 AOI22S $T=580320 709080 0 0 $X=580320 $Y=708700
X1731 1633 1688 1684 1665 1 1686 2 AOI22S $T=593340 709080 1 180 $X=589620 $Y=708700
X1732 1609 1642 1697 1535 1 1689 2 AOI22S $T=593960 739320 1 180 $X=590240 $Y=738940
X1733 1633 1688 1690 1686 1 1728 2 AOI22S $T=593960 719160 0 0 $X=593960 $Y=718780
X1734 1609 1642 1701 1689 1 1707 2 AOI22S $T=594580 729240 0 0 $X=594580 $Y=728860
X1735 1715 1642 1718 1707 1 1729 2 AOI22S $T=600780 739320 1 0 $X=600780 $Y=733900
X1736 1633 1688 1724 1728 1 1725 2 AOI22S $T=602640 719160 1 0 $X=602640 $Y=713740
X1737 1715 1737 1721 1729 1 1678 2 AOI22S $T=608220 729240 0 0 $X=608220 $Y=728860
X1738 1737 1715 297 1745 1 1678 2 AOI22S $T=608220 739320 1 0 $X=608220 $Y=733900
X1739 1525 1753 1791 310 1 1796 2 AOI22S $T=629920 699000 0 0 $X=629920 $Y=698620
X1740 1915 1930 1829 363 1 316 2 AOI22S $T=668980 779640 1 0 $X=668980 $Y=774220
X1741 1979 1973 1981 1653 1 1968 2 AOI22S $T=686960 688920 0 180 $X=683240 $Y=683500
X1742 1979 1973 1996 1804 1 1965 2 AOI22S $T=692540 658680 0 180 $X=688820 $Y=653260
X1743 1979 1973 1997 382 1 1990 2 AOI22S $T=693780 658680 1 180 $X=690060 $Y=658300
X1744 1979 1973 2004 291 1 1993 2 AOI22S $T=694400 668760 1 180 $X=690680 $Y=668380
X1745 382 2010 2032 2038 1 1787 2 AOI22S $T=702460 719160 1 0 $X=702460 $Y=713740
X1746 2048 2026 2052 2044 1 2019 2 AOI22S $T=707420 668760 1 180 $X=703700 $Y=668380
X1747 2048 2026 2100 2069 1 2065 2 AOI22S $T=715480 678840 0 180 $X=711760 $Y=673420
X1748 2048 2026 2083 2019 1 2069 2 AOI22S $T=716100 668760 1 180 $X=712380 $Y=668380
X1749 2035 2078 2076 2057 1 2066 2 AOI22S $T=714240 699000 1 0 $X=714240 $Y=693580
X1750 2048 2026 2073 2065 1 2057 2 AOI22S $T=715480 688920 1 0 $X=715480 $Y=683500
X1751 1995 2014 2102 2113 1 2101 2 AOI22S $T=729120 709080 1 0 $X=729120 $Y=703660
X1752 1995 2014 2114 2117 1 2113 2 AOI22S $T=730360 709080 0 0 $X=730360 $Y=708700
X1753 2108 2014 2129 2101 1 2143 2 AOI22S $T=735940 699000 0 0 $X=735940 $Y=698620
X1754 2055 2135 2125 2140 1 2031 2 AOI22S $T=737800 719160 0 0 $X=737800 $Y=718780
X1755 2108 2159 2149 2143 1 2175 2 AOI22S $T=746480 709080 1 0 $X=746480 $Y=703660
X1756 1994 309 2163 2038 1 2130 2 AOI22S $T=748960 729240 1 0 $X=748960 $Y=723820
X1757 2108 2159 2196 2175 1 2191 2 AOI22S $T=763840 709080 1 180 $X=760120 $Y=708700
X1758 2157 2174 2197 2032 1 2195 2 AOI22S $T=765080 719160 1 180 $X=761360 $Y=718780
X1759 2108 2159 2203 2170 1 2189 2 AOI22S $T=765700 719160 0 180 $X=761980 $Y=713740
X1760 2108 2159 2212 2191 1 2170 2 AOI22S $T=770040 709080 1 180 $X=766320 $Y=708700
X1761 2157 2174 2224 2195 1 2206 2 AOI22S $T=773140 729240 0 180 $X=769420 $Y=723820
X1762 2236 2174 2235 2240 1 2163 2 AOI22S $T=782440 729240 0 0 $X=782440 $Y=728860
X1763 2236 2174 2255 2206 1 2240 2 AOI22S $T=786160 739320 0 180 $X=782440 $Y=733900
X1764 2174 2236 2270 2258 1 2163 2 AOI22S $T=795460 729240 0 180 $X=791740 $Y=723820
X1765 492 494 502 2339 1 490 2 AOI22S $T=842580 648600 1 180 $X=838860 $Y=648220
X1766 492 2150 2364 2347 1 2339 2 AOI22S $T=842580 658680 0 180 $X=838860 $Y=653260
X1767 485 507 2387 506 1 2364 2 AOI22S $T=849400 648600 1 180 $X=845680 $Y=648220
X1768 2375 2358 2389 2380 1 2347 2 AOI22S $T=851260 658680 1 180 $X=847540 $Y=658300
X1769 2383 502 2403 506 1 2389 2 AOI22S $T=856220 658680 0 180 $X=852500 $Y=653260
X1770 2383 2364 510 506 1 2398 2 AOI22S $T=853120 648600 0 0 $X=853120 $Y=648220
X1771 2375 2358 2398 2394 1 2380 2 AOI22S $T=858080 658680 1 180 $X=854360 $Y=658300
X1772 518 519 516 520 1 2387 2 AOI22S $T=857460 648600 1 0 $X=857460 $Y=643180
X1773 2383 2389 523 2390 1 2408 2 AOI22S $T=859940 648600 0 0 $X=859940 $Y=648220
X1774 2375 2358 2408 2405 1 2394 2 AOI22S $T=864280 658680 1 180 $X=860560 $Y=658300
X1775 2375 2358 2415 2426 1 2405 2 AOI22S $T=864280 668760 0 0 $X=864280 $Y=668380
X1776 2421 2398 533 2390 1 2415 2 AOI22S $T=871100 658680 1 180 $X=867380 $Y=658300
X1777 2431 510 535 2414 1 528 2 AOI22S $T=871720 648600 0 180 $X=868000 $Y=643180
X1778 2421 2415 528 2390 1 2428 2 AOI22S $T=868620 658680 1 0 $X=868620 $Y=653260
X1779 2441 2409 2436 2419 1 2426 2 AOI22S $T=874820 668760 1 180 $X=871100 $Y=668380
X1780 2431 2387 539 2414 1 533 2 AOI22S $T=877920 648600 0 180 $X=874200 $Y=643180
X1781 2421 2408 540 2437 1 2436 2 AOI22S $T=877920 658680 1 180 $X=874200 $Y=658300
X1782 2441 2409 2428 2433 1 2419 2 AOI22S $T=877920 678840 0 180 $X=874200 $Y=673420
X1783 2441 2409 2461 2446 1 2433 2 AOI22S $T=881640 668760 1 180 $X=877920 $Y=668380
X1784 2421 2428 2447 2437 1 2449 2 AOI22S $T=878540 658680 1 0 $X=878540 $Y=653260
X1785 2414 2448 542 540 1 2403 2 AOI22S $T=883500 648600 1 180 $X=879780 $Y=648220
X1786 2441 2409 2449 2453 1 2446 2 AOI22S $T=884740 678840 0 180 $X=881020 $Y=673420
X1787 2455 2436 2472 2437 1 2461 2 AOI22S $T=887840 668760 1 180 $X=884120 $Y=668380
X1788 2448 2447 546 2414 1 2466 2 AOI22S $T=885360 658680 1 0 $X=885360 $Y=653260
X1789 2421 2449 544 2437 1 2477 2 AOI22S $T=885360 668760 1 0 $X=885360 $Y=663340
X1790 2441 2409 2476 2468 1 2453 2 AOI22S $T=891560 678840 0 180 $X=887840 $Y=673420
X1791 2455 2477 2466 2437 1 2499 2 AOI22S $T=890940 658680 0 0 $X=890940 $Y=658300
X1792 2455 2461 2483 2478 1 2476 2 AOI22S $T=894660 668760 1 180 $X=890940 $Y=668380
X1793 2486 2481 2477 2480 1 2468 2 AOI22S $T=895280 678840 1 180 $X=891560 $Y=678460
X1794 2448 2466 548 2479 1 2484 2 AOI22S $T=892180 648600 0 0 $X=892180 $Y=648220
X1795 2448 2472 555 2479 1 2489 2 AOI22S $T=897760 658680 1 0 $X=897760 $Y=653260
X1796 2455 2476 2489 2478 1 2503 2 AOI22S $T=897760 668760 0 0 $X=897760 $Y=668380
X1797 2486 2481 2503 2492 1 2480 2 AOI22S $T=901480 678840 0 180 $X=897760 $Y=673420
X1798 2507 2496 557 2479 1 2493 2 AOI22S $T=902100 648600 0 180 $X=898380 $Y=643180
X1799 2448 544 556 2479 1 2496 2 AOI22S $T=898380 648600 0 0 $X=898380 $Y=648220
X1800 2497 2499 2496 2478 1 2501 2 AOI22S $T=900240 668760 1 0 $X=900240 $Y=663340
X1801 2455 2503 2506 2478 1 2529 2 AOI22S $T=904580 668760 0 0 $X=904580 $Y=668380
X1802 2486 2481 2499 2516 1 2492 2 AOI22S $T=904580 678840 0 0 $X=904580 $Y=678460
X1803 2507 2515 565 2483 1 2506 2 AOI22S $T=908920 648600 0 180 $X=905200 $Y=643180
X1804 2489 2511 558 2507 1 2479 2 AOI22S $T=905200 658680 0 0 $X=905200 $Y=658300
X1805 2486 2481 2529 2526 1 2516 2 AOI22S $T=914500 678840 0 180 $X=910780 $Y=673420
X1806 2536 2529 2511 2478 1 2527 2 AOI22S $T=915120 668760 1 180 $X=911400 $Y=668380
X1807 2525 2506 568 2515 1 2535 2 AOI22S $T=912020 648600 0 0 $X=912020 $Y=648220
X1808 2525 2484 2531 2515 1 2576 2 AOI22S $T=912640 658680 1 0 $X=912640 $Y=653260
X1809 2497 2501 2484 2549 1 2545 2 AOI22S $T=916360 668760 1 0 $X=916360 $Y=663340
X1810 2486 2481 2501 2552 1 2526 2 AOI22S $T=916980 678840 1 0 $X=916980 $Y=673420
X1811 2507 2511 572 2515 1 2559 2 AOI22S $T=919460 658680 0 0 $X=919460 $Y=658300
X1812 2536 2527 2535 2549 1 2566 2 AOI22S $T=923180 668760 1 0 $X=923180 $Y=663340
X1813 2536 2566 2559 2549 1 2571 2 AOI22S $T=926280 658680 0 0 $X=926280 $Y=658300
X1814 2568 2562 2527 2572 1 2552 2 AOI22S $T=927520 678840 1 0 $X=927520 $Y=673420
X1815 2536 2545 2493 2549 1 2586 2 AOI22S $T=931860 668760 0 0 $X=931860 $Y=668380
X1816 2536 2586 2576 2549 1 2589 2 AOI22S $T=932480 668760 1 0 $X=932480 $Y=663340
X1817 2568 2562 2545 2591 1 2572 2 AOI22S $T=934340 678840 1 0 $X=934340 $Y=673420
X1818 2568 2562 2589 2585 1 2592 2 AOI22S $T=940540 658680 0 0 $X=940540 $Y=658300
X1819 2568 2562 2566 2598 1 2591 2 AOI22S $T=941780 668760 0 0 $X=941780 $Y=668380
X1820 2568 2562 2571 2592 1 2617 2 AOI22S $T=949840 658680 0 0 $X=949840 $Y=658300
X1821 2568 2562 2586 2617 1 2598 2 AOI22S $T=952320 668760 0 0 $X=952320 $Y=668380
X1822 78 867 1 2 BUF2 $T=341620 668760 1 180 $X=338520 $Y=668380
X1823 159 885 1 2 BUF2 $T=434620 658680 1 180 $X=431520 $Y=658300
X1824 305 1785 1 2 BUF2 $T=622480 648600 0 0 $X=622480 $Y=648220
X1825 1982 1962 1 2 BUF2 $T=687580 709080 1 0 $X=687580 $Y=703660
X1826 868 842 1 2 INV2 $T=310000 678840 1 180 $X=308140 $Y=678460
X1827 85 68 1 2 INV2 $T=357120 678840 0 180 $X=355260 $Y=673420
X1828 1051 865 1 2 INV2 $T=389980 678840 0 180 $X=388120 $Y=673420
X1829 1034 1015 1 2 INV2 $T=397420 729240 0 0 $X=397420 $Y=728860
X1830 167 1366 1 2 INV2 $T=492280 709080 1 0 $X=492280 $Y=703660
X1831 1366 1525 1 2 INV2 $T=535060 699000 0 0 $X=535060 $Y=698620
X1832 190 1591 1 2 INV2 $T=557380 719160 1 0 $X=557380 $Y=713740
X1833 248 301 1 2 INV2 $T=630540 658680 1 0 $X=630540 $Y=653260
X1834 270 320 1 2 INV2 $T=642940 759480 1 0 $X=642940 $Y=754060
X1835 311 324 1 2 INV2 $T=646660 759480 1 0 $X=646660 $Y=754060
X1836 320 352 1 2 INV2 $T=662160 779640 0 180 $X=660300 $Y=774220
X1837 248 1956 1 2 INV2 $T=678900 658680 1 0 $X=678900 $Y=653260
X1838 1979 372 1 2 INV2 $T=686340 678840 0 180 $X=684480 $Y=673420
X1839 1913 1979 1 2 INV2 $T=685720 699000 1 0 $X=685720 $Y=693580
X1840 2009 2035 1 2 INV2 $T=705560 699000 0 0 $X=705560 $Y=698620
X1841 390 396 1 2 INV2 $T=712380 769560 0 0 $X=712380 $Y=769180
X1842 909 927 1 909 927 937 2 MOAI1S $T=341000 699000 1 0 $X=341000 $Y=693580
X1843 916 934 1 916 934 927 2 MOAI1S $T=344100 678840 0 0 $X=344100 $Y=678460
X1844 928 943 1 928 943 950 2 MOAI1S $T=347200 668760 0 0 $X=347200 $Y=668380
X1845 948 945 1 948 945 939 2 MOAI1S $T=352160 699000 0 180 $X=348440 $Y=693580
X1846 1082 1110 1 1082 1110 1101 2 MOAI1S $T=414160 668760 0 180 $X=410440 $Y=663340
X1847 1133 1138 1 1133 1138 1163 2 MOAI1S $T=417260 729240 0 0 $X=417260 $Y=728860
X1848 1154 1151 1 1154 1151 1150 2 MOAI1S $T=425940 668760 1 180 $X=422220 $Y=668380
X1849 1168 1162 1 1168 1162 1154 2 MOAI1S $T=429660 658680 1 180 $X=425940 $Y=658300
X1850 1158 1166 1 1158 1166 1161 2 MOAI1S $T=429660 739320 1 180 $X=425940 $Y=738940
X1851 1202 1200 1 1202 1200 1191 2 MOAI1S $T=442060 719160 1 180 $X=438340 $Y=718780
X1852 1206 1205 1 1206 1205 1176 2 MOAI1S $T=443300 668760 0 180 $X=439580 $Y=663340
X1853 1217 1218 1 1217 1218 1202 2 MOAI1S $T=448260 719160 1 180 $X=444540 $Y=718780
X1854 1279 1277 1 1279 1277 1273 2 MOAI1S $T=468100 648600 1 180 $X=464380 $Y=648220
X1855 1478 1299 1 1478 1299 1476 2 MOAI1S $T=531960 719160 0 180 $X=528240 $Y=713740
X1856 1495 1496 1 1489 1485 1488 2 MOAI1S $T=535060 749400 0 180 $X=531340 $Y=743980
X1857 1103 1453 1 1509 1453 1513 2 MOAI1S $T=535680 729240 1 0 $X=535680 $Y=723820
X1858 1495 1506 1 1495 1506 1534 2 MOAI1S $T=535680 739320 0 0 $X=535680 $Y=738940
X1859 241 1453 1 241 1453 1515 2 MOAI1S $T=546220 709080 0 180 $X=542500 $Y=703660
X1860 1478 1482 1 1478 1482 1577 2 MOAI1S $T=544360 719160 0 0 $X=544360 $Y=718780
X1861 1495 1510 1 1543 1510 1536 2 MOAI1S $T=548700 739320 1 180 $X=544980 $Y=738940
X1862 1379 1510 1 1379 1510 1558 2 MOAI1S $T=546220 739320 1 0 $X=546220 $Y=733900
X1863 1312 1551 1 1312 1551 1524 2 MOAI1S $T=548700 719160 1 0 $X=548700 $Y=713740
X1864 1557 1556 1 1557 1556 1546 2 MOAI1S $T=553040 709080 0 180 $X=549320 $Y=703660
X1865 1509 1482 1 1509 1482 1566 2 MOAI1S $T=550560 729240 1 0 $X=550560 $Y=723820
X1866 1509 1384 1 1509 1384 1540 2 MOAI1S $T=551800 739320 1 0 $X=551800 $Y=733900
X1867 1539 1584 1 1539 1584 1575 2 MOAI1S $T=562960 729240 1 180 $X=559240 $Y=728860
X1868 1594 1556 1 1594 1556 1608 2 MOAI1S $T=561100 709080 0 0 $X=561100 $Y=708700
X1869 1588 1598 1 1588 1598 1601 2 MOAI1S $T=561720 739320 0 0 $X=561720 $Y=738940
X1870 1508 1556 1 1311 1607 1598 2 MOAI1S $T=562340 709080 1 0 $X=562340 $Y=703660
X1871 1564 1603 1 1564 1603 1567 2 MOAI1S $T=566680 739320 0 180 $X=562960 $Y=733900
X1872 1613 245 1 1613 245 1606 2 MOAI1S $T=569160 688920 1 180 $X=565440 $Y=688540
X1873 1623 1621 1 1623 1621 1617 2 MOAI1S $T=572880 719160 1 180 $X=569160 $Y=718780
X1874 1613 1555 1 1613 1555 1607 2 MOAI1S $T=573500 699000 1 180 $X=569780 $Y=698620
X1875 1508 1626 1 1311 1630 1621 2 MOAI1S $T=569780 709080 1 0 $X=569780 $Y=703660
X1876 1539 1444 1 1539 1444 1645 2 MOAI1S $T=571640 739320 1 0 $X=571640 $Y=733900
X1877 1613 259 1 1613 259 1630 2 MOAI1S $T=576600 699000 0 0 $X=576600 $Y=698620
X1878 1564 1583 1 1564 1583 1658 2 MOAI1S $T=576600 709080 1 0 $X=576600 $Y=703660
X1879 1646 1603 1 1646 1603 1634 2 MOAI1S $T=585280 729240 0 180 $X=581560 $Y=723820
X1880 1620 1583 1 1620 1675 1665 2 MOAI1S $T=582800 709080 1 0 $X=582800 $Y=703660
X1881 1657 1634 1 1480 1676 1677 2 MOAI1S $T=582800 749400 1 0 $X=582800 $Y=743980
X1882 1603 1626 1 1603 1626 1676 2 MOAI1S $T=586520 729240 0 0 $X=586520 $Y=728860
X1883 1646 1675 1 1646 1675 1686 2 MOAI1S $T=590240 709080 1 0 $X=590240 $Y=703660
X1884 1564 1650 1 1564 1650 1689 2 MOAI1S $T=590860 729240 1 0 $X=590860 $Y=723820
X1885 1620 1702 1 1620 1702 1707 2 MOAI1S $T=594580 709080 0 0 $X=594580 $Y=708700
X1886 1657 1693 1 1480 1714 1716 2 MOAI1S $T=596440 749400 1 0 $X=596440 $Y=743980
X1887 1519 1626 1 1519 1626 1728 2 MOAI1S $T=599540 709080 1 0 $X=599540 $Y=703660
X1888 1646 1650 1 1646 1727 1729 2 MOAI1S $T=600780 729240 0 0 $X=600780 $Y=728860
X1889 1547 1519 1 1547 1519 1725 2 MOAI1S $T=601400 699000 0 0 $X=601400 $Y=698620
X1890 182 1594 1 182 1594 1731 2 MOAI1S $T=605120 709080 0 0 $X=605120 $Y=708700
X1891 1437 1675 1 1437 1675 1715 2 MOAI1S $T=613800 729240 0 0 $X=613800 $Y=728860
X1892 1759 1727 1 1759 1727 1745 2 MOAI1S $T=620620 739320 0 180 $X=616900 $Y=733900
X1893 1765 1759 1 1765 1759 1714 2 MOAI1S $T=623100 749400 1 180 $X=619380 $Y=749020
X1894 317 1790 1 317 1790 325 2 MOAI1S $T=628060 648600 1 0 $X=628060 $Y=643180
X1895 332 1807 1 332 1807 1767 2 MOAI1S $T=638600 769560 0 180 $X=634880 $Y=764140
X1896 345 344 1 345 344 341 2 MOAI1S $T=649140 779640 0 180 $X=645420 $Y=774220
X1897 1846 1830 1 1846 1830 1868 2 MOAI1S $T=647900 648600 1 0 $X=647900 $Y=643180
X1898 1838 1847 1 1838 1847 1846 2 MOAI1S $T=649140 648600 0 0 $X=649140 $Y=648220
X1899 1890 1896 1 1890 1896 1910 2 MOAI1S $T=660920 648600 0 0 $X=660920 $Y=648220
X1900 1936 1935 1 1936 1935 1922 2 MOAI1S $T=674560 678840 0 180 $X=670840 $Y=673420
X1901 1955 1795 1 1955 1795 1968 2 MOAI1S $T=677660 688920 1 0 $X=677660 $Y=683500
X1902 366 367 1 366 367 1965 2 MOAI1S $T=678280 658680 0 0 $X=678280 $Y=658300
X1903 1969 1854 1 1969 1854 1990 2 MOAI1S $T=685720 668760 1 0 $X=685720 $Y=663340
X1904 1976 1849 1 1976 1849 1993 2 MOAI1S $T=689440 678840 0 0 $X=689440 $Y=678460
X1905 1976 1836 1 1976 1836 2002 2 MOAI1S $T=691300 688920 1 0 $X=691300 $Y=683500
X1906 1814 1769 1 1814 1769 2009 2 MOAI1S $T=692540 688920 0 0 $X=692540 $Y=688540
X1907 1769 1982 1 1769 1982 2040 2 MOAI1S $T=693160 709080 1 0 $X=693160 $Y=703660
X1908 1955 1752 1 1955 1752 2017 2 MOAI1S $T=695020 699000 0 0 $X=695020 $Y=698620
X1909 1973 1849 1 372 2002 2020 2 MOAI1S $T=695640 678840 0 0 $X=695640 $Y=678460
X1910 2011 1804 1 2011 1804 2019 2 MOAI1S $T=696880 668760 0 0 $X=696880 $Y=668380
X1911 1973 1994 1 372 2017 2027 2 MOAI1S $T=696880 688920 1 0 $X=696880 $Y=683500
X1912 1982 1752 1 1982 2022 2030 2 MOAI1S $T=699360 699000 0 0 $X=699360 $Y=698620
X1913 2011 376 1 2011 376 2044 2 MOAI1S $T=701220 668760 1 0 $X=701220 $Y=663340
X1914 1962 2026 1 2037 2043 2042 2 MOAI1S $T=701840 678840 0 0 $X=701840 $Y=678460
X1915 2038 1804 1 2038 1804 2031 2 MOAI1S $T=706180 719160 1 180 $X=702460 $Y=718780
X1916 2034 1849 1 2034 1849 2057 2 MOAI1S $T=704320 688920 0 0 $X=704320 $Y=688540
X1917 1836 2000 1 1836 1964 2066 2 MOAI1S $T=708040 699000 0 0 $X=708040 $Y=698620
X1918 1969 1964 1 2059 1964 2065 2 MOAI1S $T=708660 688920 1 0 $X=708660 $Y=683500
X1919 2078 2072 1 2009 2030 2058 2 MOAI1S $T=714860 709080 0 180 $X=711140 $Y=703660
X1920 2000 1994 1 2000 1994 2084 2 MOAI1S $T=715480 719160 0 0 $X=715480 $Y=718780
X1921 2010 1870 1 2010 1870 2069 2 MOAI1S $T=720440 678840 1 180 $X=716720 $Y=678460
X1922 2078 2066 1 2009 2084 2097 2 MOAI1S $T=717960 709080 1 0 $X=717960 $Y=703660
X1923 2010 2095 1 2010 2095 2101 2 MOAI1S $T=723540 709080 0 0 $X=723540 $Y=708700
X1924 2064 2027 1 2064 2027 2120 2 MOAI1S $T=728500 688920 0 0 $X=728500 $Y=688540
X1925 2003 2095 1 2003 2095 2055 2 MOAI1S $T=730360 719160 0 0 $X=730360 $Y=718780
X1926 2087 2119 1 2087 2119 2117 2 MOAI1S $T=734700 719160 0 180 $X=730980 $Y=713740
X1927 369 2138 1 369 2132 2113 2 MOAI1S $T=740280 709080 1 180 $X=736560 $Y=708700
X1928 2059 2132 1 2059 2132 2143 2 MOAI1S $T=740900 719160 1 0 $X=740900 $Y=713740
X1929 2087 2130 1 2087 2130 2140 2 MOAI1S $T=745860 729240 1 180 $X=742140 $Y=728860
X1930 2123 1994 1 2123 1994 2170 2 MOAI1S $T=747720 719160 1 0 $X=747720 $Y=713740
X1931 1618 2138 1 1618 2138 2175 2 MOAI1S $T=753300 709080 0 0 $X=753300 $Y=708700
X1932 403 2138 1 403 2138 2191 2 MOAI1S $T=754540 719160 1 0 $X=754540 $Y=713740
X1933 329 2123 1 329 2123 2189 2 MOAI1S $T=755160 719160 0 0 $X=755160 $Y=718780
X1934 2059 2130 1 2059 2130 2195 2 MOAI1S $T=762600 729240 0 0 $X=762600 $Y=728860
X1935 1618 2202 1 435 2202 2206 2 MOAI1S $T=776240 739320 1 0 $X=776240 $Y=733900
X1936 2210 2230 1 2210 2230 2238 2 MOAI1S $T=778720 658680 0 0 $X=778720 $Y=658300
X1937 2253 2230 1 2253 2230 2256 2 MOAI1S $T=789260 668760 1 0 $X=789260 $Y=663340
X1938 2022 2202 1 2022 2202 2258 2 MOAI1S $T=789260 739320 0 0 $X=789260 $Y=738940
X1939 403 2202 1 403 2202 2240 2 MOAI1S $T=795460 739320 0 180 $X=791740 $Y=733900
X1940 2343 2344 1 2343 2344 498 2 MOAI1S $T=833280 719160 0 0 $X=833280 $Y=718780
X1941 2521 2520 1 2521 2520 2517 2 MOAI1S $T=912020 739320 1 180 $X=908300 $Y=738940
X1942 566 567 1 566 567 2532 2 MOAI1S $T=910780 779640 1 0 $X=910780 $Y=774220
X1943 2525 2556 1 2525 2493 571 2 MOAI1S $T=925040 648600 0 180 $X=921320 $Y=643180
X1944 2557 2520 1 2557 2520 2544 2 MOAI1S $T=926900 739320 0 180 $X=923180 $Y=733900
X1945 159 1214 1168 153 2 1189 1 AOI13HS $T=441440 658680 1 180 $X=437720 $Y=658300
X1946 1217 1180 1192 1221 2 1222 1 AOI13HS $T=443300 729240 0 0 $X=443300 $Y=728860
X1947 1838 1848 339 323 2 1842 1 AOI13HS $T=649140 658680 1 180 $X=645420 $Y=658300
X1948 948 1 875 957 2 885 ND3 $T=357740 699000 0 180 $X=355260 $Y=693580
X1949 1082 1 1139 1151 2 1097 ND3 $T=417260 668760 1 0 $X=417260 $Y=663340
X1950 1133 1 1108 1145 2 1114 ND3 $T=417880 739320 1 0 $X=417880 $Y=733900
X1951 1177 1 1197 1200 2 1192 ND3 $T=437720 729240 1 0 $X=437720 $Y=723820
X1952 1206 1 176 1281 2 1103 ND3 $T=461900 668760 1 0 $X=461900 $Y=663340
X1953 1467 1 1092 1450 2 1484 ND3 $T=528240 729240 0 0 $X=528240 $Y=728860
X1954 334 1 310 1830 2 339 ND3 $T=638600 648600 0 0 $X=638600 $Y=648220
X1955 1890 1 1878 1891 2 1872 ND3 $T=657200 658680 0 180 $X=654720 $Y=653260
X1956 352 1 348 1819 2 1915 ND3 $T=658440 769560 0 180 $X=655960 $Y=764140
X1957 376 1 1976 1978 2 1971 ND3 $T=686960 658680 1 180 $X=684480 $Y=658300
X1958 2403 1 514 537 2 2431 ND3 $T=871100 648600 0 0 $X=871100 $Y=648220
X1959 173 1254 173 1254 2 1 1255 MAOI1 $T=459420 658680 0 180 $X=454460 $Y=653260
X1960 1177 1174 1 1177 1160 1174 2 MOAI1 $T=434000 729240 0 180 $X=429660 $Y=723820
X1961 1264 1255 1 1264 177 1255 2 MOAI1 $T=461900 678840 1 180 $X=457560 $Y=678460
X1962 306 182 1 306 1480 182 2 MOAI1 $T=620000 709080 1 180 $X=615660 $Y=708700
X1963 1947 1892 1 1947 1995 2000 2 MOAI1 $T=688200 719160 0 0 $X=688200 $Y=718780
X1964 2091 2020 1 2091 2098 2020 2 MOAI1 $T=723540 688920 1 0 $X=723540 $Y=683500
X1965 2355 2370 1 2355 2344 2370 2 MOAI1 $T=843820 719160 0 0 $X=843820 $Y=718780
X1966 2648 2653 1 2648 2657 2653 2 MOAI1 $T=969680 739320 1 0 $X=969680 $Y=733900
X1967 2658 2657 1 2658 2663 2657 2 MOAI1 $T=972780 719160 0 0 $X=972780 $Y=718780
X1968 1667 1535 1609 2 1642 1558 1 AO22 $T=585280 739320 1 180 $X=580320 $Y=738940
X1969 2173 2032 2157 2 2135 2031 1 AO22 $T=752060 719160 1 180 $X=747100 $Y=718780
X1970 642 646 658 2 1 664 XOR3 $T=221340 769560 0 0 $X=221340 $Y=769180
X1971 650 655 663 2 1 688 XOR3 $T=232500 749400 0 0 $X=232500 $Y=749020
X1972 693 685 665 2 1 663 XOR3 $T=244280 769560 0 180 $X=233120 $Y=764140
X1973 703 701 694 2 1 686 XOR3 $T=256060 739320 1 180 $X=244900 $Y=738940
X1974 1085 1104 1096 2 1 1089 XOR3 $T=414160 688920 1 180 $X=403000 $Y=688540
X1975 1126 1152 1129 2 1 1116 XOR3 $T=424700 699000 0 180 $X=413540 $Y=693580
X1976 1178 1182 1201 2 1 1199 XOR3 $T=430900 699000 1 0 $X=430900 $Y=693580
X1977 1227 1243 1219 2 1 1216 XOR3 $T=454460 699000 1 180 $X=443300 $Y=698620
X1978 655 657 652 1 2 668 MAO222 $T=225680 749400 1 0 $X=225680 $Y=743980
X1979 646 658 642 1 2 12 MAO222 $T=239320 769560 1 180 $X=234360 $Y=769180
X1980 685 689 693 1 2 642 MAO222 $T=246140 769560 1 180 $X=241180 $Y=769180
X1981 701 694 703 1 2 695 MAO222 $T=251100 749400 0 180 $X=246140 $Y=743980
X1982 727 712 728 1 2 21 MAO222 $T=261020 779640 0 180 $X=256060 $Y=774220
X1983 38 41 39 1 2 43 MAO222 $T=284580 779640 1 0 $X=284580 $Y=774220
X1984 1096 1085 1104 1 2 1099 MAO222 $T=409820 699000 0 180 $X=404860 $Y=693580
X1985 1129 1126 1152 1 2 1159 MAO222 $T=420360 699000 0 0 $X=420360 $Y=698620
X1986 1201 1178 1182 1 2 1215 MAO222 $T=437100 688920 1 0 $X=437100 $Y=683500
X1987 1219 1227 1243 1 2 174 MAO222 $T=462520 699000 1 180 $X=457560 $Y=698620
X1988 1767 303 1763 1 2 319 MAO222 $T=623100 779640 1 0 $X=623100 $Y=774220
X1989 757 26 750 1 2 725 AO12 $T=273420 759480 0 180 $X=269700 $Y=754060
X1990 1028 1023 1022 1 2 1019 AO12 $T=380680 719160 1 180 $X=376960 $Y=718780
X1991 2388 2382 2385 1 2 2402 AO12 $T=851880 709080 1 0 $X=851880 $Y=703660
X1992 2412 2413 2410 1 2 2422 AO12 $T=863660 719160 1 0 $X=863660 $Y=713740
X1993 2642 2619 2654 1 2 2644 AO12 $T=969060 688920 1 0 $X=969060 $Y=683500
X1994 1543 1 1594 2 BUF4CK $T=564820 709080 0 0 $X=564820 $Y=708700
X1995 677 1 2 14 BUF1S $T=238080 709080 1 0 $X=238080 $Y=703660
X1996 679 1 2 13 BUF1S $T=238700 688920 0 0 $X=238700 $Y=688540
X1997 674 1 2 15 BUF1S $T=241180 688920 0 0 $X=241180 $Y=688540
X1998 784 1 2 774 BUF1S $T=282720 749400 1 0 $X=282720 $Y=743980
X1999 1964 1870 1 2 BUF2CK $T=720440 678840 0 0 $X=720440 $Y=678460
X2000 1506 1524 1572 190 2 1 MXL2HS $T=551800 729240 0 0 $X=551800 $Y=728860
X2001 1506 1609 1616 194 2 1 MXL2HS $T=564200 729240 1 0 $X=564200 $Y=723820
X2002 2015 1995 2005 1826 2 1 MXL2HS $T=699360 719160 0 180 $X=693780 $Y=713740
X2003 2015 2055 2061 1919 2 1 MXL2HS $T=708040 719160 0 0 $X=708040 $Y=718780
X2004 2553 2525 573 2535 2 1 MXL2HS $T=923800 648600 1 180 $X=918220 $Y=648220
X2005 2571 2549 2553 2561 2 1 MXL2HS $T=930620 648600 1 180 $X=925040 $Y=648220
X2006 2592 584 2556 2585 2 1 MXL2HS $T=938680 658680 0 180 $X=933100 $Y=653260
X2007 1984 2 1989 371 1 AN2B1S $T=692540 769560 1 180 $X=689440 $Y=769180
X2008 733 2 727 1 655 NR2P $T=264120 749400 1 180 $X=260400 $Y=749020
X2009 59 2 58 1 839 NR2P $T=318060 668760 0 0 $X=318060 $Y=668380
X2010 862 2 879 1 859 NR2P $T=325500 749400 1 0 $X=325500 $Y=743980
X2011 70 2 68 1 813 NR2P $T=327980 678840 1 0 $X=327980 $Y=673420
X2012 1507 2 1514 1 1502 NR2P $T=539400 749400 0 180 $X=535680 $Y=743980
X2013 2035 2 2040 1 2026 NR2P $T=705560 699000 0 180 $X=701840 $Y=693580
X2014 1519 1543 1312 1551 190 1583 1 2 1571 OA222 $T=554280 709080 0 0 $X=554280 $Y=708700
X2015 219 1753 1437 1675 1747 1760 1 2 1737 OA222 $T=614420 729240 1 0 $X=614420 $Y=723820
X2016 1988 1982 1947 2000 1826 1832 1 2 2014 OA222 $T=691300 709080 0 0 $X=691300 $Y=708700
X2017 2038 2123 2003 2119 1919 2130 1 2 2135 OA222 $T=732840 729240 0 0 $X=732840 $Y=728860
X2018 727 728 712 2 1 658 XNR3 $T=262880 769560 1 180 $X=251720 $Y=769180
X2019 731 739 720 2 1 717 XNR3 $T=266600 719160 1 180 $X=255440 $Y=718780
X2020 1763 1767 303 2 1 300 XNR3 $T=622480 779640 0 180 $X=611320 $Y=774220
X2021 885 64 1 835 2 OR2T $T=327980 678840 1 180 $X=321780 $Y=678460
X2022 2413 2401 2407 1 2 XNR2H $T=863040 699000 0 0 $X=863040 $Y=698620
X2023 1018 115 1 2 BUF6 $T=385020 759480 1 0 $X=385020 $Y=754060
X2024 1964 2000 1 2 BUF6 $T=711760 699000 0 0 $X=711760 $Y=698620
X2025 1782 1776 1778 311 2 1 1043 OA112 $T=626820 759480 0 180 $X=621860 $Y=754060
X2026 176 1 2 1051 INV3CK $T=447640 668760 1 180 $X=444540 $Y=668380
X2027 1124 1127 140 1 2 XOR2H $T=412920 769560 0 0 $X=412920 $Y=769180
X2028 944 869 2 987 984 1 AOI12HP $T=356500 709080 0 0 $X=356500 $Y=708700
X2029 1003 1000 2 1016 1019 1 AOI12HP $T=372620 729240 0 0 $X=372620 $Y=728860
X2030 815 863 1 841 869 860 2 OAI112H $T=321160 709080 1 180 $X=313720 $Y=708700
X2031 802 3 49 830 1 2 2667 DFFSBN $T=291400 729240 0 0 $X=291400 $Y=728860
X2032 826 3 786 709 2 1 766 QDFFRSBN $T=295740 719160 1 180 $X=282100 $Y=718780
.ENDS
***************************************
.SUBCKT AO222S C1 C2 B2 B1 A1 A2 GND VCC O
** N=10 EP=9 IP=0 FDC=0
.ENDS
***************************************
.SUBCKT OAI222S C1 C2 GND B1 B2 VCC A1 O A2
** N=10 EP=9 IP=0 FDC=0
.ENDS
***************************************
.SUBCKT AO222 C1 C2 B2 B1 A1 A2 GND VCC O
** N=10 EP=9 IP=0 FDC=0
.ENDS
***************************************
.SUBCKT NR3 I1 VCC I2 I3 O GND
** N=7 EP=6 IP=0 FDC=0
.ENDS
***************************************
.SUBCKT AN4B1S I3 I2 I1 VCC B1 GND O
** N=8 EP=7 IP=0 FDC=0
.ENDS
***************************************
.SUBCKT ND2T I2 GND I1 O VCC
** N=6 EP=5 IP=0 FDC=0
.ENDS
***************************************
.SUBCKT OR3B2S I1 B1 VCC O B2 GND
** N=7 EP=6 IP=0 FDC=0
.ENDS
***************************************
.SUBCKT MUXB2T S A B EB VCC O GND
** N=8 EP=7 IP=0 FDC=0
.ENDS
***************************************
.SUBCKT MUXB2P S A B EB VCC O GND
** N=8 EP=7 IP=0 FDC=0
.ENDS
***************************************
.SUBCKT ND2F I2 I1 VCC O GND
** N=6 EP=5 IP=0 FDC=0
.ENDS
***************************************
.SUBCKT OA22 A1 A2 B1 B2 VCC GND O
** N=8 EP=7 IP=0 FDC=0
.ENDS
***************************************
.SUBCKT AN3S I1 I2 I3 GND VCC O
** N=7 EP=6 IP=0 FDC=0
.ENDS
***************************************
.SUBCKT ND3P I1 O I2 I3 GND VCC
** N=7 EP=6 IP=0 FDC=0
.ENDS
***************************************
.SUBCKT OAI22H B2 B1 GND A2 O A1 VCC
** N=8 EP=7 IP=0 FDC=0
.ENDS
***************************************
.SUBCKT AN3 I1 I2 I3 VCC GND O
** N=7 EP=6 IP=0 FDC=0
.ENDS
***************************************
.SUBCKT AO12T B2 B1 A1 GND VCC O
** N=7 EP=6 IP=0 FDC=0
.ENDS
***************************************
.SUBCKT AO112 O C2 C1 VCC B1 GND A1
** N=8 EP=7 IP=0 FDC=0
.ENDS
***************************************
.SUBCKT AN2P I1 I2 O GND VCC
** N=6 EP=5 IP=0 FDC=0
.ENDS
***************************************
.SUBCKT AOI22H A2 A1 VCC B1 O B2 GND
** N=8 EP=7 IP=0 FDC=0
.ENDS
***************************************
.SUBCKT BUF12CK I GND VCC O
** N=5 EP=4 IP=0 FDC=0
.ENDS
***************************************
.SUBCKT FA1P S B A CI CO GND VCC
** N=8 EP=7 IP=0 FDC=0
.ENDS
***************************************
.SUBCKT MUX3T B S0 A S1 C GND VCC O
** N=9 EP=8 IP=0 FDC=0
.ENDS
***************************************
.SUBCKT ICV_6 1 2 3 4 5 6 7 8 9 10 11 12 13 14 15 16 17 18 19 20
+ 21 22 23 24 25 26 27 28 29 30 31 32 33 34 35 36 37 38 39 40
+ 41 42 43 44 45 46 47 48 49 50 51 52 53 54 55 56 57 58 59 60
+ 61 62 63 64 65 66 67 68 69 70 71 72 73 74 75 76 77 78 79 80
+ 81 82 83 84 85 86 87 88 89 90 91 92 93 94 95 96 97 98 99 100
+ 101 102 103 104 105 106 107 108 109 110 111 112 113 114 115 116 117 118 119 120
+ 121 122 123 124 125 126 127 128 129 130 131 132 133 134 135 136 137 138 139 140
+ 141 142 143 144 145 146 147 148 149 150 151 152 153 154 155 156 157 158 159 160
+ 161 162 163 164 165 166 167 168 169 170 171 172 173 174 175 176 177 178 179 180
+ 181 182 183 184 185 186 187 188 189 190 191 192 193 194 195 196 197 198 199 200
+ 201 202 203 204 205 206 207 208 209 210 211 212 213 214 215 216 217 218 219 220
+ 221 222 223 224 225 226 227 228 229 230 231 232 233 234 235 236 237 238 239 240
+ 241 242 243 244 245 246 247 248 249 250 251 252 253 254 255 256 257 258 259 260
+ 261 262 263 264 265 266 267 268 269 270 271 272 273 274 275 276 277 278 279 280
+ 281 282 283 284 285 286 287 288 289 290 291 292 293 294 295 296 297 298 299 300
+ 301 302 303 304 305 306 307 308 309 310 311 312 313 314 315 316 317 318 319 320
+ 321 322 323 324 325 326 327 328 329 330 331 332 333 334 335 336 337 338 339 340
+ 341 342 343 344 345 346 347 348 349 350 351 352 353 354 355 356 357 358 359 360
+ 361 362 363 364 365 366 367 368 369 370 371 372 373 374 375 376 377 378 379 380
+ 381 382 383 384 385 386 387 388 389 390 391 392 393 394 395 396 397 398 399 400
+ 401 402 403 404 405 406 407 408 409 410 411 412 413 414 415 416 417 418 419 420
+ 421 422 423 424 425 426 427 428 429 430 431 432 433 434 435 436 437 438 439 440
+ 441 442 443 444 445 446 447 448 449 450 451 452 453 454 455 456 457 458 459 460
+ 461 462 463 464 465 466 467 468 469 470 471 472 473 474 475 476 477 478 479 480
+ 481 482 483 484 485 486 487 488 489 490 491 492 493 494 495 496 497 498 499 500
+ 501 502 503 504 505 506 507 508 509 510 511 512 513 514 515 516 517 518 519 520
+ 521 522 523 524 525 526 527 528 529 530 531 532 533 534 535 536 537 538 539 540
+ 541 542 543 544 545 546 547 548 549 550 551 552 553 554 555 556 557 558 559 560
+ 561 562 563 564 565 566 567 568 569 570 571 572 573 574 575 576 577 578 579 580
+ 581 582 583 584 585 586 587 588 589 590 591 592 593 594 595 596 597 598 599 600
+ 601 602 603 604 605 606 607 608 609 610 611 612 613 614 615 616 617 618 619 620
+ 621 622 623 624 625 626 627 628 629 630 631 632 633 634 635 636 637 638 639 640
+ 641 642 643 644 645 646 647 648 649 650 651 652 653 654 655 656 657 658 659 660
+ 661 662 663 664 665 666 667 668 669 670 671 672 673 674 675 676 677 678 679 680
+ 681 682 683 684 685 686 687 688 689 690 691 692 693 694 695 696 697 698 699 700
+ 701 702 703 704 705 706 707 708 709 710 711 712 713 714 715 716 717 718 719 720
+ 721 722 723 724 725 726 727 728 729 730 732 733 754
** N=2846 EP=733 IP=14416 FDC=0
X0 732 730 730 730 2845 729 733 YA2GSD $T=1199700 524080 0 90 $X=1060200 $Y=526930
X1 762 2 1 768 BUF1 $T=221960 537720 1 0 $X=221960 $Y=532300
X2 6 2 1 3 BUF1 $T=224440 557880 0 180 $X=221960 $Y=552460
X3 766 2 1 771 BUF1 $T=222580 598200 0 0 $X=222580 $Y=597820
X4 762 2 1 13 BUF1 $T=228160 537720 1 0 $X=228160 $Y=532300
X5 13 2 1 802 BUF1 $T=234980 537720 1 0 $X=234980 $Y=532300
X6 778 2 1 762 BUF1 $T=239320 547800 1 180 $X=236840 $Y=547420
X7 766 2 1 769 BUF1 $T=243040 588120 1 180 $X=240560 $Y=587740
X8 769 2 1 778 BUF1 $T=241180 567960 0 0 $X=241180 $Y=567580
X9 13 2 1 822 BUF1 $T=249860 517560 0 0 $X=249860 $Y=517180
X10 824 2 1 10 BUF1 $T=252340 628440 1 180 $X=249860 $Y=628060
X11 826 2 1 766 BUF1 $T=261020 598200 1 180 $X=258540 $Y=597820
X12 766 2 1 835 BUF1 $T=264740 578040 1 180 $X=262260 $Y=577660
X13 870 2 1 34 BUF1 $T=269080 557880 0 180 $X=266600 $Y=552460
X14 869 2 1 877 BUF1 $T=270320 537720 1 0 $X=270320 $Y=532300
X15 870 2 1 875 BUF1 $T=272800 557880 1 0 $X=272800 $Y=552460
X16 873 2 1 824 BUF1 $T=275280 628440 0 180 $X=272800 $Y=623020
X17 877 2 1 45 BUF1 $T=275900 517560 1 0 $X=275900 $Y=512140
X18 31 2 1 873 BUF1 $T=278380 628440 0 0 $X=278380 $Y=628060
X19 43 2 1 54 BUF1 $T=280860 517560 0 0 $X=280860 $Y=517180
X20 873 2 1 62 BUF1 $T=285200 628440 0 0 $X=285200 $Y=628060
X21 62 2 1 58 BUF1 $T=290780 638520 1 180 $X=288300 $Y=638140
X22 874 2 1 883 BUF1 $T=288920 567960 1 0 $X=288920 $Y=562540
X23 890 2 1 78 BUF1 $T=289540 517560 0 0 $X=289540 $Y=517180
X24 826 2 1 928 BUF1 $T=290780 598200 1 0 $X=290780 $Y=592780
X25 66 2 1 906 BUF1 $T=295120 567960 0 180 $X=292640 $Y=562540
X26 873 2 1 943 BUF1 $T=300700 628440 1 0 $X=300700 $Y=623020
X27 66 2 1 958 BUF1 $T=301940 537720 1 0 $X=301940 $Y=532300
X28 874 2 1 965 BUF1 $T=307520 557880 0 0 $X=307520 $Y=557500
X29 943 2 1 976 BUF1 $T=308760 628440 1 0 $X=308760 $Y=623020
X30 985 2 1 77 BUF1 $T=313100 507480 1 180 $X=310620 $Y=507100
X31 941 2 1 79 BUF1 $T=311240 537720 1 0 $X=311240 $Y=532300
X32 965 2 1 985 BUF1 $T=316200 537720 1 180 $X=313720 $Y=537340
X33 943 2 1 994 BUF1 $T=313720 618360 0 0 $X=313720 $Y=617980
X34 991 2 1 964 BUF1 $T=317440 537720 0 0 $X=317440 $Y=537340
X35 1029 2 1 786 BUF1 $T=337280 598200 0 180 $X=334800 $Y=592780
X36 994 2 1 96 BUF1 $T=343480 628440 0 0 $X=343480 $Y=628060
X37 115 2 1 48 BUF1 $T=360840 628440 0 180 $X=358360 $Y=623020
X38 1125 2 1 1079 BUF1 $T=367040 598200 0 180 $X=364560 $Y=592780
X39 1121 2 1 1125 BUF1 $T=367040 608280 1 0 $X=367040 $Y=602860
X40 1116 2 1 128 BUF1 $T=368900 517560 0 0 $X=368900 $Y=517180
X41 1125 2 1 1126 BUF1 $T=378820 567960 0 0 $X=378820 $Y=567580
X42 1126 2 1 1184 BUF1 $T=385020 537720 0 0 $X=385020 $Y=537340
X43 1115 2 1 1188 BUF1 $T=388120 537720 1 0 $X=388120 $Y=532300
X44 1140 2 1 1128 BUF1 $T=393700 537720 1 180 $X=391220 $Y=537340
X45 1126 2 1 1196 BUF1 $T=391220 567960 1 0 $X=391220 $Y=562540
X46 1184 2 1 141 BUF1 $T=396800 507480 0 180 $X=394320 $Y=502060
X47 145 2 1 1140 BUF1 $T=398660 537720 1 180 $X=396180 $Y=537340
X48 1168 2 1 149 BUF1 $T=396800 567960 0 0 $X=396800 $Y=567580
X49 1203 2 1 1180 BUF1 $T=399280 537720 0 0 $X=399280 $Y=537340
X50 1220 2 1 1149 BUF1 $T=405480 527640 0 180 $X=403000 $Y=522220
X51 1184 2 1 1243 BUF1 $T=414160 517560 1 0 $X=414160 $Y=512140
X52 131 2 1 1247 BUF1 $T=414780 638520 1 0 $X=414780 $Y=633100
X53 1104 2 1 168 BUF1 $T=415400 557880 1 0 $X=415400 $Y=552460
X54 1086 2 1 179 BUF1 $T=423460 588120 1 0 $X=423460 $Y=582700
X55 1171 2 1 1284 BUF1 $T=424080 567960 1 0 $X=424080 $Y=562540
X56 1243 2 1 181 BUF1 $T=426560 517560 1 0 $X=426560 $Y=512140
X57 1096 2 1 1261 BUF1 $T=426560 578040 1 0 $X=426560 $Y=572620
X58 1153 2 1 190 BUF1 $T=432140 578040 1 0 $X=432140 $Y=572620
X59 1212 2 1 198 BUF1 $T=443920 557880 0 0 $X=443920 $Y=557500
X60 174 2 1 199 BUF1 $T=446400 517560 1 0 $X=446400 $Y=512140
X61 200 2 1 1185 BUF1 $T=448880 608280 1 180 $X=446400 $Y=607900
X62 1211 2 1 1342 BUF1 $T=450120 567960 1 0 $X=450120 $Y=562540
X63 203 2 1 1218 BUF1 $T=455080 638520 1 180 $X=452600 $Y=638140
X64 1326 2 1 1362 BUF1 $T=458180 537720 0 0 $X=458180 $Y=537340
X65 186 2 1 211 BUF1 $T=461900 507480 0 0 $X=461900 $Y=507100
X66 209 2 1 217 BUF1 $T=462520 507480 1 0 $X=462520 $Y=502060
X67 1383 2 1 1295 BUF1 $T=464380 537720 0 0 $X=464380 $Y=537340
X68 1328 2 1 1369 BUF1 $T=465000 598200 1 0 $X=465000 $Y=592780
X69 181 2 1 1394 BUF1 $T=468100 517560 0 0 $X=468100 $Y=517180
X70 214 2 1 1313 BUF1 $T=471200 618360 1 180 $X=468720 $Y=617980
X71 215 2 1 165 BUF1 $T=473680 618360 0 180 $X=471200 $Y=612940
X72 1413 2 1 1272 BUF1 $T=476160 557880 0 180 $X=473680 $Y=552460
X73 219 2 1 228 BUF1 $T=474300 507480 1 0 $X=474300 $Y=502060
X74 220 2 1 1436 BUF1 $T=474300 608280 0 0 $X=474300 $Y=607900
X75 1415 2 1 1414 BUF1 $T=477400 527640 1 0 $X=477400 $Y=522220
X76 228 2 1 1273 BUF1 $T=481740 507480 1 180 $X=479260 $Y=507100
X77 230 2 1 1265 BUF1 $T=482980 547800 1 180 $X=480500 $Y=547420
X78 1318 2 1 192 BUF1 $T=484220 608280 0 0 $X=484220 $Y=607900
X79 238 2 1 1245 BUF1 $T=487320 628440 0 180 $X=484840 $Y=623020
X80 1429 2 1 1304 BUF1 $T=486080 537720 0 0 $X=486080 $Y=537340
X81 1460 2 1 1328 BUF1 $T=496620 588120 1 180 $X=494140 $Y=587740
X82 1392 2 1 1474 BUF1 $T=497860 588120 0 0 $X=497860 $Y=587740
X83 264 2 1 1307 BUF1 $T=500960 537720 1 180 $X=498480 $Y=537340
X84 263 2 1 1373 BUF1 $T=498480 578040 0 0 $X=498480 $Y=577660
X85 1484 2 1 1433 BUF1 $T=502820 567960 0 180 $X=500340 $Y=562540
X86 1428 2 1 1475 BUF1 $T=504060 557880 0 0 $X=504060 $Y=557500
X87 285 2 1 1383 BUF1 $T=505920 537720 0 0 $X=505920 $Y=537340
X88 1420 2 1 1508 BUF1 $T=509640 588120 0 0 $X=509640 $Y=587740
X89 1529 2 1 1494 BUF1 $T=520800 527640 0 0 $X=520800 $Y=527260
X90 317 2 1 1492 BUF1 $T=523900 547800 0 180 $X=521420 $Y=542380
X91 318 2 1 316 BUF1 $T=523900 608280 1 180 $X=521420 $Y=607900
X92 1460 2 1 1530 BUF1 $T=524520 588120 1 0 $X=524520 $Y=582700
X93 1532 2 1 1542 BUF1 $T=532580 527640 1 180 $X=530100 $Y=527260
X94 1417 2 1 352 BUF1 $T=533820 588120 0 0 $X=533820 $Y=587740
X95 335 2 1 1338 BUF1 $T=538160 567960 0 180 $X=535680 $Y=562540
X96 1583 2 1 232 BUF1 $T=540020 608280 0 180 $X=537540 $Y=602860
X97 1581 2 1 1468 BUF1 $T=541880 557880 1 180 $X=539400 $Y=557500
X98 1157 2 1 357 BUF1 $T=539400 638520 1 0 $X=539400 $Y=633100
X99 356 2 1 1438 BUF1 $T=542500 527640 0 180 $X=540020 $Y=522220
X100 1539 2 1 1563 BUF1 $T=541880 547800 0 0 $X=541880 $Y=547420
X101 116 2 1 328 BUF1 $T=542500 608280 1 0 $X=542500 $Y=602860
X102 360 2 1 295 BUF1 $T=544980 638520 1 180 $X=542500 $Y=638140
X103 364 2 1 1511 BUF1 $T=549940 507480 0 180 $X=547460 $Y=502060
X104 1548 2 1 367 BUF1 $T=548080 628440 1 0 $X=548080 $Y=623020
X105 1601 2 1 235 BUF1 $T=551180 598200 1 180 $X=548700 $Y=597820
X106 1621 2 1 375 BUF1 $T=552420 517560 1 0 $X=552420 $Y=512140
X107 1486 2 1 378 BUF1 $T=553660 598200 0 0 $X=553660 $Y=597820
X108 1606 2 1 349 BUF1 $T=556760 537720 0 180 $X=554280 $Y=532300
X109 1436 2 1 1623 BUF1 $T=554280 608280 1 0 $X=554280 $Y=602860
X110 132 2 1 1560 BUF1 $T=556140 527640 1 0 $X=556140 $Y=522220
X111 218 2 1 1635 BUF1 $T=559240 598200 1 0 $X=559240 $Y=592780
X112 1633 2 1 358 BUF1 $T=565440 537720 0 180 $X=562960 $Y=532300
X113 382 2 1 1644 BUF1 $T=564820 507480 0 0 $X=564820 $Y=507100
X114 383 2 1 389 BUF1 $T=566060 628440 1 0 $X=566060 $Y=623020
X115 1644 2 1 1552 BUF1 $T=570400 537720 1 180 $X=567920 $Y=537340
X116 261 2 1 1651 BUF1 $T=567920 557880 0 0 $X=567920 $Y=557500
X117 254 2 1 388 BUF1 $T=567920 628440 0 0 $X=567920 $Y=628060
X118 1560 2 1 1686 BUF1 $T=572260 537720 0 0 $X=572260 $Y=537340
X119 1595 2 1 1681 BUF1 $T=572260 618360 0 0 $X=572260 $Y=617980
X120 1595 2 1 396 BUF1 $T=573500 628440 1 0 $X=573500 $Y=623020
X121 388 2 1 1691 BUF1 $T=582800 608280 0 180 $X=580320 $Y=602860
X122 397 2 1 1712 BUF1 $T=583420 608280 0 0 $X=583420 $Y=607900
X123 274 2 1 1720 BUF1 $T=584040 598200 0 0 $X=584040 $Y=597820
X124 1745 2 1 379 BUF1 $T=592100 517560 0 180 $X=589620 $Y=512140
X125 398 2 1 1716 BUF1 $T=589620 578040 0 0 $X=589620 $Y=577660
X126 1686 2 1 1718 BUF1 $T=592720 527640 0 0 $X=592720 $Y=527260
X127 1569 2 1 413 BUF1 $T=595820 598200 1 0 $X=595820 $Y=592780
X128 414 2 1 1722 BUF1 $T=601400 598200 1 180 $X=598920 $Y=597820
X129 1681 2 1 1706 BUF1 $T=616900 578040 0 180 $X=614420 $Y=572620
X130 258 2 1 434 BUF1 $T=614420 628440 1 0 $X=614420 $Y=623020
X131 1601 2 1 443 BUF1 $T=620000 507480 0 0 $X=620000 $Y=507100
X132 445 2 1 1696 BUF1 $T=628060 598200 1 180 $X=625580 $Y=597820
X133 1583 2 1 453 BUF1 $T=634260 507480 1 0 $X=634260 $Y=502060
X134 449 2 1 456 BUF1 $T=634880 527640 0 0 $X=634880 $Y=527260
X135 1726 2 1 1899 BUF1 $T=642940 598200 1 0 $X=642940 $Y=592780
X136 469 2 1 401 BUF1 $T=651620 628440 0 180 $X=649140 $Y=623020
X137 1686 2 1 1941 BUF1 $T=660300 527640 0 0 $X=660300 $Y=527260
X138 477 2 1 468 BUF1 $T=660920 628440 0 0 $X=660920 $Y=628060
X139 425 2 1 475 BUF1 $T=662160 628440 1 0 $X=662160 $Y=623020
X140 1979 2 1 1974 BUF1 $T=671460 567960 1 180 $X=668980 $Y=567580
X141 371 2 1 484 BUF1 $T=669600 638520 1 0 $X=669600 $Y=633100
X142 1941 2 1 1996 BUF1 $T=683860 537720 1 0 $X=683860 $Y=532300
X143 2016 2 1 2012 BUF1 $T=695640 608280 1 0 $X=695640 $Y=602860
X144 503 2 1 2016 BUF1 $T=699980 628440 0 180 $X=697500 $Y=623020
X145 1996 2 1 2032 BUF1 $T=698740 527640 1 0 $X=698740 $Y=522220
X146 1979 2 1 2031 BUF1 $T=699360 567960 1 0 $X=699360 $Y=562540
X147 1996 2 1 2043 BUF1 $T=700600 517560 0 0 $X=700600 $Y=517180
X148 2012 2 1 1979 BUF1 $T=703700 588120 0 180 $X=701220 $Y=582700
X149 439 2 1 504 BUF1 $T=704940 517560 0 180 $X=702460 $Y=512140
X150 2043 2 1 510 BUF1 $T=715480 507480 1 0 $X=715480 $Y=502060
X151 2031 2 1 2089 BUF1 $T=719820 567960 1 0 $X=719820 $Y=562540
X152 2089 2 1 2068 BUF1 $T=726020 578040 0 180 $X=723540 $Y=572620
X153 2043 2 1 2091 BUF1 $T=726020 517560 1 0 $X=726020 $Y=512140
X154 2089 2 1 2103 BUF1 $T=727880 578040 1 0 $X=727880 $Y=572620
X155 2165 2 1 2157 BUF1 $T=747720 578040 0 0 $X=747720 $Y=577660
X156 2188 2 1 2138 BUF1 $T=766940 557880 1 180 $X=764460 $Y=557500
X157 2165 2 1 2188 BUF1 $T=768800 578040 1 180 $X=766320 $Y=577660
X158 2231 2 1 2165 BUF1 $T=773140 598200 0 180 $X=770660 $Y=592780
X159 2188 2 1 2214 BUF1 $T=773140 578040 0 0 $X=773140 $Y=577660
X160 2232 2 1 2231 BUF1 $T=784300 608280 0 180 $X=781820 $Y=602860
X161 2231 2 1 2282 BUF1 $T=802900 608280 1 0 $X=802900 $Y=602860
X162 2231 2 1 2289 BUF1 $T=806620 598200 0 0 $X=806620 $Y=597820
X163 2309 2 1 2267 BUF1 $T=817780 547800 1 180 $X=815300 $Y=547420
X164 2289 2 1 2309 BUF1 $T=817780 588120 1 0 $X=817780 $Y=582700
X165 2309 2 1 2318 BUF1 $T=823360 547800 0 0 $X=823360 $Y=547420
X166 2325 2 1 2336 BUF1 $T=827080 567960 1 0 $X=827080 $Y=562540
X167 2319 2 1 2322 BUF1 $T=827080 588120 0 0 $X=827080 $Y=587740
X168 2322 2 1 2333 BUF1 $T=832660 557880 0 0 $X=832660 $Y=557500
X169 2289 2 1 2344 BUF1 $T=832660 588120 0 0 $X=832660 $Y=587740
X170 623 2 1 2315 BUF1 $T=835140 638520 1 180 $X=832660 $Y=638140
X171 2336 2 1 2351 BUF1 $T=838240 547800 1 0 $X=838240 $Y=542380
X172 2351 2 1 2377 BUF1 $T=838860 517560 0 0 $X=838860 $Y=517180
X173 2351 2 1 2392 BUF1 $T=838860 527640 1 0 $X=838860 $Y=522220
X174 638 2 1 2360 BUF1 $T=841960 638520 0 180 $X=839480 $Y=633100
X175 2333 2 1 2358 BUF1 $T=841960 537720 1 0 $X=841960 $Y=532300
X176 2359 2 1 2369 BUF1 $T=844440 557880 1 180 $X=841960 $Y=557500
X177 2380 2 1 2370 BUF1 $T=846920 578040 1 180 $X=844440 $Y=577660
X178 2388 2 1 2375 BUF1 $T=847540 547800 1 180 $X=845060 $Y=547420
X179 2370 2 1 2388 BUF1 $T=845060 557880 0 0 $X=845060 $Y=557500
X180 2389 2 1 2359 BUF1 $T=847540 578040 0 180 $X=845060 $Y=572620
X181 2363 2 1 2389 BUF1 $T=845060 608280 1 0 $X=845060 $Y=602860
X182 638 2 1 2380 BUF1 $T=847540 608280 1 180 $X=845060 $Y=607900
X183 638 2 1 2374 BUF1 $T=847540 618360 1 180 $X=845060 $Y=617980
X184 643 2 1 2407 BUF1 $T=849400 628440 1 0 $X=849400 $Y=623020
X185 2380 2 1 2440 BUF1 $T=852500 598200 1 0 $X=852500 $Y=592780
X186 643 2 1 650 BUF1 $T=853740 638520 1 0 $X=853740 $Y=633100
X187 2407 2 1 2410 BUF1 $T=854980 588120 0 0 $X=854980 $Y=587740
X188 651 2 1 2416 BUF1 $T=858080 608280 0 180 $X=855600 $Y=602860
X189 2388 2 1 2435 BUF1 $T=856220 537720 0 0 $X=856220 $Y=537340
X190 2388 2 1 2439 BUF1 $T=856220 547800 1 0 $X=856220 $Y=542380
X191 2428 2 1 2418 BUF1 $T=858700 557880 1 180 $X=856220 $Y=557500
X192 2410 2 1 2428 BUF1 $T=856220 567960 0 0 $X=856220 $Y=567580
X193 653 2 1 649 BUF1 $T=859320 638520 0 180 $X=856840 $Y=633100
X194 653 2 1 2412 BUF1 $T=861180 628440 0 180 $X=858700 $Y=623020
X195 2404 2 1 2446 BUF1 $T=859320 547800 0 0 $X=859320 $Y=547420
X196 2421 2 1 2404 BUF1 $T=862420 578040 1 180 $X=859940 $Y=577660
X197 2451 2 1 645 BUF1 $T=864900 507480 1 180 $X=862420 $Y=507100
X198 2410 2 1 2507 BUF1 $T=866140 588120 0 0 $X=866140 $Y=587740
X199 653 2 1 2421 BUF1 $T=866140 628440 1 0 $X=866140 $Y=623020
X200 2392 2 1 2494 BUF1 $T=868620 517560 0 0 $X=868620 $Y=517180
X201 2428 2 1 2482 BUF1 $T=869240 557880 0 0 $X=869240 $Y=557500
X202 657 2 1 2480 BUF1 $T=869240 598200 0 0 $X=869240 $Y=597820
X203 2477 2 1 2474 BUF1 $T=872340 618360 1 0 $X=872340 $Y=612940
X204 2429 2 1 2521 BUF1 $T=877920 537720 1 0 $X=877920 $Y=532300
X205 2482 2 1 2529 BUF1 $T=877920 547800 1 0 $X=877920 $Y=542380
X206 2451 2 1 664 BUF1 $T=879160 507480 1 0 $X=879160 $Y=502060
X207 2324 2 1 2451 BUF1 $T=879160 507480 0 0 $X=879160 $Y=507100
X208 2422 2 1 2527 BUF1 $T=879780 527640 1 0 $X=879780 $Y=522220
X209 2502 2 1 2531 BUF1 $T=879780 598200 1 0 $X=879780 $Y=592780
X210 2502 2 1 2534 BUF1 $T=880400 588120 1 0 $X=880400 $Y=582700
X211 2435 2 1 2533 BUF1 $T=881020 527640 0 0 $X=881020 $Y=527260
X212 2485 2 1 2471 BUF1 $T=881020 598200 0 0 $X=881020 $Y=597820
X213 2446 2 1 2541 BUF1 $T=881640 547800 0 0 $X=881640 $Y=547420
X214 2552 2 1 2509 BUF1 $T=887840 598200 1 180 $X=885360 $Y=597820
X215 2552 2 1 2504 BUF1 $T=888460 578040 1 180 $X=885980 $Y=577660
X216 2494 2 1 2578 BUF1 $T=892180 527640 1 0 $X=892180 $Y=522220
X217 2451 2 1 2604 BUF1 $T=898380 517560 1 0 $X=898380 $Y=512140
X218 2521 2 1 2595 BUF1 $T=898380 527640 0 0 $X=898380 $Y=527260
X219 2547 2 1 682 BUF1 $T=902100 598200 1 180 $X=899620 $Y=597820
X220 2541 2 1 2616 BUF1 $T=902100 537720 0 0 $X=902100 $Y=537340
X221 2547 2 1 2603 BUF1 $T=902100 598200 0 0 $X=902100 $Y=597820
X222 2527 2 1 2612 BUF1 $T=903960 527640 1 0 $X=903960 $Y=522220
X223 2533 2 1 2631 BUF1 $T=904580 527640 0 0 $X=904580 $Y=527260
X224 2527 2 1 2654 BUF1 $T=910160 527640 1 0 $X=910160 $Y=522220
X225 2595 2 1 2679 BUF1 $T=916980 527640 0 0 $X=916980 $Y=527260
X226 2674 2 1 2670 BUF1 $T=919460 608280 1 180 $X=916980 $Y=607900
X227 696 2 1 2674 BUF1 $T=921940 628440 0 0 $X=921940 $Y=628060
X228 2701 2 1 2641 BUF1 $T=927520 588120 1 180 $X=925040 $Y=587740
X229 2578 2 1 2702 BUF1 $T=928140 517560 0 0 $X=928140 $Y=517180
X230 2718 2 1 2738 BUF1 $T=933100 608280 1 0 $X=933100 $Y=602860
X231 2604 2 1 2751 BUF1 $T=933720 517560 0 0 $X=933720 $Y=517180
X232 2718 2 1 2748 BUF1 $T=939920 567960 0 0 $X=939920 $Y=567580
X233 2707 2 1 2754 BUF1 $T=944880 598200 0 0 $X=944880 $Y=597820
X234 2669 2 1 2815 BUF1 $T=961620 588120 1 0 $X=961620 $Y=582700
X235 2751 2 1 718 BUF1 $T=977120 527640 1 180 $X=974640 $Y=527260
X236 2751 2 1 2842 BUF1 $T=977740 537720 0 180 $X=975260 $Y=532300
X237 730 2 1 729 BUF1 $T=975260 547800 1 0 $X=975260 $Y=542380
X238 758 5 768 2 1 784 QDFFRBN $T=220720 517560 0 0 $X=220720 $Y=517180
X239 779 765 768 2 1 755 QDFFRBN $T=232500 527640 1 180 $X=220720 $Y=527260
X240 785 765 762 2 1 756 QDFFRBN $T=232500 537720 1 180 $X=220720 $Y=537340
X241 780 765 769 2 1 757 QDFFRBN $T=232500 588120 0 180 $X=220720 $Y=582700
X242 4 5 768 2 1 764 QDFFRBN $T=221340 517560 1 0 $X=221340 $Y=512140
X243 759 765 762 2 1 777 QDFFRBN $T=221340 547800 0 0 $X=221340 $Y=547420
X244 760 765 769 2 1 782 QDFFRBN $T=221340 578040 1 0 $X=221340 $Y=572620
X245 763 765 778 2 1 776 QDFFRBN $T=221960 557880 0 0 $X=221960 $Y=557500
X246 783 765 769 2 1 761 QDFFRBN $T=234360 567960 1 180 $X=222580 $Y=567580
X247 767 765 771 2 1 788 QDFFRBN $T=223200 588120 0 0 $X=223200 $Y=587740
X248 770 765 771 2 1 795 QDFFRBN $T=223820 608280 0 0 $X=223820 $Y=607900
X249 791 765 766 2 1 772 QDFFRBN $T=236220 608280 0 180 $X=224440 $Y=602860
X250 792 765 771 2 1 773 QDFFRBN $T=236220 618360 1 180 $X=224440 $Y=617980
X251 774 765 10 2 1 797 QDFFRBN $T=225060 628440 1 0 $X=225060 $Y=623020
X252 775 765 10 2 1 798 QDFFRBN $T=225060 638520 1 0 $X=225060 $Y=633100
X253 799 765 10 2 1 8 QDFFRBN $T=238080 638520 1 180 $X=226300 $Y=638140
X254 9 765 771 2 1 809 QDFFRBN $T=228780 598200 1 0 $X=228780 $Y=592780
X255 794 765 13 2 1 805 QDFFRBN $T=234360 527640 0 0 $X=234360 $Y=527260
X256 812 765 769 2 1 781 QDFFRBN $T=246140 588120 0 180 $X=234360 $Y=582700
X257 813 5 13 2 1 789 QDFFRBN $T=246760 517560 1 180 $X=234980 $Y=517180
X258 814 765 778 2 1 790 QDFFRBN $T=246760 537720 1 180 $X=234980 $Y=537340
X259 815 765 769 2 1 793 QDFFRBN $T=246760 578040 0 180 $X=234980 $Y=572620
X260 12 765 778 2 1 818 QDFFRBN $T=237460 557880 0 0 $X=237460 $Y=557500
X261 823 765 778 2 1 803 QDFFRBN $T=252340 547800 1 180 $X=240560 $Y=547420
X262 834 765 771 2 1 796 QDFFRBN $T=252340 618360 0 180 $X=240560 $Y=612940
X263 804 5 822 2 1 14 QDFFRBN $T=241180 517560 1 0 $X=241180 $Y=512140
X264 806 765 802 2 1 828 QDFFRBN $T=241800 537720 1 0 $X=241800 $Y=532300
X265 829 765 766 2 1 808 QDFFRBN $T=254820 608280 0 180 $X=243040 $Y=602860
X266 810 765 826 2 1 831 QDFFRBN $T=243660 598200 0 0 $X=243660 $Y=597820
X267 811 765 824 2 1 833 QDFFRBN $T=243660 638520 1 0 $X=243660 $Y=633100
X268 816 765 826 2 1 832 QDFFRBN $T=244900 598200 1 0 $X=244900 $Y=592780
X269 23 765 10 2 1 801 QDFFRBN $T=257300 638520 1 180 $X=245520 $Y=638140
X270 820 765 835 2 1 854 QDFFRBN $T=248000 567960 0 0 $X=248000 $Y=567580
X271 841 765 766 2 1 807 QDFFRBN $T=259780 578040 1 180 $X=248000 $Y=577660
X272 821 765 802 2 1 843 QDFFRBN $T=248620 537720 0 0 $X=248620 $Y=537340
X273 19 765 824 2 1 848 QDFFRBN $T=250480 618360 0 0 $X=250480 $Y=617980
X274 17 765 762 2 1 845 QDFFRBN $T=251720 557880 1 0 $X=251720 $Y=552460
X275 851 765 762 2 1 827 QDFFRBN $T=265360 547800 0 180 $X=253580 $Y=542380
X276 22 765 824 2 1 850 QDFFRBN $T=255440 618360 1 0 $X=255440 $Y=612940
X277 867 765 802 2 1 836 QDFFRBN $T=268460 537720 0 180 $X=256680 $Y=532300
X278 15 765 31 2 1 859 QDFFRBN $T=256680 628440 1 0 $X=256680 $Y=623020
X279 857 765 835 2 1 839 QDFFRBN $T=269080 578040 0 180 $X=257300 $Y=572620
X280 865 765 31 2 1 28 QDFFRBN $T=270940 638520 1 180 $X=259160 $Y=638140
X281 844 5 822 2 1 890 QDFFRBN $T=259780 517560 0 0 $X=259780 $Y=517180
X282 868 765 824 2 1 26 QDFFRBN $T=271560 628440 1 180 $X=259780 $Y=628060
X283 852 5 822 2 1 876 QDFFRBN $T=264120 517560 1 0 $X=264120 $Y=512140
X284 860 765 873 2 1 861 QDFFRBN $T=267220 618360 0 0 $X=267220 $Y=617980
X285 900 50 31 2 1 872 QDFFRBN $T=284580 638520 1 180 $X=272800 $Y=638140
X286 917 765 873 2 1 898 QDFFRBN $T=293880 628440 0 180 $X=282100 $Y=623020
X287 893 765 873 2 1 926 QDFFRBN $T=283340 618360 1 0 $X=283340 $Y=612940
X288 55 765 928 2 1 935 QDFFRBN $T=286440 588120 0 0 $X=286440 $Y=587740
X289 49 765 928 2 1 946 QDFFRBN $T=287680 588120 1 0 $X=287680 $Y=582700
X290 918 765 943 2 1 950 QDFFRBN $T=292020 628440 0 0 $X=292020 $Y=628060
X291 955 50 62 2 1 921 QDFFRBN $T=305660 638520 1 180 $X=293880 $Y=638140
X292 937 765 928 2 1 968 QDFFRBN $T=297600 598200 1 0 $X=297600 $Y=592780
X293 942 765 943 2 1 981 QDFFRBN $T=299460 618360 1 0 $X=299460 $Y=612940
X294 988 765 928 2 1 882 QDFFRBN $T=312480 588120 1 180 $X=300700 $Y=587740
X295 970 765 976 2 1 996 QDFFRBN $T=308140 628440 0 0 $X=308140 $Y=628060
X296 997 50 62 2 1 74 QDFFRBN $T=321160 638520 1 180 $X=309380 $Y=638140
X297 989 87 943 2 1 982 QDFFRBN $T=323640 608280 1 180 $X=311860 $Y=607900
X298 1017 765 994 2 1 979 QDFFRBN $T=327980 628440 0 180 $X=316200 $Y=623020
X299 1026 765 943 2 1 992 QDFFRBN $T=331080 618360 1 180 $X=319300 $Y=617980
X300 1011 50 96 2 1 1048 QDFFRBN $T=324880 638520 0 0 $X=324880 $Y=638140
X301 99 87 976 2 1 1005 QDFFRBN $T=338520 628440 1 180 $X=326740 $Y=628060
X302 1044 87 994 2 1 1012 QDFFRBN $T=342860 628440 0 180 $X=331080 $Y=623020
X303 1046 87 994 2 1 1070 QDFFRBN $T=334800 608280 0 0 $X=334800 $Y=607900
X304 1077 87 994 2 1 1030 QDFFRBN $T=347200 618360 0 180 $X=335420 $Y=612940
X305 1058 87 96 2 1 1082 QDFFRBN $T=340380 638520 1 0 $X=340380 $Y=633100
X306 1091 87 994 2 1 1057 QDFFRBN $T=357740 628440 0 180 $X=345960 $Y=623020
X307 1100 87 1079 2 1 1028 QDFFRBN $T=358980 608280 0 180 $X=347200 $Y=602860
X308 1075 87 96 2 1 1108 QDFFRBN $T=347820 628440 0 0 $X=347820 $Y=628060
X309 1107 87 1079 2 1 1032 QDFFRBN $T=362080 608280 1 180 $X=350300 $Y=607900
X310 1138 110 122 2 1 1116 QDFFRBN $T=376960 517560 0 180 $X=365180 $Y=512140
X311 1067 87 1121 2 1 1130 QDFFRBN $T=365180 618360 1 0 $X=365180 $Y=612940
X312 1143 110 1126 2 1 1086 QDFFRBN $T=377580 567960 1 180 $X=365800 $Y=567580
X313 1151 110 1125 2 1 1096 QDFFRBN $T=379440 588120 1 180 $X=367660 $Y=587740
X314 1131 87 1121 2 1 1161 QDFFRBN $T=370760 608280 0 0 $X=370760 $Y=607900
X315 1160 110 1126 2 1 1104 QDFFRBN $T=383160 557880 0 180 $X=371380 $Y=552460
X316 1164 110 1126 2 1 1115 QDFFRBN $T=384400 547800 0 180 $X=372620 $Y=542380
X317 1134 110 1126 2 1 1171 QDFFRBN $T=373240 567960 1 0 $X=373240 $Y=562540
X318 1174 110 1125 2 1 1123 QDFFRBN $T=386260 598200 1 180 $X=374480 $Y=597820
X319 1156 110 141 2 1 138 QDFFRBN $T=382540 507480 1 0 $X=382540 $Y=502060
X320 1176 110 1196 2 1 1203 QDFFRBN $T=386260 557880 0 0 $X=386260 $Y=557500
X321 1193 110 1125 2 1 1153 QDFFRBN $T=392460 598200 1 0 $X=392460 $Y=592780
X322 1198 110 1184 2 1 1220 QDFFRBN $T=394940 527640 0 0 $X=394940 $Y=527260
X323 1200 110 1184 2 1 142 QDFFRBN $T=395560 507480 0 0 $X=395560 $Y=507100
X324 1210 110 1125 2 1 1168 QDFFRBN $T=414160 588120 0 180 $X=402380 $Y=582700
X325 1223 110 1184 2 1 1208 QDFFRBN $T=406720 527640 0 0 $X=406720 $Y=527260
X326 1228 110 1243 2 1 166 QDFFRBN $T=408580 507480 0 0 $X=408580 $Y=507100
X327 1230 110 1184 2 1 160 QDFFRBN $T=409200 537720 1 0 $X=409200 $Y=532300
X328 1241 110 1196 2 1 1212 QDFFRBN $T=414780 557880 0 0 $X=414780 $Y=557500
X329 1244 110 1196 2 1 1211 QDFFRBN $T=416020 567960 0 0 $X=416020 $Y=567580
X330 1311 110 181 2 1 1326 QDFFRBN $T=442680 517560 0 0 $X=442680 $Y=517180
X331 1334 110 181 2 1 1355 QDFFRBN $T=449500 517560 1 0 $X=449500 $Y=512140
X332 1380 110 1394 2 1 1406 QDFFRBN $T=463760 527640 0 0 $X=463760 $Y=527260
X333 1386 110 1394 2 1 1415 QDFFRBN $T=465620 527640 1 0 $X=465620 $Y=522220
X334 1412 110 1394 2 1 1428 QDFFRBN $T=474300 537720 0 0 $X=474300 $Y=537340
X335 1440 110 1394 2 1 1446 QDFFRBN $T=486700 517560 0 0 $X=486700 $Y=517180
X336 1465 110 1394 2 1 1489 QDFFRBN $T=496620 527640 0 0 $X=496620 $Y=527260
X337 1466 110 1394 2 1 1484 QDFFRBN $T=496620 537720 1 0 $X=496620 $Y=532300
X338 1567 110 1560 2 1 317 QDFFRBN $T=540640 557880 0 180 $X=528860 $Y=552460
X339 1591 110 1560 2 1 1539 QDFFRBN $T=544980 547800 0 0 $X=544980 $Y=547420
X340 1589 110 132 2 1 1532 QDFFRBN $T=546840 527640 0 0 $X=546840 $Y=527260
X341 376 110 132 2 1 384 QDFFRBN $T=555520 507480 1 0 $X=555520 $Y=502060
X342 1628 110 1560 2 1 1624 QDFFRBN $T=570400 547800 1 180 $X=558620 $Y=547420
X343 1649 110 1560 2 1 1631 QDFFRBN $T=573500 547800 0 180 $X=561720 $Y=542380
X344 1662 110 1560 2 1 1621 QDFFRBN $T=578460 527640 0 180 $X=566680 $Y=522220
X345 1653 110 1686 2 1 1646 QDFFRBN $T=585900 527640 1 180 $X=574120 $Y=527260
X346 1675 110 1718 2 1 390 QDFFRBN $T=577220 517560 1 0 $X=577220 $Y=512140
X347 1733 110 1718 2 1 399 QDFFRBN $T=604500 507480 1 180 $X=592720 $Y=507100
X348 1744 110 1718 2 1 1745 QDFFRBN $T=606980 527640 0 180 $X=595200 $Y=522220
X349 1831 437 1686 2 1 1862 QDFFRBN $T=620620 517560 1 0 $X=620620 $Y=512140
X350 1852 437 1686 2 1 1910 QDFFRBN $T=628680 527640 1 0 $X=628680 $Y=522220
X351 1889 437 1686 2 1 1932 QDFFRBN $T=639840 527640 0 0 $X=639840 $Y=527260
X352 1914 437 1941 2 1 1953 QDFFRBN $T=647900 547800 0 0 $X=647900 $Y=547420
X353 1878 437 1941 2 1 1965 QDFFRBN $T=652860 547800 1 0 $X=652860 $Y=542380
X354 1957 437 1974 2 1 1989 QDFFRBN $T=661540 547800 0 0 $X=661540 $Y=547420
X355 1864 479 1974 2 1 1986 QDFFRBN $T=661540 567960 1 0 $X=661540 $Y=562540
X356 1937 479 1974 2 1 1995 QDFFRBN $T=665260 578040 1 0 $X=665260 $Y=572620
X357 1967 437 1941 2 1 2009 QDFFRBN $T=665880 547800 1 0 $X=665880 $Y=542380
X358 1971 437 1941 2 1 2000 QDFFRBN $T=667740 527640 0 0 $X=667740 $Y=527260
X359 1985 437 1996 2 1 2001 QDFFRBN $T=670220 527640 1 0 $X=670220 $Y=522220
X360 1984 437 1941 2 1 2002 QDFFRBN $T=670220 537720 1 0 $X=670220 $Y=532300
X361 1962 479 1979 2 1 2008 QDFFRBN $T=672700 588120 1 0 $X=672700 $Y=582700
X362 1991 479 1979 2 1 2015 QDFFRBN $T=674560 567960 0 0 $X=674560 $Y=567580
X363 1983 479 1979 2 1 2018 QDFFRBN $T=678900 578040 1 0 $X=678900 $Y=572620
X364 1978 479 2012 2 1 2019 QDFFRBN $T=678900 588120 0 0 $X=678900 $Y=587740
X365 1999 479 2012 2 1 2047 QDFFRBN $T=679520 598200 1 0 $X=679520 $Y=592780
X366 494 437 1996 2 1 2034 QDFFRBN $T=683860 527640 1 0 $X=683860 $Y=522220
X367 2006 479 2016 2 1 2029 QDFFRBN $T=683860 618360 1 0 $X=683860 $Y=612940
X368 1950 479 1979 2 1 2035 QDFFRBN $T=685100 567960 1 0 $X=685100 $Y=562540
X369 496 437 1996 2 1 2037 QDFFRBN $T=685720 517560 0 0 $X=685720 $Y=517180
X370 1994 479 2012 2 1 2036 QDFFRBN $T=686960 588120 1 0 $X=686960 $Y=582700
X371 500 437 1996 2 1 2040 QDFFRBN $T=687580 517560 1 0 $X=687580 $Y=512140
X372 1969 479 2016 2 1 2038 QDFFRBN $T=687580 608280 0 0 $X=687580 $Y=607900
X373 1924 437 2031 2 1 2039 QDFFRBN $T=688200 547800 0 0 $X=688200 $Y=547420
X374 1972 437 2032 2 1 2041 QDFFRBN $T=688820 547800 1 0 $X=688820 $Y=542380
X375 1980 479 2012 2 1 2071 QDFFRBN $T=693160 598200 0 0 $X=693160 $Y=597820
X376 2026 437 2032 2 1 2044 QDFFRBN $T=693780 527640 0 0 $X=693780 $Y=527260
X377 2028 479 503 2 1 2054 QDFFRBN $T=695020 628440 0 0 $X=695020 $Y=628060
X378 2011 479 2016 2 1 2058 QDFFRBN $T=697500 618360 1 0 $X=697500 $Y=612940
X379 2013 479 503 2 1 2062 QDFFRBN $T=698120 638520 1 0 $X=698120 $Y=633100
X380 508 437 2043 2 1 2025 QDFFRBN $T=711140 507480 1 180 $X=699360 $Y=507100
X381 2010 479 2016 2 1 2065 QDFFRBN $T=701220 608280 0 0 $X=701220 $Y=607900
X382 2042 437 2031 2 1 2064 QDFFRBN $T=701840 547800 0 0 $X=701840 $Y=547420
X383 2049 437 2032 2 1 2066 QDFFRBN $T=704320 547800 1 0 $X=704320 $Y=542380
X384 2050 437 2031 2 1 2073 QDFFRBN $T=704940 567960 1 0 $X=704940 $Y=562540
X385 507 437 2043 2 1 2072 QDFFRBN $T=706800 517560 0 0 $X=706800 $Y=517180
X386 2052 437 2032 2 1 2074 QDFFRBN $T=706800 537720 0 0 $X=706800 $Y=537340
X387 2053 479 2068 2 1 2078 QDFFRBN $T=708040 588120 1 0 $X=708040 $Y=582700
X388 2004 437 2032 2 1 2086 QDFFRBN $T=708660 527640 1 0 $X=708660 $Y=522220
X389 1959 479 2068 2 1 2077 QDFFRBN $T=708660 578040 1 0 $X=708660 $Y=572620
X390 1964 479 2068 2 1 2080 QDFFRBN $T=709280 578040 0 0 $X=709280 $Y=577660
X391 513 437 2043 2 1 2060 QDFFRBN $T=722920 507480 1 180 $X=711140 $Y=507100
X392 2067 437 2031 2 1 2095 QDFFRBN $T=715480 547800 0 0 $X=715480 $Y=547420
X393 2070 437 2091 2 1 2100 QDFFRBN $T=716720 527640 0 0 $X=716720 $Y=527260
X394 512 437 2043 2 1 2107 QDFFRBN $T=720440 517560 0 0 $X=720440 $Y=517180
X395 2083 479 2068 2 1 2094 QDFFRBN $T=721060 578040 0 0 $X=721060 $Y=577660
X396 514 437 510 2 1 2109 QDFFRBN $T=721680 507480 1 0 $X=721680 $Y=502060
X397 2088 437 2089 2 1 2113 QDFFRBN $T=722300 557880 0 0 $X=722300 $Y=557500
X398 1881 437 2091 2 1 2117 QDFFRBN $T=722920 527640 1 0 $X=722920 $Y=522220
X399 2093 437 2089 2 1 2116 QDFFRBN $T=724780 567960 0 0 $X=724780 $Y=567580
X400 2092 479 2103 2 1 2118 QDFFRBN $T=725400 588120 1 0 $X=725400 $Y=582700
X401 2097 479 2103 2 1 2124 QDFFRBN $T=726020 598200 0 0 $X=726020 $Y=597820
X402 2112 437 2091 2 1 2136 QDFFRBN $T=732840 527640 0 0 $X=732840 $Y=527260
X403 2110 479 2103 2 1 2137 QDFFRBN $T=732840 578040 0 0 $X=732840 $Y=577660
X404 2033 437 2091 2 1 2141 QDFFRBN $T=733460 507480 0 0 $X=733460 $Y=507100
X405 2007 437 2091 2 1 2142 QDFFRBN $T=734080 517560 0 0 $X=734080 $Y=517180
X406 2075 437 2138 2 1 2152 QDFFRBN $T=736560 557880 0 0 $X=736560 $Y=557500
X407 2104 479 2103 2 1 2149 QDFFRBN $T=737180 588120 1 0 $X=737180 $Y=582700
X408 2147 437 2091 2 1 2122 QDFFRBN $T=749580 527640 0 180 $X=737800 $Y=522220
X409 2017 437 2138 2 1 2155 QDFFRBN $T=738420 547800 0 0 $X=738420 $Y=547420
X410 2046 437 2138 2 1 2156 QDFFRBN $T=739660 547800 1 0 $X=739660 $Y=542380
X411 2129 479 2089 2 1 2187 QDFFRBN $T=740280 578040 1 0 $X=740280 $Y=572620
X412 2063 479 2103 2 1 2167 QDFFRBN $T=740900 598200 0 0 $X=740900 $Y=597820
X413 2123 479 2165 2 1 2154 QDFFRBN $T=745860 588120 0 0 $X=745860 $Y=587740
X414 2102 479 2165 2 1 2175 QDFFRBN $T=748960 588120 1 0 $X=748960 $Y=582700
X415 2146 437 2138 2 1 2183 QDFFRBN $T=750820 557880 0 0 $X=750820 $Y=557500
X416 2160 437 2138 2 1 2182 QDFFRBN $T=752060 547800 1 0 $X=752060 $Y=542380
X417 2162 479 2157 2 1 538 QDFFRBN $T=753300 578040 0 0 $X=753300 $Y=577660
X418 2014 437 2138 2 1 2196 QDFFRBN $T=753920 547800 0 0 $X=753920 $Y=547420
X419 2159 479 2165 2 1 546 QDFFRBN $T=755780 598200 1 0 $X=755780 $Y=592780
X420 2174 437 2188 2 1 544 QDFFRBN $T=757020 567960 0 0 $X=757020 $Y=567580
X421 2180 479 2165 2 1 556 QDFFRBN $T=762600 588120 1 0 $X=762600 $Y=582700
X422 539 437 2188 2 1 559 QDFFRBN $T=765080 567960 1 0 $X=765080 $Y=562540
X423 2051 437 561 2 1 2239 QDFFRBN $T=771280 517560 1 0 $X=771280 $Y=512140
X424 551 437 2188 2 1 567 QDFFRBN $T=771280 567960 0 0 $X=771280 $Y=567580
X425 2210 437 566 2 1 2227 QDFFRBN $T=773760 507480 1 0 $X=773760 $Y=502060
X426 2111 479 2231 2 1 569 QDFFRBN $T=774380 588120 0 0 $X=774380 $Y=587740
X427 557 479 2214 2 1 571 QDFFRBN $T=775620 578040 0 0 $X=775620 $Y=577660
X428 558 479 2214 2 1 572 QDFFRBN $T=775620 588120 1 0 $X=775620 $Y=582700
X429 2139 479 2232 2 1 2245 QDFFRBN $T=776860 608280 0 0 $X=776860 $Y=607900
X430 2140 479 2232 2 1 2261 QDFFRBN $T=781200 618360 0 0 $X=781200 $Y=617980
X431 2191 479 2232 2 1 2262 QDFFRBN $T=783680 628440 1 0 $X=783680 $Y=623020
X432 2244 479 2232 2 1 2273 QDFFRBN $T=787400 608280 1 0 $X=787400 $Y=602860
X433 575 479 2231 2 1 589 QDFFRBN $T=788020 588120 0 0 $X=788020 $Y=587740
X434 2250 580 2267 2 1 2293 QDFFRBN $T=791120 537720 1 0 $X=791120 $Y=532300
X435 2192 479 2232 2 1 2280 QDFFRBN $T=791120 608280 0 0 $X=791120 $Y=607900
X436 579 479 2231 2 1 595 QDFFRBN $T=791740 598200 0 0 $X=791740 $Y=597820
X437 587 479 2282 2 1 2287 QDFFRBN $T=797320 638520 1 0 $X=797320 $Y=633100
X438 2225 479 2282 2 1 2304 QDFFRBN $T=799800 628440 1 0 $X=799800 $Y=623020
X439 591 479 2282 2 1 2292 QDFFRBN $T=800420 618360 0 0 $X=800420 $Y=617980
X440 593 580 2289 2 1 2299 QDFFRBN $T=801660 588120 0 0 $X=801660 $Y=587740
X441 2276 580 2267 2 1 2296 QDFFRBN $T=802280 547800 0 0 $X=802280 $Y=547420
X442 594 580 2289 2 1 610 QDFFRBN $T=803520 588120 1 0 $X=803520 $Y=582700
X443 596 580 2282 2 1 2303 QDFFRBN $T=805380 608280 0 0 $X=805380 $Y=607900
X444 2233 580 2267 2 1 2308 QDFFRBN $T=806000 547800 1 0 $X=806000 $Y=542380
X445 2218 580 2282 2 1 2312 QDFFRBN $T=807860 608280 1 0 $X=807860 $Y=602860
X446 2230 479 612 2 1 2320 QDFFRBN $T=809720 638520 1 0 $X=809720 $Y=633100
X447 2216 479 2282 2 1 2316 QDFFRBN $T=810340 628440 0 0 $X=810340 $Y=628060
X448 2284 580 2309 2 1 2321 QDFFRBN $T=810960 557880 0 0 $X=810960 $Y=557500
X449 2264 580 2309 2 1 2341 QDFFRBN $T=813440 567960 1 0 $X=813440 $Y=562540
X450 2300 580 2309 2 1 2328 QDFFRBN $T=815300 567960 0 0 $X=815300 $Y=567580
X451 609 580 2289 2 1 620 QDFFRBN $T=815300 588120 0 0 $X=815300 $Y=587740
X452 2286 580 2318 2 1 2340 QDFFRBN $T=816540 537720 0 0 $X=816540 $Y=537340
X453 2222 580 2318 2 1 2327 QDFFRBN $T=819640 547800 1 0 $X=819640 $Y=542380
X454 2311 580 2318 2 1 2352 QDFFRBN $T=822120 527640 0 0 $X=822120 $Y=527260
X455 616 580 2289 2 1 2343 QDFFRBN $T=822120 588120 1 0 $X=822120 $Y=582700
X456 2305 580 2318 2 1 2357 QDFFRBN $T=822740 527640 1 0 $X=822740 $Y=522220
X457 618 580 2344 2 1 2356 QDFFRBN $T=825840 598200 0 0 $X=825840 $Y=597820
X458 2332 580 631 2 1 2383 QDFFRBN $T=828320 507480 0 0 $X=828320 $Y=507100
X459 2310 580 631 2 1 2361 QDFFRBN $T=828940 517560 1 0 $X=828940 $Y=512140
X460 628 580 2344 2 1 2391 QDFFRBN $T=835140 588120 1 0 $X=835140 $Y=582700
X461 629 580 2344 2 1 2417 QDFFRBN $T=835140 588120 0 0 $X=835140 $Y=587740
X462 636 580 2344 2 1 2393 QDFFRBN $T=838860 598200 0 0 $X=838860 $Y=597820
X463 637 580 2324 2 1 2386 QDFFRBN $T=840720 517560 1 0 $X=840720 $Y=512140
X464 639 580 645 2 1 2427 QDFFRBN $T=845060 507480 0 0 $X=845060 $Y=507100
X465 647 580 2324 2 1 2460 QDFFRBN $T=854360 517560 1 0 $X=854360 $Y=512140
X466 656 658 2324 2 1 2488 QDFFRBN $T=865520 507480 0 0 $X=865520 $Y=507100
X467 659 658 2451 2 1 2493 QDFFRBN $T=866760 507480 1 0 $X=866760 $Y=502060
X468 676 658 2451 2 1 2532 QDFFRBN $T=894660 507480 0 180 $X=882880 $Y=502060
X469 677 658 2451 2 1 2520 QDFFRBN $T=895900 517560 0 180 $X=884120 $Y=512140
X470 2642 658 2344 2 1 680 QDFFRBN $T=908300 588120 0 180 $X=896520 $Y=582700
X471 2623 658 2344 2 1 679 QDFFRBN $T=908300 598200 0 180 $X=896520 $Y=592780
X472 685 658 2604 2 1 2632 QDFFRBN $T=899000 507480 1 0 $X=899000 $Y=502060
X473 690 658 2604 2 1 2609 QDFFRBN $T=915740 517560 0 180 $X=903960 $Y=512140
X474 2662 658 2604 2 1 2714 QDFFRBN $T=920080 517560 1 0 $X=920080 $Y=512140
X475 2734 658 2751 2 1 2711 QDFFRBN $T=934340 527640 1 0 $X=934340 $Y=522220
X476 2777 658 2751 2 1 2713 QDFFRBN $T=950460 547800 0 180 $X=938680 $Y=542380
X477 2804 658 2751 2 1 2736 QDFFRBN $T=957900 527640 1 180 $X=946120 $Y=527260
X478 2831 658 713 2 1 710 QDFFRBN $T=964720 608280 1 180 $X=952940 $Y=607900
X479 723 658 718 2 1 2813 QDFFRBN $T=970920 507480 0 180 $X=959140 $Y=502060
X480 2840 658 718 2 1 2758 QDFFRBN $T=972160 527640 1 180 $X=960380 $Y=527260
X481 2830 658 2842 2 1 724 QDFFRBN $T=965340 537720 0 0 $X=965340 $Y=537340
X482 2824 722 713 2 1 719 QDFFRBN $T=965340 638520 0 0 $X=965340 $Y=638140
X483 721 658 718 2 1 2843 QDFFRBN $T=965960 517560 1 0 $X=965960 $Y=512140
X484 2832 722 713 2 1 717 QDFFRBN $T=965960 628440 1 0 $X=965960 $Y=623020
X485 2833 658 2842 2 1 726 QDFFRBN $T=966580 557880 1 0 $X=966580 $Y=552460
X486 2835 658 2842 2 1 2845 QDFFRBN $T=966580 588120 1 0 $X=966580 $Y=582700
X487 2834 658 2842 2 1 720 QDFFRBN $T=967200 578040 0 0 $X=967200 $Y=577660
X488 2836 658 713 2 1 725 QDFFRBN $T=967200 608280 0 0 $X=967200 $Y=607900
X489 2828 658 2842 2 1 728 QDFFRBN $T=967820 578040 1 0 $X=967820 $Y=572620
X490 95 88 1 2 INV3 $T=331080 537720 0 180 $X=328600 $Y=532300
X491 1069 95 1 2 INV3 $T=350920 537720 1 0 $X=350920 $Y=532300
X492 1090 130 1 2 INV3 $T=370140 598200 1 0 $X=370140 $Y=592780
X493 786 2 800 1 INV1S $T=238700 517560 0 180 $X=237460 $Y=512140
X494 18 2 15 1 INV1S $T=244280 618360 1 180 $X=243040 $Y=617980
X495 9 2 825 1 INV1S $T=250480 588120 1 0 $X=250480 $Y=582700
X496 12 2 830 1 INV1S $T=254200 557880 0 0 $X=254200 $Y=557500
X497 36 2 22 1 INV1S $T=263500 608280 0 180 $X=262260 $Y=602860
X498 17 2 853 1 INV1S $T=265360 537720 0 0 $X=265360 $Y=537340
X499 876 2 27 1 INV1S $T=271560 507480 1 180 $X=270320 $Y=507100
X500 48 2 826 1 INV1S $T=278380 608280 0 180 $X=277140 $Y=602860
X501 840 2 886 1 INV1S $T=278380 527640 1 0 $X=278380 $Y=522220
X502 884 2 840 1 INV1S $T=279620 537720 1 180 $X=278380 $Y=537340
X503 840 2 889 1 INV1S $T=279000 547800 0 0 $X=279000 $Y=547420
X504 52 2 49 1 INV1S $T=282100 598200 0 180 $X=280860 $Y=592780
X505 886 2 51 1 INV1S $T=281480 527640 0 0 $X=281480 $Y=527260
X506 877 2 43 1 INV1S $T=283340 537720 1 180 $X=282100 $Y=537340
X507 60 2 55 1 INV1S $T=285200 598200 0 180 $X=283960 $Y=592780
X508 59 2 903 1 INV1S $T=286440 517560 1 180 $X=285200 $Y=517180
X509 911 2 915 1 INV1S $T=290160 527640 1 0 $X=290160 $Y=522220
X510 897 2 916 1 INV1S $T=290780 547800 1 0 $X=290780 $Y=542380
X511 913 2 925 1 INV1S $T=293260 547800 0 0 $X=293260 $Y=547420
X512 875 2 911 1 INV1S $T=298220 547800 1 180 $X=296980 $Y=547420
X513 944 2 934 1 INV1S $T=300700 517560 0 180 $X=299460 $Y=512140
X514 880 2 66 1 INV1S $T=301320 547800 0 0 $X=301320 $Y=547420
X515 951 2 72 1 INV1S $T=303800 507480 0 180 $X=302560 $Y=502060
X516 910 2 949 1 INV1S $T=303800 547800 1 180 $X=302560 $Y=547420
X517 949 2 975 1 INV1S $T=308760 547800 1 0 $X=308760 $Y=542380
X518 971 2 974 1 INV1S $T=309380 507480 0 0 $X=309380 $Y=507100
X519 941 2 991 1 INV1S $T=315580 537720 1 0 $X=315580 $Y=532300
X520 1022 2 1007 1 INV1S $T=324260 527640 0 180 $X=323020 $Y=522220
X521 94 2 1071 1 INV1S $T=344100 527640 1 0 $X=344100 $Y=522220
X522 1071 2 1001 1 INV1S $T=347200 517560 0 0 $X=347200 $Y=517180
X523 1069 2 1064 1 INV1S $T=349060 547800 1 180 $X=347820 $Y=547420
X524 108 2 106 1 INV1S $T=351540 507480 1 180 $X=350300 $Y=507100
X525 1043 2 1103 1 INV1S $T=358360 517560 0 0 $X=358360 $Y=517180
X526 1116 2 1112 1 INV1S $T=363940 527640 1 180 $X=362700 $Y=527260
X527 48 2 1121 1 INV1S $T=365800 608280 0 0 $X=365800 $Y=607900
X528 48 2 132 1 INV1S $T=376960 507480 0 0 $X=376960 $Y=507100
X529 88 2 1155 1 INV1S $T=378820 517560 0 0 $X=378820 $Y=517180
X530 1133 2 1173 1 INV1S $T=385020 547800 0 0 $X=385020 $Y=547420
X531 1173 2 1181 1 INV1S $T=386260 547800 0 0 $X=386260 $Y=547420
X532 1173 2 1120 1 INV1S $T=386260 567960 1 0 $X=386260 $Y=562540
X533 138 2 1169 1 INV1S $T=389360 507480 1 180 $X=388120 $Y=507100
X534 148 2 1133 1 INV1S $T=398660 517560 0 180 $X=397420 $Y=512140
X535 154 2 156 1 INV1S $T=406720 507480 1 0 $X=406720 $Y=502060
X536 148 2 1229 1 INV1S $T=406720 517560 1 0 $X=406720 $Y=512140
X537 1208 2 152 1 INV1S $T=411060 517560 1 0 $X=411060 $Y=512140
X538 1240 2 1209 1 INV1S $T=415400 557880 0 180 $X=414160 $Y=552460
X539 1240 2 145 1 INV1S $T=416640 537720 1 180 $X=415400 $Y=537340
X540 166 2 163 1 INV1S $T=419120 507480 0 180 $X=417880 $Y=502060
X541 169 2 176 1 INV1S $T=422220 507480 1 0 $X=422220 $Y=502060
X542 174 2 1240 1 INV1S $T=425320 537720 0 180 $X=424080 $Y=532300
X543 160 2 1248 1 INV1S $T=425320 547800 1 180 $X=424080 $Y=547420
X544 1203 2 1330 1 INV1S $T=447640 537720 0 0 $X=447640 $Y=537340
X545 1340 2 1323 1 INV1S $T=448880 588120 1 180 $X=447640 $Y=587740
X546 1326 2 1344 1 INV1S $T=450740 537720 0 0 $X=450740 $Y=537340
X547 1350 2 1359 1 INV1S $T=456940 598200 1 0 $X=456940 $Y=592780
X548 1379 2 1347 1 INV1S $T=463140 588120 0 180 $X=461900 $Y=582700
X549 1355 2 1356 1 INV1S $T=465620 537720 1 0 $X=465620 $Y=532300
X550 1157 2 1329 1 INV1S $T=465620 618360 0 0 $X=465620 $Y=617980
X551 1393 2 1382 1 INV1S $T=472440 578040 1 180 $X=471200 $Y=577660
X552 1406 2 212 1 INV1S $T=474300 537720 1 180 $X=473060 $Y=537340
X553 243 2 202 1 INV1S $T=476780 618360 1 180 $X=475540 $Y=617980
X554 1388 2 1439 1 INV1S $T=483600 608280 1 0 $X=483600 $Y=602860
X555 116 2 238 1 INV1S $T=483600 628440 0 0 $X=483600 $Y=628060
X556 245 2 206 1 INV1S $T=487940 628440 1 180 $X=486700 $Y=628060
X557 1450 2 1457 1 INV1S $T=491660 618360 0 0 $X=491660 $Y=617980
X558 1446 2 236 1 INV1S $T=496620 527640 0 180 $X=495380 $Y=522220
X559 1472 2 1462 1 INV1S $T=496620 598200 1 180 $X=495380 $Y=597820
X560 1432 2 1470 1 INV1S $T=495380 618360 0 0 $X=495380 $Y=617980
X561 216 2 274 1 INV1S $T=498480 608280 0 0 $X=498480 $Y=607900
X562 262 2 215 1 INV1S $T=499720 618360 0 180 $X=498480 $Y=612940
X563 1473 2 267 1 INV1S $T=500340 517560 1 0 $X=500340 $Y=512140
X564 285 2 1413 1 INV1S $T=504680 537720 1 180 $X=503440 $Y=537340
X565 287 2 1473 1 INV1S $T=505300 507480 1 180 $X=504060 $Y=507100
X566 1428 2 1485 1 INV1S $T=504060 578040 0 0 $X=504060 $Y=577660
X567 1318 2 1486 1 INV1S $T=504060 598200 0 0 $X=504060 $Y=597820
X568 304 2 227 1 INV1S $T=513360 628440 0 180 $X=512120 $Y=623020
X569 1157 2 289 1 INV1S $T=515840 638520 0 180 $X=514600 $Y=633100
X570 1518 2 1513 1 INV1S $T=517080 628440 0 180 $X=515840 $Y=623020
X571 1489 2 1529 1 INV1S $T=518320 527640 0 0 $X=518320 $Y=527260
X572 1525 2 1519 1 INV1S $T=520180 628440 1 180 $X=518940 $Y=628060
X573 1538 2 311 1 INV1S $T=520800 628440 0 180 $X=519560 $Y=623020
X574 319 2 251 1 INV1S $T=523280 608280 0 180 $X=522040 $Y=602860
X575 1545 2 308 1 INV1S $T=526380 517560 0 180 $X=525140 $Y=512140
X576 317 2 1543 1 INV1S $T=527000 547800 0 0 $X=527000 $Y=547420
X577 1550 2 320 1 INV1S $T=528860 517560 1 180 $X=527620 $Y=517180
X578 331 2 1550 1 INV1S $T=529480 517560 0 0 $X=529480 $Y=517180
X579 333 2 1561 1 INV1S $T=530720 608280 1 0 $X=530720 $Y=602860
X580 1555 2 336 1 INV1S $T=531340 638520 0 0 $X=531340 $Y=638140
X581 1561 2 346 1 INV1S $T=531960 628440 1 0 $X=531960 $Y=623020
X582 1573 2 1556 1 INV1S $T=535680 578040 1 180 $X=534440 $Y=577660
X583 304 2 355 1 INV1S $T=536920 618360 1 0 $X=536920 $Y=612940
X584 1542 2 1585 1 INV1S $T=539400 547800 1 0 $X=539400 $Y=542380
X585 1539 2 1580 1 INV1S $T=541260 567960 1 180 $X=540020 $Y=567580
X586 1595 2 1586 1 INV1S $T=543740 618360 1 180 $X=542500 $Y=617980
X587 1581 2 364 1 INV1S $T=543120 517560 1 0 $X=543120 $Y=512140
X588 214 2 1584 1 INV1S $T=543120 628440 1 0 $X=543120 $Y=623020
X589 361 2 1593 1 INV1S $T=544980 567960 0 0 $X=544980 $Y=567580
X590 188 2 1595 1 INV1S $T=546220 618360 1 0 $X=546220 $Y=612940
X591 368 2 1453 1 INV1S $T=548080 557880 0 180 $X=546840 $Y=552460
X592 1571 2 344 1 INV1S $T=548080 517560 0 0 $X=548080 $Y=517180
X593 360 2 365 1 INV1S $T=549940 638520 1 180 $X=548700 $Y=638140
X594 274 2 1604 1 INV1S $T=553660 608280 1 180 $X=552420 $Y=607900
X595 1599 2 1618 1 INV1S $T=554900 598200 1 0 $X=554900 $Y=592780
X596 1646 2 1571 1 INV1S $T=565440 527640 0 180 $X=564200 $Y=522220
X597 1595 2 380 1 INV1S $T=565440 628440 1 180 $X=564200 $Y=628060
X598 1660 2 1650 1 INV1S $T=569160 618360 0 180 $X=567920 $Y=612940
X599 254 2 1673 1 INV1S $T=572260 618360 1 0 $X=572260 $Y=612940
X600 1682 2 1684 1 INV1S $T=575980 598200 0 0 $X=575980 $Y=597820
X601 390 2 1669 1 INV1S $T=578460 507480 1 180 $X=577220 $Y=507100
X602 1486 2 397 1 INV1S $T=577220 598200 1 0 $X=577220 $Y=592780
X603 1584 2 418 1 INV1S $T=579080 608280 0 0 $X=579080 $Y=607900
X604 1618 2 1709 1 INV1S $T=582800 598200 0 0 $X=582800 $Y=597820
X605 328 2 408 1 INV1S $T=588380 638520 1 0 $X=588380 $Y=633100
X606 328 2 1732 1 INV1S $T=589000 608280 1 0 $X=589000 $Y=602860
X607 1618 2 1736 1 INV1S $T=590240 608280 1 0 $X=590240 $Y=602860
X608 1618 2 1743 1 INV1S $T=592720 608280 1 0 $X=592720 $Y=602860
X609 1745 2 412 1 INV1S $T=593960 507480 1 0 $X=593960 $Y=502060
X610 1618 2 1815 1 INV1S $T=614420 598200 0 0 $X=614420 $Y=597820
X611 218 2 1797 1 INV1S $T=615040 608280 0 0 $X=615040 $Y=607900
X612 1583 2 433 1 INV1S $T=615660 517560 1 0 $X=615660 $Y=512140
X613 1618 2 1827 1 INV1S $T=618760 608280 0 0 $X=618760 $Y=607900
X614 440 2 444 1 INV1S $T=626200 507480 1 0 $X=626200 $Y=502060
X615 1841 2 1840 1 INV1S $T=626820 628440 0 0 $X=626820 $Y=628060
X616 1857 2 1869 1 INV1S $T=630540 547800 1 0 $X=630540 $Y=542380
X617 1872 2 1846 1 INV1S $T=631780 638520 1 180 $X=630540 $Y=638140
X618 1863 2 1871 1 INV1S $T=631780 628440 0 0 $X=631780 $Y=628060
X619 450 2 1918 1 INV1S $T=642940 588120 1 0 $X=642940 $Y=582700
X620 1886 2 1902 1 INV1S $T=643560 547800 0 0 $X=643560 $Y=547420
X621 450 2 1905 1 INV1S $T=647900 588120 1 180 $X=646660 $Y=587740
X622 450 2 1921 1 INV1S $T=648520 628440 0 0 $X=648520 $Y=628060
X623 463 2 1919 1 INV1S $T=649140 507480 0 0 $X=649140 $Y=507100
X624 1925 2 1928 1 INV1S $T=652240 517560 0 0 $X=652240 $Y=517180
X625 1915 2 1931 1 INV1S $T=652860 527640 1 0 $X=652860 $Y=522220
X626 1895 2 1942 1 INV1S $T=655340 527640 0 0 $X=655340 $Y=527260
X627 470 2 464 1 INV1S $T=662160 628440 0 180 $X=660920 $Y=623020
X628 1936 2 1954 1 INV1S $T=662160 507480 0 0 $X=662160 $Y=507100
X629 1956 2 1973 1 INV1S $T=667120 507480 0 0 $X=667120 $Y=507100
X630 477 2 483 1 INV1S $T=670220 638520 0 0 $X=670220 $Y=638140
X631 1961 2 1987 1 INV1S $T=671460 507480 1 0 $X=671460 $Y=502060
X632 1574 2 469 1 INV1S $T=673320 628440 1 0 $X=673320 $Y=623020
X633 1982 2 1990 1 INV1S $T=674560 507480 1 0 $X=674560 $Y=502060
X634 469 2 462 1 INV1S $T=676420 628440 1 0 $X=676420 $Y=623020
X635 489 2 1988 1 INV1S $T=678900 507480 1 0 $X=678900 $Y=502060
X636 490 2 492 1 INV1S $T=679520 537720 0 0 $X=679520 $Y=537340
X637 2002 2 2020 1 INV1S $T=688200 537720 0 0 $X=688200 $Y=537340
X638 1923 2 2022 1 INV1S $T=691300 537720 1 0 $X=691300 $Y=532300
X639 1574 2 501 1 INV1S $T=691300 628440 0 0 $X=691300 $Y=628060
X640 2044 2 2057 1 INV1S $T=703080 608280 1 0 $X=703080 $Y=602860
X641 2064 2 2069 1 INV1S $T=714860 608280 0 0 $X=714860 $Y=607900
X642 2074 2 2079 1 INV1S $T=719820 547800 1 0 $X=719820 $Y=542380
X643 2078 2 2081 1 INV1S $T=720440 588120 0 0 $X=720440 $Y=587740
X644 2066 2 2084 1 INV1S $T=720440 598200 0 0 $X=720440 $Y=597820
X645 2098 2 503 1 INV1S $T=724160 628440 0 180 $X=722920 $Y=623020
X646 2094 2 2105 1 INV1S $T=726640 608280 0 0 $X=726640 $Y=607900
X647 2095 2 2114 1 INV1S $T=726640 618360 0 0 $X=726640 $Y=617980
X648 517 2 2098 1 INV1S $T=728500 628440 0 0 $X=728500 $Y=628060
X649 2009 2 2106 1 INV1S $T=730360 537720 0 0 $X=730360 $Y=537340
X650 2119 2 2126 1 INV1S $T=738420 618360 0 0 $X=738420 $Y=617980
X651 2125 2 2128 1 INV1S $T=739040 628440 0 0 $X=739040 $Y=628060
X652 2120 2 2130 1 INV1S $T=740900 567960 1 0 $X=740900 $Y=562540
X653 2118 2 528 1 INV1S $T=745860 567960 1 0 $X=745860 $Y=562540
X654 2137 2 2145 1 INV1S $T=747100 608280 1 0 $X=747100 $Y=602860
X655 2000 2 2168 1 INV1S $T=748960 527640 0 0 $X=748960 $Y=527260
X656 2141 2 2166 1 INV1S $T=750200 507480 1 0 $X=750200 $Y=502060
X657 2154 2 533 1 INV1S $T=750200 628440 0 0 $X=750200 $Y=628060
X658 2142 2 2161 1 INV1S $T=751440 527640 1 0 $X=751440 $Y=522220
X659 2116 2 2170 1 INV1S $T=753920 567960 0 0 $X=753920 $Y=567580
X660 2136 2 2189 1 INV1S $T=756400 598200 0 0 $X=756400 $Y=597820
X661 2172 2 2163 1 INV1S $T=757640 618360 1 180 $X=756400 $Y=617980
X662 2169 2 2177 1 INV1S $T=759500 618360 0 0 $X=759500 $Y=617980
X663 2086 2 2176 1 INV1S $T=763220 527640 1 180 $X=761980 $Y=527260
X664 2124 2 545 1 INV1S $T=765080 507480 1 0 $X=765080 $Y=502060
X665 2073 2 540 1 INV1S $T=765080 517560 1 0 $X=765080 $Y=512140
X666 2117 2 2194 1 INV1S $T=765080 517560 0 0 $X=765080 $Y=517180
X667 2100 2 2195 1 INV1S $T=765080 527640 0 0 $X=765080 $Y=527260
X668 2187 2 2190 1 INV1S $T=765080 578040 0 0 $X=765080 $Y=577660
X669 2149 2 542 1 INV1S $T=766320 517560 1 0 $X=766320 $Y=512140
X670 2182 2 2197 1 INV1S $T=767560 547800 1 0 $X=767560 $Y=542380
X671 2155 2 555 1 INV1S $T=768800 507480 0 0 $X=768800 $Y=507100
X672 2183 2 548 1 INV1S $T=768800 517560 0 0 $X=768800 $Y=517180
X673 2156 2 2198 1 INV1S $T=768800 527640 0 0 $X=768800 $Y=527260
X674 2152 2 550 1 INV1S $T=768800 537720 1 0 $X=768800 $Y=532300
X675 2196 2 2203 1 INV1S $T=768800 547800 1 0 $X=768800 $Y=542380
X676 2113 2 2199 1 INV1S $T=768800 547800 0 0 $X=768800 $Y=547420
X677 547 2 2204 1 INV1S $T=770660 638520 1 0 $X=770660 $Y=633100
X678 2185 2 2201 1 INV1S $T=771280 598200 0 0 $X=771280 $Y=597820
X679 2202 2 2200 1 INV1S $T=772520 618360 1 180 $X=771280 $Y=617980
X680 2209 2 2205 1 INV1S $T=775000 547800 0 180 $X=773760 $Y=542380
X681 2001 2 2219 1 INV1S $T=774380 517560 0 0 $X=774380 $Y=517180
X682 2220 2 2228 1 INV1S $T=779340 537720 1 0 $X=779340 $Y=532300
X683 2237 2 2254 1 INV1S $T=785540 517560 0 0 $X=785540 $Y=517180
X684 2098 2 561 1 INV1S $T=790500 517560 0 180 $X=789260 $Y=512140
X685 2251 2 2234 1 INV1S $T=790500 547800 0 180 $X=789260 $Y=542380
X686 2241 2 2252 1 INV1S $T=789880 557880 0 0 $X=789880 $Y=557500
X687 577 2 2259 1 INV1S $T=790500 578040 0 0 $X=790500 $Y=577660
X688 2236 2 2247 1 INV1S $T=790500 638520 1 0 $X=790500 $Y=633100
X689 574 2 578 1 INV1S $T=791120 588120 1 0 $X=791120 $Y=582700
X690 2249 2 2258 1 INV1S $T=791740 578040 1 0 $X=791740 $Y=572620
X691 2098 2 2232 1 INV1S $T=796700 618360 0 0 $X=796700 $Y=617980
X692 581 2 588 1 INV1S $T=797940 588120 1 0 $X=797940 $Y=582700
X693 584 2 2268 1 INV1S $T=797940 628440 1 0 $X=797940 $Y=623020
X694 2248 2 2281 1 INV1S $T=798560 557880 1 0 $X=798560 $Y=552460
X695 2184 2 592 1 INV1S $T=799800 547800 0 0 $X=799800 $Y=547420
X696 2239 2 598 1 INV1S $T=804140 507480 1 0 $X=804140 $Y=502060
X697 2269 2 2283 1 INV1S $T=804140 517560 1 0 $X=804140 $Y=512140
X698 2175 2 600 1 INV1S $T=807240 557880 0 0 $X=807240 $Y=557500
X699 2272 2 2302 1 INV1S $T=809720 507480 0 0 $X=809720 $Y=507100
X700 2167 2 605 1 INV1S $T=810340 567960 1 0 $X=810340 $Y=562540
X701 2288 2 2306 1 INV1S $T=812820 527640 0 0 $X=812820 $Y=527260
X702 602 2 606 1 INV1S $T=812820 598200 0 0 $X=812820 $Y=597820
X703 608 2 611 1 INV1S $T=815920 598200 0 0 $X=815920 $Y=597820
X704 2292 2 2313 1 INV1S $T=819020 517560 1 0 $X=819020 $Y=512140
X705 2299 2 614 1 INV1S $T=821500 517560 0 0 $X=821500 $Y=517180
X706 613 2 615 1 INV1S $T=821500 598200 0 0 $X=821500 $Y=597820
X707 2307 2 2314 1 INV1S $T=821500 608280 0 0 $X=821500 $Y=607900
X708 2314 2 2319 1 INV1S $T=822120 608280 1 0 $X=822120 $Y=602860
X709 2098 2 2324 1 INV1S $T=823980 517560 1 0 $X=823980 $Y=512140
X710 2303 2 622 1 INV1S $T=824600 507480 1 0 $X=824600 $Y=502060
X711 2287 2 621 1 INV1S $T=824600 507480 0 0 $X=824600 $Y=507100
X712 2315 2 2349 1 INV1S $T=830180 628440 1 0 $X=830180 $Y=623020
X713 2339 2 2307 1 INV1S $T=832040 628440 1 180 $X=830800 $Y=628060
X714 619 2 2339 1 INV1S $T=830800 638520 1 0 $X=830800 $Y=633100
X715 2343 2 2353 1 INV1S $T=833900 517560 0 0 $X=833900 $Y=517180
X716 627 2 624 1 INV1S $T=835760 608280 1 180 $X=834520 $Y=607900
X717 2349 2 2325 1 INV1S $T=837620 618360 1 180 $X=836380 $Y=617980
X718 632 2 634 1 INV1S $T=837000 608280 1 0 $X=837000 $Y=602860
X719 2371 2 2363 1 INV1S $T=840720 628440 0 180 $X=839480 $Y=623020
X720 2371 2 2350 1 INV1S $T=840720 628440 1 180 $X=839480 $Y=628060
X721 2356 2 2390 1 INV1S $T=845680 537720 1 0 $X=845680 $Y=532300
X722 2393 2 2396 1 INV1S $T=848160 537720 1 0 $X=848160 $Y=532300
X723 640 2 2371 1 INV1S $T=851260 638520 0 180 $X=850020 $Y=633100
X724 2358 2 2409 1 INV1S $T=851260 527640 0 0 $X=851260 $Y=527260
X725 2409 2 2422 1 INV1S $T=851880 527640 1 0 $X=851880 $Y=522220
X726 2369 2 2426 1 INV1S $T=851880 537720 1 0 $X=851880 $Y=532300
X727 644 2 646 1 INV1S $T=851880 598200 0 0 $X=851880 $Y=597820
X728 2416 2 2405 1 INV1S $T=854980 598200 0 0 $X=854980 $Y=597820
X729 2426 2 2429 1 INV1S $T=856840 537720 1 0 $X=856840 $Y=532300
X730 2426 2 2430 1 INV1S $T=858080 537720 1 0 $X=858080 $Y=532300
X731 2433 2 2401 1 INV1S $T=865520 588120 1 180 $X=864280 $Y=587740
X732 2405 2 2464 1 INV1S $T=865520 608280 1 0 $X=865520 $Y=602860
X733 2391 2 2515 1 INV1S $T=868620 517560 1 0 $X=868620 $Y=512140
X734 2464 2 2468 1 INV1S $T=868620 608280 1 0 $X=868620 $Y=602860
X735 2464 2 2472 1 INV1S $T=869860 618360 1 0 $X=869860 $Y=612940
X736 2497 2 2502 1 INV1S $T=876060 588120 1 0 $X=876060 $Y=582700
X737 657 2 2485 1 INV1S $T=876060 618360 0 0 $X=876060 $Y=617980
X738 2517 2 2542 1 INV1S $T=881020 608280 1 0 $X=881020 $Y=602860
X739 2498 2 2538 1 INV1S $T=882880 588120 0 0 $X=882880 $Y=587740
X740 2536 2 2553 1 INV1S $T=886600 547800 0 0 $X=886600 $Y=547420
X741 2547 2 2552 1 INV1S $T=887840 598200 1 0 $X=887840 $Y=592780
X742 2563 2 2574 1 INV1S $T=892180 598200 0 0 $X=892180 $Y=597820
X743 2574 2 2588 1 INV1S $T=893420 598200 0 0 $X=893420 $Y=597820
X744 2542 2 2580 1 INV1S $T=893420 608280 1 0 $X=893420 $Y=602860
X745 2580 2 2549 1 INV1S $T=894660 618360 0 180 $X=893420 $Y=612940
X746 2580 2 2584 1 INV1S $T=894040 608280 0 0 $X=894040 $Y=607900
X747 2482 2 2590 1 INV1S $T=895900 537720 1 0 $X=895900 $Y=532300
X748 2590 2 2551 1 INV1S $T=897140 537720 1 180 $X=895900 $Y=537340
X749 2487 2 2593 1 INV1S $T=895900 547800 0 0 $X=895900 $Y=547420
X750 2588 2 2591 1 INV1S $T=898380 598200 1 180 $X=897140 $Y=597820
X751 2588 2 2608 1 INV1S $T=899000 608280 0 0 $X=899000 $Y=607900
X752 2590 2 2598 1 INV1S $T=899620 537720 0 0 $X=899620 $Y=537340
X753 679 2 2624 1 INV1S $T=906440 598200 0 0 $X=906440 $Y=597820
X754 2572 2 2643 1 INV1S $T=908920 598200 0 0 $X=908920 $Y=597820
X755 2606 2 2652 1 INV1S $T=913260 598200 1 0 $X=913260 $Y=592780
X756 680 2 2656 1 INV1S $T=913880 588120 1 0 $X=913880 $Y=582700
X757 2545 2 2668 1 INV1S $T=917600 628440 1 0 $X=917600 $Y=623020
X758 2583 2 2686 1 INV1S $T=920700 628440 0 0 $X=920700 $Y=628060
X759 2689 2 2687 1 INV1S $T=922560 638520 0 180 $X=921320 $Y=633100
X760 2561 2 2699 1 INV1S $T=925040 547800 0 0 $X=925040 $Y=547420
X761 697 2 2695 1 INV1S $T=925040 557880 1 0 $X=925040 $Y=552460
X762 698 2 2704 1 INV1S $T=925660 567960 1 0 $X=925660 $Y=562540
X763 2713 2 2696 1 INV1S $T=927520 547800 1 180 $X=926280 $Y=547420
X764 2674 2 2709 1 INV1S $T=928140 608280 0 0 $X=928140 $Y=607900
X765 2709 2 2718 1 INV1S $T=928760 608280 1 0 $X=928760 $Y=602860
X766 2685 2 2720 1 INV1S $T=930620 588120 0 0 $X=930620 $Y=587740
X767 2718 2 2707 1 INV1S $T=931240 598200 1 0 $X=931240 $Y=592780
X768 2733 2 2737 1 INV1S $T=934340 578040 0 0 $X=934340 $Y=577660
X769 2716 2 704 1 INV1S $T=934960 547800 0 0 $X=934960 $Y=547420
X770 2629 2 2745 1 INV1S $T=937440 608280 0 0 $X=937440 $Y=607900
X771 2728 2 2764 1 INV1S $T=940540 618360 1 0 $X=940540 $Y=612940
X772 2740 2 705 1 INV1S $T=940540 638520 0 0 $X=940540 $Y=638140
X773 2620 2 2767 1 INV1S $T=946120 578040 0 180 $X=944880 $Y=572620
X774 2757 2 2770 1 INV1S $T=945500 588120 1 0 $X=945500 $Y=582700
X775 2774 2 2759 1 INV1S $T=950460 517560 0 180 $X=949220 $Y=512140
X776 2725 2 2773 1 INV1S $T=951080 578040 1 180 $X=949840 $Y=577660
X777 2814 2 2777 1 INV1S $T=953560 537720 1 180 $X=952320 $Y=537340
X778 2537 2 2790 1 INV1S $T=953560 557880 0 180 $X=952320 $Y=552460
X779 2765 2 2780 1 INV1S $T=953560 638520 1 180 $X=952320 $Y=638140
X780 2655 2 2802 1 INV1S $T=952940 578040 0 0 $X=952940 $Y=577660
X781 2808 2 2812 1 INV1S $T=958520 598200 0 0 $X=958520 $Y=597820
X782 2763 2 2818 1 INV1S $T=959760 588120 1 0 $X=959760 $Y=582700
X783 2813 2 2822 1 INV1S $T=960380 517560 1 0 $X=960380 $Y=512140
X784 2794 2 2830 1 INV1S $T=961000 537720 0 0 $X=961000 $Y=537340
X785 2820 2 2809 1 INV1S $T=962240 618360 1 180 $X=961000 $Y=617980
X786 727 2 2817 1 INV1S $T=962240 638520 0 180 $X=961000 $Y=633100
X787 2807 2 2823 1 INV1S $T=962240 547800 1 0 $X=962240 $Y=542380
X788 2743 2 2827 1 INV1S $T=962860 598200 0 0 $X=962860 $Y=597820
X789 720 2 2821 1 INV1S $T=965340 578040 1 180 $X=964100 $Y=577660
X790 724 2 2819 1 INV1S $T=968440 547800 0 180 $X=967200 $Y=542380
X791 728 2 2826 1 INV1S $T=974640 567960 0 180 $X=973400 $Y=562540
X792 2815 2 2816 1 INV1S $T=974020 618360 1 0 $X=974020 $Y=612940
X793 2825 2 2811 1 INV1S $T=974020 628440 0 0 $X=974020 $Y=628060
X794 726 2 2838 1 INV1S $T=977120 557880 1 180 $X=975880 $Y=557500
X795 2845 2 2841 1 INV1S $T=977120 598200 0 180 $X=975880 $Y=592780
X796 874 28 2 18 855 1 846 FA1 $T=276520 598200 0 180 $X=261020 $Y=592780
X797 44 817 2 830 878 1 847 FA1 $T=277140 557880 1 180 $X=261640 $Y=557500
X798 910 832 2 825 846 1 862 FA1 $T=285200 578040 1 180 $X=269700 $Y=577660
X799 941 882 2 52 932 1 863 FA1 $T=297600 608280 0 180 $X=282100 $Y=602860
X800 987 952 2 920 983 1 939 FA1 $T=314340 567960 1 180 $X=298840 $Y=567580
X801 1008 981 2 52 973 1 966 FA1 $T=323640 598200 1 180 $X=308140 $Y=597820
X802 1016 982 2 60 1009 1 973 FA1 $T=326740 608280 0 180 $X=311240 $Y=602860
X803 91 896 2 18 1024 1 885 FA1 $T=331080 588120 0 180 $X=315580 $Y=582700
X804 1015 1000 2 999 1027 1 986 FA1 $T=331700 567960 0 180 $X=316200 $Y=562540
X805 1037 986 2 995 1002 1 983 FA1 $T=331700 567960 1 180 $X=316200 $Y=567580
X806 83 961 2 36 966 1 1024 FA1 $T=316820 588120 0 0 $X=316820 $Y=587740
X807 1078 1031 2 1056 1066 1 1035 FA1 $T=350920 588120 0 180 $X=335420 $Y=582700
X808 1780 1754 2 1740 1773 1 1735 FA1 $T=606360 618360 1 180 $X=590860 $Y=617980
X809 1822 1765 2 1789 1819 1 1773 FA1 $T=619380 618360 0 180 $X=603880 $Y=612940
X810 1783 1806 2 1752 1791 1 1832 FA1 $T=607600 557880 1 0 $X=607600 $Y=552460
X811 1831 1774 2 1769 1812 1 1791 FA1 $T=625580 527640 0 180 $X=610080 $Y=522220
X812 1865 1821 2 1778 1813 1 1808 FA1 $T=629300 567960 1 180 $X=613800 $Y=567580
X813 1852 1800 2 1829 1849 1 1812 FA1 $T=630540 537720 0 180 $X=615040 $Y=532300
X814 1864 1803 2 1777 1832 1 1813 FA1 $T=630540 557880 1 180 $X=615040 $Y=557500
X815 1874 1830 2 1840 1851 1 1819 FA1 $T=634880 618360 0 180 $X=619380 $Y=612940
X816 1828 1855 2 1810 1808 1 1866 FA1 $T=620000 578040 1 0 $X=620000 $Y=572620
X817 1856 1887 2 1850 1866 1 1903 FA1 $T=629920 588120 0 0 $X=629920 $Y=587740
X818 1889 1853 2 1869 1912 1 1849 FA1 $T=649140 537720 0 180 $X=633640 $Y=532300
X819 1878 1902 2 1908 1882 1 1912 FA1 $T=635500 547800 1 0 $X=635500 $Y=542380
X820 1924 1892 2 1890 1897 1 1882 FA1 $T=651620 557880 0 180 $X=636120 $Y=552460
X821 1949 1916 2 1917 1943 1 1897 FA1 $T=659060 567960 0 180 $X=643560 $Y=562540
X822 1901 1933 2 1875 1903 1 1963 FA1 $T=644180 598200 0 0 $X=644180 $Y=597820
X823 1984 1942 2 1906 1946 1 1923 FA1 $T=667120 537720 0 180 $X=651620 $Y=532300
X824 1934 1898 2 1968 1930 1 482 FA1 $T=654100 638520 1 0 $X=654100 $Y=633100
X825 1969 488 2 1780 1976 1 2006 FA1 $T=667120 618360 1 0 $X=667120 $Y=612940
X826 2007 1990 2 1988 2003 1 1977 FA1 $T=685100 507480 1 180 $X=669600 $Y=507100
X827 1981 491 2 1822 1960 1 2010 FA1 $T=670220 608280 0 0 $X=670220 $Y=607900
X828 2033 498 2 499 502 1 2003 FA1 $T=697500 507480 0 180 $X=682000 $Y=502060
X829 2051 2008 2 2036 2027 1 2023 FA1 $T=708040 578040 1 180 $X=692540 $Y=577660
X830 2017 2019 2 2047 2023 1 2055 FA1 $T=692540 588120 0 0 $X=692540 $Y=587740
X831 2076 2030 2 2054 2056 1 2045 FA1 $T=718580 628440 0 180 $X=703080 $Y=623020
X832 2050 2071 2 2024 2055 1 2090 FA1 $T=708040 598200 1 0 $X=708040 $Y=592780
X833 2092 2062 2 509 2045 1 2059 FA1 $T=725400 628440 1 180 $X=709900 $Y=628060
X834 2097 2029 2 2058 2061 1 2056 FA1 $T=726020 618360 0 180 $X=710520 $Y=612940
X835 2104 2065 2 2038 2090 1 2061 FA1 $T=726640 608280 0 180 $X=711140 $Y=602860
X836 2063 515 2 516 2059 1 2099 FA1 $T=712380 638520 1 0 $X=712380 $Y=633100
X837 2123 2020 2 2009 2115 1 2087 FA1 $T=738420 547800 0 180 $X=722920 $Y=542380
X838 2102 523 2 525 2099 1 2143 FA1 $T=729740 638520 1 0 $X=729740 $Y=633100
X839 2159 2000 2 2106 2148 1 2115 FA1 $T=751440 537720 1 180 $X=735940 $Y=537340
X840 2180 2141 2 2161 2150 1 2144 FA1 $T=763220 517560 0 180 $X=747720 $Y=512140
X841 2146 535 2 534 2143 1 537 FA1 $T=747720 638520 1 0 $X=747720 $Y=633100
X842 2186 2166 2 2132 531 1 2150 FA1 $T=764460 507480 1 180 $X=748960 $Y=507100
X843 2162 2142 2 2176 2144 1 2193 FA1 $T=752680 527640 1 0 $X=752680 $Y=522220
X844 2174 2086 2 2168 2193 1 2148 FA1 $T=768800 537720 1 180 $X=753300 $Y=537340
X845 2662 2515 2 700 2721 1 2723 FA1 $T=915120 507480 1 0 $X=915120 $Y=502060
X846 838 2 29 17 25 1 849 FA1S $T=256060 507480 0 0 $X=256060 $Y=507100
X847 866 2 830 854 862 1 870 FA1S $T=265360 567960 1 0 $X=265360 $Y=562540
X848 869 2 853 827 866 1 884 FA1S $T=266600 547800 1 0 $X=266600 $Y=542380
X849 878 2 825 856 885 1 858 FA1S $T=281480 588120 0 180 $X=269700 $Y=582700
X850 892 2 901 879 907 1 914 FA1S $T=276520 578040 1 0 $X=276520 $Y=572620
X851 897 2 902 881 904 1 913 FA1S $T=277760 537720 1 0 $X=277760 $Y=532300
X852 905 2 892 895 899 1 920 FA1S $T=280860 557880 0 0 $X=280860 $Y=557500
X853 909 2 894 888 61 1 922 FA1S $T=282100 507480 0 0 $X=282100 $Y=507100
X854 933 2 925 905 939 1 954 FA1S $T=292020 557880 1 0 $X=292020 $Y=552460
X855 927 2 938 916 933 1 959 FA1S $T=293880 547800 1 0 $X=293880 $Y=542380
X856 69 2 934 922 68 1 64 FA1S $T=295740 507480 0 0 $X=295740 $Y=507100
X857 962 2 930 929 947 1 984 FA1S $T=301940 578040 0 0 $X=301940 $Y=577660
X858 971 2 957 956 980 1 944 FA1S $T=314340 517560 0 180 $X=302560 $Y=512140
X859 952 2 962 914 969 1 995 FA1S $T=303800 578040 1 0 $X=303800 $Y=572620
X860 980 2 990 81 75 1 951 FA1S $T=316820 507480 0 180 $X=305040 $Y=502060
X861 85 2 974 1007 909 1 86 FA1S $T=315580 507480 0 0 $X=315580 $Y=507100
X862 998 2 912 931 1023 1 1022 FA1S $T=315580 517560 1 0 $X=315580 $Y=512140
X863 1002 2 1015 984 1035 1 1034 FA1S $T=316820 578040 0 0 $X=316820 $Y=577660
X864 1040 2 1047 1051 1033 1 1055 FA1S $T=328600 557880 1 0 $X=328600 $Y=552460
X865 1049 2 1038 1020 1040 1 1061 FA1S $T=332940 557880 0 0 $X=332940 $Y=557500
X866 1027 2 1041 1013 1049 1 1056 FA1S $T=333560 567960 0 0 $X=333560 $Y=567580
X867 1060 2 1053 106 1062 1 1023 FA1S $T=347820 517560 0 180 $X=336040 $Y=512140
X868 1062 2 1036 107 101 1 956 FA1S $T=348440 507480 1 180 $X=336660 $Y=507100
X869 1066 2 1076 1061 1074 1 1084 FA1S $T=341000 578040 1 0 $X=341000 $Y=572620
X870 1072 2 1052 1054 1068 1 1088 FA1S $T=342860 527640 0 0 $X=342860 $Y=527260
X871 1073 2 1063 1059 1072 1 1097 FA1S $T=344100 547800 1 0 $X=344100 $Y=542380
X872 1074 2 1065 1055 1073 1 1087 FA1S $T=344100 557880 1 0 $X=344100 $Y=552460
X873 112 2 998 109 1060 1 118 FA1S $T=351540 507480 0 0 $X=351540 $Y=507100
X874 117 2 1127 1122 119 1 111 FA1S $T=367040 638520 1 180 $X=355260 $Y=638140
X875 1136 2 1152 1145 1144 1 1122 FA1S $T=380060 638520 0 180 $X=368280 $Y=633100
X876 1154 2 1129 1177 1136 1 127 FA1S $T=385020 618360 1 180 $X=373240 $Y=617980
X877 1179 2 1191 1190 1183 1 135 FA1S $T=393080 638520 0 180 $X=381300 $Y=633100
X878 1205 2 1172 1215 1202 1 1217 FA1S $T=394320 608280 0 0 $X=394320 $Y=607900
X879 1213 2 1232 1217 1154 1 144 FA1S $T=408580 618360 1 180 $X=396800 $Y=617980
X880 157 2 1239 1237 1213 1 151 FA1S $T=412920 628440 0 180 $X=401140 $Y=623020
X881 1227 2 1179 1225 155 1 150 FA1S $T=413540 638520 0 180 $X=401760 $Y=633100
X882 1238 2 1219 1205 1246 1 1239 FA1S $T=409200 608280 0 0 $X=409200 $Y=607900
X883 1246 2 1242 1250 1235 1 1232 FA1S $T=423460 618360 0 180 $X=411680 $Y=612940
X884 175 2 1260 1249 1227 1 1237 FA1S $T=430280 628440 1 180 $X=418500 $Y=628060
X885 1256 2 1264 1286 1238 1 164 FA1S $T=430900 608280 0 180 $X=419120 $Y=602860
X886 1264 2 1277 1270 1251 1 1249 FA1S $T=435860 608280 1 180 $X=424080 $Y=607900
X887 1282 2 1301 1305 1259 1 177 FA1S $T=440200 638520 1 180 $X=428420 $Y=638140
X888 189 2 1282 1317 1256 1 180 FA1S $T=441440 628440 0 180 $X=429660 $Y=623020
X889 1301 2 1314 195 1306 1 1260 FA1S $T=444540 628440 1 180 $X=432760 $Y=628060
X890 1324 2 1312 1339 1302 1 1286 FA1S $T=452600 608280 0 180 $X=440820 $Y=602860
X891 1341 2 1321 1343 1324 1 1317 FA1S $T=456320 628440 0 180 $X=444540 $Y=623020
X892 205 2 1361 1381 1341 1 201 FA1S $T=461900 628440 1 180 $X=450120 $Y=628060
X893 1361 2 1366 1374 1357 1 1343 FA1S $T=463760 618360 1 180 $X=451980 $Y=617980
X894 207 2 1385 1387 1376 1 204 FA1S $T=466860 638520 1 180 $X=455080 $Y=638140
X895 1385 2 1391 1410 1403 1 1381 FA1S $T=476160 628440 0 180 $X=464380 $Y=623020
X896 1432 2 1421 1423 1426 1 1450 FA1S $T=478020 618360 1 0 $X=478020 $Y=612940
X897 1469 2 1459 1457 266 1 282 FA1S $T=494140 638520 1 0 $X=494140 $Y=633100
X898 1481 2 1490 1493 1487 1 1459 FA1S $T=508400 628440 0 180 $X=496620 $Y=623020
X899 281 2 290 1488 1469 1 260 FA1S $T=509640 638520 1 180 $X=497860 $Y=638140
X900 1491 2 1470 1502 1481 1 1488 FA1S $T=504060 608280 0 0 $X=504060 $Y=607900
X901 1518 2 1480 1505 1568 1 1538 FA1S $T=513980 618360 0 0 $X=513980 $Y=617980
X902 312 2 1513 1519 1491 1 323 FA1S $T=515220 638520 0 0 $X=515220 $Y=638140
X903 1555 2 1541 1577 1562 1 1525 FA1S $T=535060 628440 1 180 $X=523280 $Y=628060
X904 1642 2 1640 1629 1663 1 1664 FA1S $T=559240 618360 0 0 $X=559240 $Y=617980
X905 1648 2 1626 1611 1671 1 1672 FA1S $T=561720 567960 1 0 $X=561720 $Y=562540
X906 1654 2 1613 1704 1661 1 1636 FA1S $T=573500 578040 1 180 $X=561720 $Y=577660
X907 386 2 1650 1612 1680 1 1679 FA1S $T=562960 638520 0 0 $X=562960 $Y=638140
X908 1657 2 1667 1636 1648 1 1688 FA1S $T=564820 567960 0 0 $X=564820 $Y=567580
X909 1660 2 1643 1676 1666 1 1682 FA1S $T=565440 608280 1 0 $X=565440 $Y=602860
X910 1678 2 1625 1668 1695 1 1705 FA1S $T=570400 557880 1 0 $X=570400 $Y=552460
X911 1693 2 1713 1707 1699 1 1667 FA1S $T=584040 588120 1 180 $X=572260 $Y=587740
X912 1671 2 1702 1717 1694 1 1668 FA1S $T=585280 567960 0 180 $X=573500 $Y=562540
X913 1690 2 1639 1677 1714 1 1724 FA1S $T=573500 618360 1 0 $X=573500 $Y=612940
X914 1695 2 1687 1715 1692 1 1756 FA1S $T=575360 547800 1 0 $X=575360 $Y=542380
X915 1697 2 1665 1654 1693 1 1723 FA1S $T=575360 588120 1 0 $X=575360 $Y=582700
X916 400 2 404 1679 1708 1 1737 FA1S $T=576600 628440 0 0 $X=576600 $Y=628060
X917 1680 2 405 409 402 1 1685 FA1S $T=588380 638520 1 180 $X=576600 $Y=638140
X918 1708 2 1685 1684 1690 1 1730 FA1S $T=577840 628440 1 0 $X=577840 $Y=623020
X919 1731 2 1719 1725 1738 1 1757 FA1S $T=585280 567960 1 0 $X=585280 $Y=562540
X920 1739 2 1729 1728 1734 1 1759 FA1S $T=587140 588120 1 0 $X=587140 $Y=582700
X921 1740 2 1642 1758 1724 1 1765 FA1S $T=587140 618360 1 0 $X=587140 $Y=612940
X922 1749 2 1759 1757 1741 1 1727 FA1S $T=599540 557880 1 180 $X=587760 $Y=557500
X923 1741 2 1751 1701 1746 1 1762 FA1S $T=588380 537720 1 0 $X=588380 $Y=532300
X924 1747 2 1731 1670 1739 1 1763 FA1S $T=589620 578040 1 0 $X=589620 $Y=572620
X925 1750 2 410 1730 1772 1 1754 FA1S $T=590860 628440 1 0 $X=590860 $Y=623020
X926 1752 2 1672 1727 1678 1 1774 FA1S $T=591480 557880 1 0 $X=591480 $Y=552460
X927 1764 2 1753 1775 1766 1 1748 FA1S $T=605740 608280 0 180 $X=593960 $Y=602860
X928 1760 2 1776 1748 1697 1 1779 FA1S $T=595200 578040 0 0 $X=595200 $Y=577660
X929 416 2 1750 1737 1735 1 1784 FA1S $T=596440 628440 0 0 $X=596440 $Y=628060
X930 1769 2 1705 1781 1762 1 1800 FA1S $T=598920 527640 0 0 $X=598920 $Y=527260
X931 1772 2 424 1755 1787 1 1758 FA1S $T=611940 638520 1 180 $X=600160 $Y=638140
X932 1777 2 1763 1688 1749 1 1806 FA1S $T=600780 557880 0 0 $X=600780 $Y=557500
X933 1778 2 1723 1761 1657 1 1803 FA1S $T=601400 567960 1 0 $X=601400 $Y=562540
X934 1786 2 1767 1796 1747 1 1761 FA1S $T=613180 578040 0 180 $X=601400 $Y=572620
X935 1781 2 1710 1770 1804 1 1807 FA1S $T=602640 537720 1 0 $X=602640 $Y=532300
X936 1790 2 1792 1802 1799 1 1767 FA1S $T=614420 598200 1 180 $X=602640 $Y=597820
X937 1776 2 1771 1768 1782 1 1796 FA1S $T=603880 598200 1 0 $X=603880 $Y=592780
X938 1789 2 1820 1664 1833 1 1830 FA1S $T=608220 618360 0 0 $X=608220 $Y=617980
X939 1810 2 1826 1779 1786 1 1821 FA1S $T=610080 578040 0 0 $X=610080 $Y=577660
X940 1817 2 1790 1793 1814 1 1826 FA1S $T=611940 588120 0 0 $X=611940 $Y=587740
X941 1787 2 1816 430 431 1 1833 FA1S $T=611940 638520 0 0 $X=611940 $Y=638140
X942 1823 2 1801 1785 1809 1 1908 FA1S $T=615040 537720 0 0 $X=615040 $Y=537340
X943 1820 2 1798 1811 1824 1 1843 FA1S $T=615040 628440 0 0 $X=615040 $Y=628060
X944 1838 2 1847 1844 1764 1 1818 FA1S $T=628680 598200 0 180 $X=616900 $Y=592780
X945 1829 2 1807 1823 1756 1 1853 FA1S $T=618140 547800 1 0 $X=618140 $Y=542380
X946 1841 2 1634 1836 1859 1 1863 FA1S $T=620620 638520 1 0 $X=620620 $Y=633100
X947 1851 2 1843 1871 1860 1 1834 FA1S $T=633640 618360 1 180 $X=621860 $Y=617980
X948 1850 2 1817 1818 1760 1 1855 FA1S $T=624340 588120 1 0 $X=624340 $Y=582700
X949 1854 2 1842 1839 1845 1 1844 FA1S $T=624960 608280 1 0 $X=624960 $Y=602860
X950 1857 2 1835 1848 1858 1 1886 FA1S $T=627440 547800 0 0 $X=627440 $Y=547420
X951 1875 2 1854 1861 1838 1 1887 FA1S $T=630540 598200 1 0 $X=630540 $Y=592780
X952 1884 2 1867 1837 1876 1 1861 FA1S $T=633640 608280 0 0 $X=633640 $Y=607900
X953 1860 2 1877 1891 1947 1 1922 FA1S $T=638600 618360 0 0 $X=638600 $Y=617980
X954 1913 2 1884 1900 1926 1 1933 FA1S $T=642940 608280 1 0 $X=642940 $Y=602860
X955 1915 2 463 1894 461 1 1925 FA1S $T=644180 517560 1 0 $X=644180 $Y=512140
X956 1936 2 1919 465 467 1 1956 FA1S $T=650380 507480 0 0 $X=650380 $Y=507100
X957 1950 2 1958 1934 1865 1 1991 FA1S $T=654100 567960 0 0 $X=654100 $Y=567580
X958 1947 2 1939 1920 1944 1 1958 FA1S $T=654100 618360 1 0 $X=654100 $Y=612940
X959 1914 2 1783 1927 1955 1 1972 FA1S $T=654720 557880 1 0 $X=654720 $Y=552460
X960 1952 2 1954 1928 1966 1 1971 FA1S $T=656580 517560 0 0 $X=656580 $Y=517180
X961 1946 2 1931 1895 1952 1 1967 FA1S $T=656580 527640 1 0 $X=656580 $Y=522220
X962 1961 2 472 474 476 1 1982 FA1S $T=659680 507480 1 0 $X=659680 $Y=502060
X963 1962 2 1922 478 1828 1 1983 FA1S $T=659680 588120 1 0 $X=659680 $Y=582700
X964 1978 2 1834 480 1856 1 1994 FA1S $T=665260 588120 0 0 $X=665260 $Y=587740
X965 1980 2 1874 481 1901 1 1999 FA1S $T=665880 598200 1 0 $X=665880 $Y=592780
X966 1966 2 1973 1987 1977 1 2004 FA1S $T=671460 517560 0 0 $X=671460 $Y=517180
X967 1997 2 1993 1989 1953 1 2014 FA1S $T=675180 547800 0 0 $X=675180 $Y=547420
X968 1998 2 473 486 1784 1 2011 FA1S $T=675180 628440 0 0 $X=675180 $Y=628060
X969 2013 2 497 493 495 1 2028 FA1S $T=682620 638520 1 0 $X=682620 $Y=633100
X970 2021 2 2015 2005 1997 1 2046 FA1S $T=688200 557880 0 0 $X=688200 $Y=557500
X971 2027 2 2018 2035 2021 1 2075 FA1S $T=690680 567960 0 0 $X=690680 $Y=567580
X972 2721 2 702 2313 703 1 707 FA1S $T=933100 507480 1 0 $X=933100 $Y=502060
X973 2800 2 716 2396 2787 1 2810 FA1S $T=951080 517560 0 0 $X=951080 $Y=517180
X974 2814 2 2822 2417 2839 1 2798 FA1S $T=959140 537720 1 0 $X=959140 $Y=532300
X975 2839 2 2843 2390 2800 1 2844 FA1S $T=965960 517560 0 0 $X=965960 $Y=517180
X976 764 2 7 786 1 NR2 $T=222580 507480 0 0 $X=222580 $Y=507100
X977 20 2 21 16 1 NR2 $T=253580 507480 0 180 $X=251720 $Y=502060
X978 870 2 879 874 1 NR2 $T=272180 578040 1 0 $X=272180 $Y=572620
X979 883 2 881 43 1 NR2 $T=278380 537720 1 180 $X=276520 $Y=537340
X980 886 2 894 53 1 NR2 $T=281480 517560 1 0 $X=281480 $Y=512140
X981 889 2 901 906 1 NR2 $T=281480 567960 1 0 $X=281480 $Y=562540
X982 889 2 908 883 1 NR2 $T=287060 557880 1 0 $X=287060 $Y=552460
X983 915 2 57 53 1 NR2 $T=292020 517560 0 180 $X=290160 $Y=512140
X984 915 2 924 54 1 NR2 $T=293880 527640 1 0 $X=293880 $Y=522220
X985 54 2 931 53 1 NR2 $T=296360 517560 0 180 $X=294500 $Y=512140
X986 875 2 930 906 1 NR2 $T=298220 557880 1 180 $X=296360 $Y=557500
X987 59 2 940 54 1 NR2 $T=301320 527640 0 180 $X=299460 $Y=522220
X988 889 2 947 941 1 NR2 $T=300080 578040 1 0 $X=300080 $Y=572620
X989 910 2 963 965 1 NR2 $T=305660 557880 0 0 $X=305660 $Y=557500
X990 968 2 945 60 1 NR2 $T=308760 608280 1 180 $X=306900 $Y=607900
X991 963 2 977 960 1 NR2 $T=308140 557880 1 0 $X=308140 $Y=552460
X992 875 2 978 941 1 NR2 $T=311240 567960 1 0 $X=311240 $Y=562540
X993 880 2 993 965 1 NR2 $T=313720 547800 0 0 $X=313720 $Y=547420
X994 941 2 1010 965 1 NR2 $T=314340 547800 1 0 $X=314340 $Y=542380
X995 964 2 1019 958 1 NR2 $T=323020 537720 0 0 $X=323020 $Y=537340
X996 886 2 93 92 1 NR2 $T=328600 507480 0 0 $X=328600 $Y=507100
X997 975 2 1033 1025 1 NR2 $T=328600 537720 0 0 $X=328600 $Y=537340
X998 59 2 1036 92 1 NR2 $T=329840 517560 1 0 $X=329840 $Y=512140
X999 958 2 97 92 1 NR2 $T=336040 517560 0 180 $X=334180 $Y=512140
X1000 889 2 1041 1025 1 NR2 $T=336040 578040 1 180 $X=334180 $Y=577660
X1001 1025 2 1045 79 1 NR2 $T=336660 527640 1 180 $X=334800 $Y=527260
X1002 875 2 1038 1025 1 NR2 $T=336660 567960 0 180 $X=334800 $Y=562540
X1003 95 2 1039 958 1 NR2 $T=335420 517560 0 0 $X=335420 $Y=517180
X1004 1050 2 1059 1051 1 NR2 $T=337280 547800 1 0 $X=337280 $Y=542380
X1005 958 2 1054 1003 1 NR2 $T=339140 527640 1 0 $X=339140 $Y=522220
X1006 985 2 1051 1042 1 NR2 $T=341000 537720 1 180 $X=339140 $Y=537340
X1007 875 2 1053 92 1 NR2 $T=342240 517560 1 180 $X=340380 $Y=517180
X1008 985 2 104 92 1 NR2 $T=342860 507480 0 180 $X=341000 $Y=502060
X1009 1064 2 1068 985 1 NR2 $T=345340 537720 0 180 $X=343480 $Y=532300
X1010 975 2 1063 1064 1 NR2 $T=343480 547800 0 0 $X=343480 $Y=547420
X1011 875 2 1065 1064 1 NR2 $T=346580 557880 0 0 $X=346580 $Y=557500
X1012 1071 2 1083 95 1 NR2 $T=347200 527640 1 0 $X=347200 $Y=522220
X1013 889 2 1076 1064 1 NR2 $T=348440 567960 1 0 $X=348440 $Y=562540
X1014 1096 2 1099 1078 1 NR2 $T=352160 588120 1 180 $X=350300 $Y=587740
X1015 1094 2 1109 1089 1 NR2 $T=357740 578040 0 0 $X=357740 $Y=577660
X1016 1116 2 1102 1043 1 NR2 $T=360220 527640 0 180 $X=358360 $Y=522220
X1017 1102 2 1095 1113 1 NR2 $T=358360 537720 1 0 $X=358360 $Y=532300
X1018 1111 2 1110 1095 1 NR2 $T=360220 537720 1 180 $X=358360 $Y=537340
X1019 1115 2 1114 1088 1 NR2 $T=360220 547800 0 180 $X=358360 $Y=542380
X1020 1101 2 1081 1105 1 NR2 $T=358980 557880 1 0 $X=358980 $Y=552460
X1021 1112 2 1111 1103 1 NR2 $T=363320 517560 1 180 $X=361460 $Y=517180
X1022 1085 2 1098 1087 1 NR2 $T=364560 567960 0 180 $X=362700 $Y=562540
X1023 1118 2 1129 1132 1 NR2 $T=365800 618360 0 0 $X=365800 $Y=617980
X1024 123 2 125 129 1 NR2 $T=370760 638520 0 0 $X=370760 $Y=638140
X1025 1148 2 1113 1159 1 NR2 $T=379440 527640 1 0 $X=379440 $Y=522220
X1026 131 2 1145 140 1 NR2 $T=379440 638520 0 0 $X=379440 $Y=638140
X1027 1163 2 1167 1170 1 NR2 $T=383780 578040 1 0 $X=383780 $Y=572620
X1028 137 2 1144 1185 1 NR2 $T=385640 628440 0 0 $X=385640 $Y=628060
X1029 1155 2 1186 1169 1 NR2 $T=389980 517560 1 180 $X=388120 $Y=517180
X1030 123 2 1190 1185 1 NR2 $T=391220 628440 0 0 $X=391220 $Y=628060
X1031 143 2 1191 140 1 NR2 $T=393080 638520 1 180 $X=391220 $Y=638140
X1032 1182 2 1172 1175 1 NR2 $T=393080 608280 1 0 $X=393080 $Y=602860
X1033 1168 2 1195 1037 1 NR2 $T=396180 588120 0 180 $X=394320 $Y=582700
X1034 129 2 1183 147 1 NR2 $T=394320 628440 0 0 $X=394320 $Y=628060
X1035 129 2 1202 140 1 NR2 $T=398660 628440 0 180 $X=396800 $Y=623020
X1036 146 2 1152 1218 1 NR2 $T=397420 638520 0 0 $X=397420 $Y=638140
X1037 152 2 1166 1197 1 NR2 $T=401140 527640 0 180 $X=399280 $Y=522220
X1038 143 2 1215 1218 1 NR2 $T=399900 628440 0 0 $X=399900 $Y=628060
X1039 1212 2 1206 954 1 NR2 $T=406100 547800 0 0 $X=406100 $Y=547420
X1040 1221 2 1204 1226 1 NR2 $T=406100 567960 0 0 $X=406100 $Y=567580
X1041 131 2 158 1218 1 NR2 $T=407960 638520 1 180 $X=406100 $Y=638140
X1042 1236 2 1219 1222 1 NR2 $T=409820 598200 0 180 $X=407960 $Y=592780
X1043 1185 2 1242 147 1 NR2 $T=414780 628440 1 0 $X=414780 $Y=623020
X1044 123 2 1235 1245 1 NR2 $T=414780 628440 0 0 $X=414780 $Y=628060
X1045 146 2 159 165 1 NR2 $T=414780 638520 0 0 $X=414780 $Y=638140
X1046 1247 2 1250 165 1 NR2 $T=418500 628440 1 0 $X=418500 $Y=623020
X1047 137 2 170 1245 1 NR2 $T=420360 638520 0 0 $X=420360 $Y=638140
X1048 1245 2 1259 140 1 NR2 $T=423460 638520 0 0 $X=423460 $Y=638140
X1049 1245 2 1251 147 1 NR2 $T=425940 628440 0 180 $X=424080 $Y=623020
X1050 129 2 1270 1218 1 NR2 $T=428420 618360 0 0 $X=428420 $Y=617980
X1051 1185 2 1277 140 1 NR2 $T=436480 618360 0 180 $X=434620 $Y=612940
X1052 1292 2 1288 1280 1 NR2 $T=438340 578040 1 180 $X=436480 $Y=577660
X1053 1309 2 1319 1263 1 NR2 $T=442060 588120 0 180 $X=440200 $Y=582700
X1054 192 2 1312 165 1 NR2 $T=440820 608280 0 0 $X=440820 $Y=607900
X1055 194 2 1302 1313 1 NR2 $T=441440 618360 0 0 $X=441440 $Y=617980
X1056 137 2 1306 1313 1 NR2 $T=442060 638520 0 0 $X=442060 $Y=638140
X1057 1185 2 1305 1218 1 NR2 $T=446400 628440 0 0 $X=446400 $Y=628060
X1058 1337 2 1332 1320 1 NR2 $T=449500 567960 1 180 $X=447640 $Y=567580
X1059 1245 2 1321 1218 1 NR2 $T=449500 618360 1 180 $X=447640 $Y=617980
X1060 194 2 1314 1329 1 NR2 $T=447640 638520 1 0 $X=447640 $Y=633100
X1061 1329 2 1339 202 1 NR2 $T=450120 608280 0 0 $X=450120 $Y=607900
X1062 1313 2 1357 202 1 NR2 $T=457560 618360 0 180 $X=455700 $Y=612940
X1063 1363 2 1354 1352 1 NR2 $T=458180 578040 0 180 $X=456320 $Y=572620
X1064 1329 2 1366 206 1 NR2 $T=459420 628440 1 0 $X=459420 $Y=623020
X1065 165 2 1374 200 1 NR2 $T=462520 618360 1 0 $X=462520 $Y=612940
X1066 1313 2 1376 203 1 NR2 $T=464380 638520 0 180 $X=462520 $Y=633100
X1067 1384 2 1389 1390 1 NR2 $T=465620 567960 0 0 $X=465620 $Y=567580
X1068 212 2 1395 1371 1 NR2 $T=469960 507480 1 180 $X=468100 $Y=507100
X1069 1370 2 1419 1399 1 NR2 $T=468100 557880 0 0 $X=468100 $Y=557500
X1070 1329 2 1391 203 1 NR2 $T=469960 638520 0 180 $X=468100 $Y=633100
X1071 215 2 1387 1329 1 NR2 $T=470580 638520 1 180 $X=468720 $Y=638140
X1072 165 2 1410 1245 1 NR2 $T=473680 618360 0 0 $X=473680 $Y=617980
X1073 1313 2 1403 206 1 NR2 $T=474300 638520 1 0 $X=474300 $Y=633100
X1074 232 2 1423 146 1 NR2 $T=479880 628440 1 180 $X=478020 $Y=628060
X1075 222 2 244 233 1 NR2 $T=479880 638520 1 0 $X=479880 $Y=633100
X1076 1448 2 1442 1418 1 NR2 $T=487940 557880 1 180 $X=486080 $Y=557500
X1077 236 2 1444 1430 1 NR2 $T=491040 517560 0 180 $X=489180 $Y=512140
X1078 1452 2 1435 1445 1 NR2 $T=491040 547800 0 180 $X=489180 $Y=542380
X1079 251 2 252 200 1 NR2 $T=494140 638520 0 180 $X=492280 $Y=633100
X1080 1446 2 1461 1468 1 NR2 $T=495380 557880 0 0 $X=495380 $Y=557500
X1081 1461 2 1467 1471 1 NR2 $T=495380 567960 1 0 $X=495380 $Y=562540
X1082 1485 2 1388 1338 1 NR2 $T=506540 578040 1 0 $X=506540 $Y=572620
X1083 251 2 1490 238 1 NR2 $T=506540 618360 0 0 $X=506540 $Y=617980
X1084 284 2 1493 289 1 NR2 $T=507160 638520 1 0 $X=507160 $Y=633100
X1085 232 2 1505 1247 1 NR2 $T=511500 618360 1 180 $X=509640 $Y=617980
X1086 301 2 1487 1247 1 NR2 $T=512120 638520 0 180 $X=510260 $Y=633100
X1087 1506 2 1520 1504 1 NR2 $T=517080 527640 1 180 $X=515220 $Y=527260
X1088 1506 2 1531 1515 1 NR2 $T=518320 537720 1 0 $X=518320 $Y=532300
X1089 329 2 337 192 1 NR2 $T=529480 638520 0 180 $X=527620 $Y=633100
X1090 1566 2 327 1554 1 NR2 $T=532580 618360 0 180 $X=530720 $Y=612940
X1091 1571 2 1545 332 1 NR2 $T=533820 517560 1 180 $X=531960 $Y=517180
X1092 232 2 1577 342 1 NR2 $T=534440 638520 1 0 $X=534440 $Y=633100
X1093 1576 2 325 1582 1 NR2 $T=536300 517560 0 0 $X=536300 $Y=517180
X1094 1580 2 1573 1338 1 NR2 $T=538160 567960 1 180 $X=536300 $Y=567580
X1095 358 2 1576 1581 1 NR2 $T=542500 517560 0 0 $X=542500 $Y=517180
X1096 1581 2 1546 1564 1 NR2 $T=543120 527640 1 0 $X=543120 $Y=522220
X1097 335 2 283 1581 1 NR2 $T=543120 557880 1 0 $X=543120 $Y=552460
X1098 1573 2 1594 1597 1 NR2 $T=546840 578040 1 0 $X=546840 $Y=572620
X1099 352 2 1597 1593 1 NR2 $T=550560 567960 1 180 $X=548700 $Y=567580
X1100 1598 2 1613 1614 1 NR2 $T=549320 588120 1 0 $X=549320 $Y=582700
X1101 1608 2 374 1615 1 NR2 $T=554280 628440 0 0 $X=554280 $Y=628060
X1102 1617 2 1629 1619 1 NR2 $T=557380 618360 1 0 $X=557380 $Y=612940
X1103 1622 2 1626 1627 1 NR2 $T=559860 567960 1 0 $X=559860 $Y=562540
X1104 1630 2 1639 1637 1 NR2 $T=560480 608280 1 0 $X=560480 $Y=602860
X1105 1655 2 1665 1659 1 NR2 $T=568540 598200 1 0 $X=568540 $Y=592780
X1106 392 2 1663 388 1 NR2 $T=573500 628440 0 180 $X=571640 $Y=623020
X1107 366 2 1676 1674 1 NR2 $T=572260 598200 1 0 $X=572260 $Y=592780
X1108 1674 2 1687 398 1 NR2 $T=574120 547800 0 0 $X=574120 $Y=547420
X1109 291 2 1694 1691 1 NR2 $T=575360 578040 1 0 $X=575360 $Y=572620
X1110 401 2 1677 388 1 NR2 $T=579700 618360 1 180 $X=577840 $Y=617980
X1111 1674 2 1702 1696 1 NR2 $T=578460 567960 0 0 $X=578460 $Y=567580
X1112 291 2 1692 1712 1 NR2 $T=579700 547800 0 0 $X=579700 $Y=547420
X1113 1706 2 1704 1696 1 NR2 $T=581560 578040 0 180 $X=579700 $Y=572620
X1114 1691 2 1713 1569 1 NR2 $T=579700 598200 1 0 $X=579700 $Y=592780
X1115 1706 2 1719 398 1 NR2 $T=583420 567960 0 0 $X=583420 $Y=567580
X1116 1712 2 1661 1716 1 NR2 $T=583420 578040 1 0 $X=583420 $Y=572620
X1117 1720 2 1707 1709 1 NR2 $T=585280 598200 0 180 $X=583420 $Y=592780
X1118 1720 2 1717 398 1 NR2 $T=587760 557880 0 180 $X=585900 $Y=552460
X1119 1722 2 1725 1691 1 NR2 $T=586520 578040 1 0 $X=586520 $Y=572620
X1120 1722 2 1699 1732 1 NR2 $T=586520 598200 1 0 $X=586520 $Y=592780
X1121 1720 2 1728 1696 1 NR2 $T=587140 578040 0 0 $X=587140 $Y=577660
X1122 406 2 1714 397 1 NR2 $T=589000 618360 1 180 $X=587140 $Y=617980
X1123 1721 2 1701 1647 1 NR2 $T=589000 527640 0 0 $X=589000 $Y=527260
X1124 291 2 1734 1732 1 NR2 $T=592100 598200 0 180 $X=590240 $Y=592780
X1125 1674 2 1729 1736 1 NR2 $T=590240 598200 0 0 $X=590240 $Y=597820
X1126 1722 2 1715 1706 1 NR2 $T=590860 537720 0 0 $X=590860 $Y=537340
X1127 1722 2 1746 1712 1 NR2 $T=592100 547800 0 0 $X=592100 $Y=547420
X1128 1742 2 411 1602 1 NR2 $T=592720 638520 0 0 $X=592720 $Y=638140
X1129 1712 2 1753 1743 1 NR2 $T=597680 598200 1 180 $X=595820 $Y=597820
X1130 1706 2 1751 1569 1 NR2 $T=597060 537720 0 0 $X=597060 $Y=537340
X1131 1712 2 1738 1569 1 NR2 $T=597680 567960 0 0 $X=597680 $Y=567580
X1132 1720 2 1801 1722 1 NR2 $T=600160 547800 0 180 $X=598300 $Y=542380
X1133 1712 2 1768 1696 1 NR2 $T=598300 598200 1 0 $X=598300 $Y=592780
X1134 417 2 1788 420 1 NR2 $T=602020 507480 1 0 $X=602020 $Y=502060
X1135 414 2 1766 418 1 NR2 $T=602020 608280 0 0 $X=602020 $Y=607900
X1136 1691 2 1771 1716 1 NR2 $T=603260 588120 1 0 $X=603260 $Y=582700
X1137 1720 2 1770 1569 1 NR2 $T=603880 537720 0 0 $X=603880 $Y=537340
X1138 1674 2 1785 1569 1 NR2 $T=606360 547800 1 180 $X=604500 $Y=547420
X1139 1732 2 1782 413 1 NR2 $T=605740 608280 1 0 $X=605740 $Y=602860
X1140 1691 2 1793 1696 1 NR2 $T=608220 588120 1 0 $X=608220 $Y=582700
X1141 1797 2 1775 413 1 NR2 $T=610080 608280 0 180 $X=608220 $Y=602860
X1142 291 2 1799 418 1 NR2 $T=608220 608280 0 0 $X=608220 $Y=607900
X1143 425 2 1798 388 1 NR2 $T=610080 628440 1 180 $X=608220 $Y=628060
X1144 291 2 1809 1706 1 NR2 $T=610700 537720 0 0 $X=610700 $Y=537340
X1145 1825 2 1804 1805 1 NR2 $T=615040 547800 1 180 $X=613180 $Y=547420
X1146 414 2 1792 1797 1 NR2 $T=613180 608280 0 0 $X=613180 $Y=607900
X1147 392 2 1811 397 1 NR2 $T=615040 628440 1 180 $X=613180 $Y=628060
X1148 401 2 1816 397 1 NR2 $T=615040 638520 0 180 $X=613180 $Y=633100
X1149 1732 2 1814 1716 1 NR2 $T=615660 588120 0 180 $X=613800 $Y=582700
X1150 1681 2 1802 1815 1 NR2 $T=613800 608280 1 0 $X=613800 $Y=602860
X1151 401 2 1824 396 1 NR2 $T=616900 638520 1 0 $X=616900 $Y=633100
X1152 1827 2 1839 1691 1 NR2 $T=621240 598200 1 180 $X=619380 $Y=597820
X1153 436 2 1837 1732 1 NR2 $T=621240 608280 1 0 $X=621240 $Y=602860
X1154 1797 2 1842 398 1 NR2 $T=624960 608280 0 0 $X=624960 $Y=607900
X1155 1732 2 1847 1696 1 NR2 $T=625580 588120 0 0 $X=625580 $Y=587740
X1156 418 2 1845 413 1 NR2 $T=626820 608280 0 0 $X=626820 $Y=607900
X1157 1797 2 1867 445 1 NR2 $T=630540 608280 0 0 $X=630540 $Y=607900
X1158 1879 2 1858 1873 1 NR2 $T=636120 567960 1 180 $X=634260 $Y=567580
X1159 418 2 1876 398 1 NR2 $T=636740 618360 0 180 $X=634880 $Y=612940
X1160 425 2 1885 1681 1 NR2 $T=637980 628440 0 180 $X=636120 $Y=623020
X1161 1888 2 1873 1883 1 NR2 $T=639220 567960 1 180 $X=637360 $Y=567580
X1162 452 2 1870 1681 1 NR2 $T=637360 578040 0 0 $X=637360 $Y=577660
X1163 436 2 1900 1797 1 NR2 $T=641700 618360 0 180 $X=639840 $Y=612940
X1164 421 2 1896 1935 1 NR2 $T=644180 638520 0 0 $X=644180 $Y=638140
X1165 1904 2 1879 1909 1 NR2 $T=646040 578040 1 0 $X=646040 $Y=572620
X1166 418 2 1926 445 1 NR2 $T=649140 608280 0 0 $X=649140 $Y=607900
X1167 466 2 1930 464 1 NR2 $T=651000 638520 0 180 $X=649140 $Y=633100
X1168 1681 2 1917 464 1 NR2 $T=650380 588120 1 0 $X=650380 $Y=582700
X1169 468 2 1927 464 1 NR2 $T=652240 628440 0 0 $X=652240 $Y=628060
X1170 1938 2 1943 1945 1 NR2 $T=655340 578040 1 0 $X=655340 $Y=572620
X1171 1929 2 1939 1940 1 NR2 $T=655340 588120 0 0 $X=655340 $Y=587740
X1172 469 2 1944 1935 1 NR2 $T=655340 628440 1 0 $X=655340 $Y=623020
X1173 468 2 473 475 1 NR2 $T=659060 628440 0 0 $X=659060 $Y=628060
X1174 464 2 1964 1935 1 NR2 $T=660920 588120 0 0 $X=660920 $Y=587740
X1175 425 2 1955 1935 1 NR2 $T=660920 598200 1 0 $X=660920 $Y=592780
X1176 1948 2 1968 1970 1 NR2 $T=665880 628440 0 0 $X=665880 $Y=628060
X1177 1975 2 1976 471 1 NR2 $T=668980 608280 1 180 $X=667120 $Y=607900
X1178 1986 2 1992 1995 1 NR2 $T=671460 557880 1 0 $X=671460 $Y=552460
X1179 1913 2 1975 1963 1 NR2 $T=672700 608280 1 0 $X=672700 $Y=602860
X1180 2005 2 1993 1992 1 NR2 $T=681380 557880 0 180 $X=679520 $Y=552460
X1181 519 2 2119 2084 1 NR2 $T=735320 608280 0 180 $X=733460 $Y=602860
X1182 530 2 2169 2114 1 NR2 $T=750200 618360 0 0 $X=750200 $Y=617980
X1183 541 2 547 2105 1 NR2 $T=766940 628440 1 180 $X=765080 $Y=628060
X1184 536 2 2185 2189 1 NR2 $T=768180 598200 1 180 $X=766320 $Y=597820
X1185 553 2 2209 2195 1 NR2 $T=773760 527640 0 0 $X=773760 $Y=527260
X1186 2173 2 2206 560 1 NR2 $T=776860 598200 0 0 $X=776860 $Y=597820
X1187 565 2 2248 2199 1 NR2 $T=788020 557880 0 180 $X=786160 $Y=552460
X1188 573 2 2249 2170 1 NR2 $T=788020 578040 0 180 $X=786160 $Y=572620
X1189 568 2 2237 2194 1 NR2 $T=790500 507480 0 180 $X=788640 $Y=502060
X1190 585 2 584 2259 1 NR2 $T=796080 628440 1 180 $X=794220 $Y=628060
X1191 604 2 2288 2203 1 NR2 $T=807240 537720 1 180 $X=805380 $Y=537340
X1192 2190 2 2271 599 1 NR2 $T=808480 567960 0 0 $X=808480 $Y=567580
X1193 2367 2 2475 2458 1 NR2 $T=866140 578040 0 0 $X=866140 $Y=577660
X1194 2480 2 2497 2416 1 NR2 $T=873580 578040 1 180 $X=871720 $Y=577660
X1195 657 2 2511 2472 1 NR2 $T=874820 628440 0 0 $X=874820 $Y=628060
X1196 2480 2 2522 2433 1 NR2 $T=879780 588120 1 180 $X=877920 $Y=587740
X1197 2514 2 2518 2490 1 NR2 $T=879780 608280 0 180 $X=877920 $Y=602860
X1198 2498 2 2514 668 1 NR2 $T=883500 608280 0 0 $X=883500 $Y=607900
X1199 2585 2 2575 2546 1 NR2 $T=894660 588120 0 180 $X=892800 $Y=582700
X1200 2591 2 2594 2499 1 NR2 $T=897140 567960 0 180 $X=895280 $Y=562540
X1201 2591 2 2587 2483 1 NR2 $T=897140 567960 1 180 $X=895280 $Y=567580
X1202 2587 2 2596 2475 1 NR2 $T=895900 578040 1 0 $X=895900 $Y=572620
X1203 2608 2 2619 688 1 NR2 $T=903960 618360 1 0 $X=903960 $Y=612940
X1204 2584 2 2614 2453 1 NR2 $T=907680 567960 0 180 $X=905820 $Y=562540
X1205 2584 2 2633 2516 1 NR2 $T=908920 578040 0 180 $X=907060 $Y=572620
X1206 2611 2 2634 2633 1 NR2 $T=907060 578040 0 0 $X=907060 $Y=577660
X1207 2478 2 2637 2640 1 NR2 $T=907680 557880 0 0 $X=907680 $Y=557500
X1208 2597 2 2629 2635 1 NR2 $T=907680 608280 0 0 $X=907680 $Y=607900
X1209 2584 2 2630 2449 1 NR2 $T=908920 608280 1 0 $X=908920 $Y=602860
X1210 2707 2 2688 2568 1 NR2 $T=926900 588120 0 180 $X=925040 $Y=582700
X1211 2697 2 2725 2575 1 NR2 $T=925660 578040 0 0 $X=925660 $Y=577660
X1212 2686 2 2728 2698 1 NR2 $T=936200 608280 1 180 $X=934340 $Y=607900
X1213 695 2 2744 2740 1 NR2 $T=934340 638520 1 0 $X=934340 $Y=633100
X1214 2685 2 2749 2733 1 NR2 $T=936820 588120 1 0 $X=936820 $Y=582700
X1215 2754 2 2742 2744 1 NR2 $T=941780 618360 1 180 $X=939920 $Y=617980
X1216 2744 2 2765 706 1 NR2 $T=940540 628440 0 0 $X=940540 $Y=628060
X1217 2699 2 2724 2760 1 NR2 $T=941780 557880 0 0 $X=941780 $Y=557500
X1218 2746 2 2763 2749 1 NR2 $T=942400 588120 0 0 $X=942400 $Y=587740
X1219 2754 2 2771 2728 1 NR2 $T=947360 618360 1 180 $X=945500 $Y=617980
X1220 705 2 709 2710 1 NR2 $T=945500 638520 0 0 $X=945500 $Y=638140
X1221 2754 2 2784 2749 1 NR2 $T=947980 588120 1 180 $X=946120 $Y=587740
X1222 2754 2 2783 2770 1 NR2 $T=951080 588120 0 180 $X=949220 $Y=582700
X1223 36 861 2 1 871 OR2 $T=269700 608280 1 0 $X=269700 $Y=602860
X1224 1497 428 2 1 1794 OR2 $T=612560 507480 0 0 $X=612560 $Y=507100
X1225 2069 518 2 1 2121 OR2 $T=733460 628440 0 0 $X=733460 $Y=628060
X1226 2057 532 2 1 2153 OR2 $T=753920 608280 0 180 $X=751440 $Y=602860
X1227 2081 554 2 1 2211 OR2 $T=772520 618360 1 0 $X=772520 $Y=612940
X1228 2219 563 2 1 2229 OR2 $T=779340 517560 0 0 $X=779340 $Y=517180
X1229 2130 2227 2 1 2253 OR2 $T=779960 567960 1 0 $X=779960 $Y=562540
X1230 2145 570 2 1 2226 OR2 $T=785540 638520 1 0 $X=785540 $Y=633100
X1231 2079 576 2 1 2243 OR2 $T=788640 527640 0 0 $X=788640 $Y=527260
X1232 2197 590 2 1 2275 OR2 $T=799800 527640 1 0 $X=799800 $Y=522220
X1233 2198 586 2 1 2285 OR2 $T=802280 507480 0 0 $X=802280 $Y=507100
X1234 2442 657 2 1 2458 OR2 $T=865520 598200 1 0 $X=865520 $Y=592780
X1235 2329 2458 2 1 2519 OR2 $T=865520 608280 0 0 $X=865520 $Y=607900
X1236 2507 2502 2 1 2492 OR2 $T=877300 598200 0 180 $X=874820 $Y=592780
X1237 2468 2471 2 1 2547 OR2 $T=883500 598200 1 0 $X=883500 $Y=592780
X1238 2479 2573 2 1 2602 OR2 $T=892180 628440 1 0 $X=892180 $Y=623020
X1239 681 2608 2 1 2621 OR2 $T=900860 628440 1 0 $X=900860 $Y=623020
X1240 684 2608 2 1 2628 OR2 $T=901480 618360 0 0 $X=901480 $Y=617980
X1241 674 2608 2 1 2626 OR2 $T=903960 638520 0 0 $X=903960 $Y=638140
X1242 683 2549 2 1 2644 OR2 $T=907060 628440 0 0 $X=907060 $Y=628060
X1243 2481 2584 2 1 2664 OR2 $T=910160 578040 0 0 $X=910160 $Y=577660
X1244 2606 2643 2 1 2673 OR2 $T=913260 598200 0 0 $X=913260 $Y=597820
X1245 2565 2591 2 1 2675 OR2 $T=915740 578040 0 0 $X=915740 $Y=577660
X1246 2668 2670 2 1 2677 OR2 $T=916360 618360 1 0 $X=916360 $Y=612940
X1247 693 682 2 1 2653 OR2 $T=918840 628440 1 180 $X=916360 $Y=628060
X1248 694 682 2 1 2666 OR2 $T=918840 638520 1 180 $X=916360 $Y=638140
X1249 2665 2603 2 1 2690 OR2 $T=919460 557880 0 0 $X=919460 $Y=557500
X1250 2684 2603 2 1 2672 OR2 $T=921940 578040 0 180 $X=919460 $Y=572620
X1251 2673 2694 2 1 2683 OR2 $T=924420 608280 0 180 $X=921940 $Y=602860
X1252 2683 2668 2 1 2698 OR2 $T=921940 608280 0 0 $X=921940 $Y=607900
X1253 2657 2674 2 1 2712 OR2 $T=927520 628440 0 0 $X=927520 $Y=628060
X1254 2689 691 2 1 2740 OR2 $T=928140 638520 0 0 $X=928140 $Y=638140
X1255 2719 2657 2 1 2689 OR2 $T=931240 628440 1 0 $X=931240 $Y=623020
X1256 2729 2691 2 1 2757 OR2 $T=933720 567960 0 0 $X=933720 $Y=567580
X1257 2757 2655 2 1 2733 OR2 $T=942400 588120 0 180 $X=939920 $Y=582700
X1258 2766 2637 2 1 2760 OR2 $T=945500 547800 1 180 $X=943020 $Y=547420
X1259 2353 712 2 1 2756 OR2 $T=953560 517560 1 0 $X=953560 $Y=512140
X1260 45 41 876 2 1 ND2S $T=275280 507480 1 180 $X=273420 $Y=507100
X1261 45 888 47 2 1 ND2S $T=278380 507480 0 0 $X=278380 $Y=507100
X1262 869 895 880 2 1 ND2S $T=278380 557880 1 0 $X=278380 $Y=552460
X1263 890 912 51 2 1 ND2S $T=286440 517560 0 180 $X=284580 $Y=512140
X1264 51 902 903 2 1 ND2S $T=284580 527640 1 0 $X=284580 $Y=522220
X1265 874 923 66 2 1 ND2S $T=296360 567960 0 0 $X=296360 $Y=567580
X1266 78 957 911 2 1 ND2S $T=306900 527640 0 180 $X=305040 $Y=522220
X1267 877 969 964 2 1 ND2S $T=308140 537720 0 0 $X=308140 $Y=537340
X1268 78 990 903 2 1 ND2S $T=313100 527640 0 180 $X=311240 $Y=522220
X1269 78 80 880 2 1 ND2S $T=313100 527640 1 180 $X=311240 $Y=527260
X1270 78 84 991 2 1 ND2S $T=316820 517560 0 0 $X=316820 $Y=517180
X1271 88 1003 991 2 1 ND2S $T=319300 527640 1 180 $X=317440 $Y=527260
X1272 877 999 1001 2 1 ND2S $T=319920 537720 1 0 $X=319920 $Y=532300
X1273 1010 1006 903 2 1 ND2S $T=321780 547800 1 180 $X=319920 $Y=547420
X1274 1006 1000 967 2 1 ND2S $T=321780 557880 1 180 $X=319920 $Y=557500
X1275 1001 1042 880 2 1 ND2S $T=324880 537720 0 180 $X=323020 $Y=532300
X1276 964 1018 880 2 1 ND2S $T=324880 547800 0 180 $X=323020 $Y=542380
X1277 877 1013 88 2 1 ND2S $T=324260 527640 0 0 $X=324260 $Y=527260
X1278 85 114 100 2 1 ND2S $T=360220 517560 0 180 $X=358360 $Y=512140
X1279 120 1118 116 2 1 ND2S $T=364560 638520 0 180 $X=362700 $Y=633100
X1280 1157 1132 133 2 1 ND2S $T=381920 628440 1 180 $X=380060 $Y=628060
X1281 139 1175 133 2 1 ND2S $T=386880 608280 0 0 $X=386880 $Y=607900
X1282 120 1182 1157 2 1 ND2S $T=389980 618360 0 0 $X=389980 $Y=617980
X1283 120 1222 139 2 1 ND2S $T=414160 588120 0 0 $X=414160 $Y=587740
X1284 153 1236 1157 2 1 ND2S $T=414780 598200 0 0 $X=414780 $Y=597820
X1285 1273 183 1188 2 1 ND2S $T=434620 517560 0 180 $X=432760 $Y=512140
X1286 1273 185 1220 2 1 ND2S $T=434620 517560 1 180 $X=432760 $Y=517180
X1287 1274 1285 1267 2 1 ND2S $T=434620 567960 0 180 $X=432760 $Y=562540
X1288 191 1271 187 2 1 ND2S $T=433380 507480 1 0 $X=433380 $Y=502060
X1289 1275 184 1281 2 1 ND2S $T=434000 608280 1 0 $X=434000 $Y=602860
X1290 171 1290 1220 2 1 ND2S $T=437100 527640 0 180 $X=435240 $Y=522220
X1291 1273 197 1284 2 1 ND2S $T=442060 517560 0 180 $X=440200 $Y=512140
X1292 1273 196 1261 2 1 ND2S $T=443920 517560 0 180 $X=442060 $Y=512140
X1293 1276 1348 1345 2 1 ND2S $T=454460 537720 0 180 $X=452600 $Y=532300
X1294 1351 1360 162 2 1 ND2S $T=458180 517560 1 180 $X=456320 $Y=517180
X1295 1331 1367 1336 2 1 ND2S $T=458180 557880 0 180 $X=456320 $Y=552460
X1296 1371 1351 208 2 1 ND2S $T=460040 517560 0 0 $X=460040 $Y=517180
X1297 208 1377 212 2 1 ND2S $T=465000 517560 0 0 $X=465000 $Y=517180
X1298 1342 221 1273 2 1 ND2S $T=467480 517560 0 180 $X=465620 $Y=512140
X1299 1375 1409 1392 2 1 ND2S $T=470580 588120 1 180 $X=468720 $Y=587740
X1300 229 222 216 2 1 ND2S $T=476160 638520 1 180 $X=474300 $Y=638140
X1301 1203 224 1273 2 1 ND2S $T=477400 507480 0 0 $X=477400 $Y=507100
X1302 1414 1430 1395 2 1 ND2S $T=479260 517560 1 180 $X=477400 $Y=517180
X1303 229 1421 223 2 1 ND2S $T=479880 608280 1 180 $X=478020 $Y=607900
X1304 228 242 1414 2 1 ND2S $T=481740 507480 0 180 $X=479880 $Y=502060
X1305 227 1426 234 2 1 ND2S $T=479880 628440 1 0 $X=479880 $Y=623020
X1306 1428 1408 1438 2 1 ND2S $T=482360 578040 0 180 $X=480500 $Y=572620
X1307 1368 1431 1392 2 1 ND2S $T=480500 588120 0 0 $X=480500 $Y=587740
X1308 1433 1434 1444 2 1 ND2S $T=482980 517560 0 0 $X=482980 $Y=517180
X1309 235 233 1436 2 1 ND2S $T=483600 638520 1 0 $X=483600 $Y=633100
X1310 240 237 1429 2 1 ND2S $T=486080 527640 0 0 $X=486080 $Y=527260
X1311 1362 247 228 2 1 ND2S $T=489180 507480 1 0 $X=489180 $Y=502060
X1312 1416 1451 1453 2 1 ND2S $T=489180 567960 0 0 $X=489180 $Y=567580
X1313 1437 1463 1453 2 1 ND2S $T=492280 567960 0 0 $X=492280 $Y=567580
X1314 228 269 1355 2 1 ND2S $T=496620 507480 0 180 $X=494760 $Y=502060
X1315 1435 1476 1460 2 1 ND2S $T=494760 578040 1 0 $X=494760 $Y=572620
X1316 1467 1449 1460 2 1 ND2S $T=495380 598200 1 0 $X=495380 $Y=592780
X1317 1458 262 256 2 1 ND2S $T=500340 507480 1 180 $X=498480 $Y=507100
X1318 273 1478 263 2 1 ND2S $T=502820 517560 1 180 $X=500960 $Y=517180
X1319 229 1480 234 2 1 ND2S $T=502820 618360 1 180 $X=500960 $Y=617980
X1320 228 288 1484 2 1 ND2S $T=510880 507480 1 180 $X=509020 $Y=507100
X1321 286 243 270 2 1 ND2S $T=510260 608280 1 0 $X=510260 $Y=602860
X1322 295 297 1436 2 1 ND2S $T=510880 638520 0 0 $X=510880 $Y=638140
X1323 255 1512 1460 2 1 ND2S $T=512740 578040 1 0 $X=512740 $Y=572620
X1324 1429 1495 1532 2 1 ND2S $T=513360 557880 0 0 $X=513360 $Y=557500
X1325 240 1503 285 2 1 ND2S $T=515220 517560 0 0 $X=515220 $Y=517180
X1326 276 1527 1508 2 1 ND2S $T=515840 588120 1 0 $X=515840 $Y=582700
X1327 240 1510 225 2 1 ND2S $T=516460 547800 1 0 $X=516460 $Y=542380
X1328 1523 1521 1516 2 1 ND2S $T=518940 567960 1 0 $X=518940 $Y=562540
X1329 255 1524 1508 2 1 ND2S $T=518940 578040 1 0 $X=518940 $Y=572620
X1330 273 1535 1508 2 1 ND2S $T=523900 598200 0 0 $X=523900 $Y=597820
X1331 257 1537 1508 2 1 ND2S $T=526380 567960 1 180 $X=524520 $Y=567580
X1332 1501 1547 1474 2 1 ND2S $T=524520 588120 0 0 $X=524520 $Y=587740
X1333 325 1526 320 2 1 ND2S $T=527000 507480 1 180 $X=525140 $Y=507100
X1334 257 1553 320 2 1 ND2S $T=527000 527640 0 180 $X=525140 $Y=522220
X1335 229 1541 328 2 1 ND2S $T=527620 628440 1 0 $X=527620 $Y=623020
X1336 1563 334 321 2 1 ND2S $T=532580 507480 1 180 $X=530720 $Y=507100
X1337 1559 1572 1575 2 1 ND2S $T=532580 537720 1 180 $X=530720 $Y=537340
X1338 1521 1565 1474 2 1 ND2S $T=532580 588120 1 180 $X=530720 $Y=587740
X1339 1521 1590 1530 2 1 ND2S $T=532580 598200 1 180 $X=530720 $Y=597820
X1340 345 1566 1584 2 1 ND2S $T=536920 608280 0 0 $X=536920 $Y=607900
X1341 1539 1540 1438 2 1 ND2S $T=541880 578040 0 180 $X=540020 $Y=572620
X1342 355 1562 357 2 1 ND2S $T=540640 628440 0 0 $X=540640 $Y=628060
X1343 344 343 356 2 1 ND2S $T=543120 507480 1 0 $X=543120 $Y=502060
X1344 360 1554 1586 2 1 ND2S $T=543740 608280 0 0 $X=543740 $Y=607900
X1345 361 1579 1474 2 1 ND2S $T=544360 588120 1 0 $X=544360 $Y=582700
X1346 1548 1602 1436 2 1 ND2S $T=549940 628440 1 180 $X=548080 $Y=628060
X1347 330 1630 1604 2 1 ND2S $T=553040 608280 0 180 $X=551180 $Y=602860
X1348 1592 1617 1604 2 1 ND2S $T=553040 618360 0 180 $X=551180 $Y=612940
X1349 1507 1598 1635 2 1 ND2S $T=552420 588120 0 0 $X=552420 $Y=587740
X1350 1507 1622 328 2 1 ND2S $T=555520 578040 0 180 $X=553660 $Y=572620
X1351 1606 1610 1609 2 1 ND2S $T=554280 537720 0 0 $X=554280 $Y=537340
X1352 371 1608 350 2 1 ND2S $T=556140 628440 0 180 $X=554280 $Y=623020
X1353 1621 1620 377 2 1 ND2S $T=558620 517560 0 180 $X=556760 $Y=512140
X1354 1584 1614 1651 2 1 ND2S $T=557380 588120 1 0 $X=557380 $Y=582700
X1355 367 1615 380 2 1 ND2S $T=559860 638520 1 0 $X=559860 $Y=633100
X1356 261 1647 328 2 1 ND2S $T=564200 557880 1 180 $X=562340 $Y=557500
X1357 385 1655 1635 2 1 ND2S $T=565440 598200 0 180 $X=563580 $Y=592780
X1358 1635 1627 1651 2 1 ND2S $T=564200 588120 1 0 $X=564200 $Y=582700
X1359 330 1643 378 2 1 ND2S $T=566060 598200 0 0 $X=566060 $Y=597820
X1360 1507 1659 1584 2 1 ND2S $T=568540 588120 0 180 $X=566680 $Y=582700
X1361 1592 1666 1673 2 1 ND2S $T=572260 598200 0 0 $X=572260 $Y=597820
X1362 1592 391 218 2 1 ND2S $T=572260 628440 0 0 $X=572260 $Y=628060
X1363 1683 1689 395 2 1 ND2S $T=579080 507480 0 180 $X=577220 $Y=502060
X1364 1507 1721 1673 2 1 ND2S $T=585900 547800 0 0 $X=585900 $Y=547420
X1365 389 1742 1726 2 1 ND2S $T=592720 628440 0 0 $X=592720 $Y=628060
X1366 1745 415 356 2 1 ND2S $T=600160 507480 0 180 $X=598300 $Y=502060
X1367 1651 1805 1673 2 1 ND2S $T=610080 547800 1 180 $X=608220 $Y=547420
X1368 427 1795 432 2 1 ND2S $T=613800 507480 1 0 $X=613800 $Y=502060
X1369 1507 1825 1486 2 1 ND2S $T=625580 557880 1 0 $X=625580 $Y=552460
X1370 1486 1880 1651 2 1 ND2S $T=630540 567960 0 180 $X=628680 $Y=562540
X1371 1623 1883 460 2 1 ND2S $T=637360 578040 1 0 $X=637360 $Y=572620
X1372 385 1888 1899 2 1 ND2S $T=641080 578040 1 0 $X=641080 $Y=572620
X1373 371 1907 1726 2 1 ND2S $T=644180 618360 0 180 $X=642320 $Y=612940
X1374 462 1893 1726 2 1 ND2S $T=646660 628440 1 180 $X=644800 $Y=628060
X1375 1899 1909 1905 2 1 ND2S $T=647900 588120 0 180 $X=646040 $Y=582700
X1376 1623 1904 385 2 1 ND2S $T=648520 578040 1 180 $X=646660 $Y=577660
X1377 371 1929 1623 2 1 ND2S $T=653480 588120 1 180 $X=651620 $Y=587740
X1378 1623 1945 1918 2 1 ND2S $T=654100 578040 1 180 $X=652240 $Y=577660
X1379 1899 1938 470 2 1 ND2S $T=654720 578040 0 0 $X=654720 $Y=577660
X1380 259 1940 1899 2 1 ND2S $T=657200 598200 0 180 $X=655340 $Y=592780
X1381 2069 2125 518 2 1 ND2S $T=729740 628440 1 0 $X=729740 $Y=623020
X1382 2084 2133 519 2 1 ND2S $T=736560 618360 0 180 $X=734700 $Y=612940
X1383 2121 2127 2125 2 1 ND2S $T=737180 628440 0 180 $X=735320 $Y=623020
X1384 521 2132 522 2 1 ND2S $T=737180 507480 1 0 $X=737180 $Y=502060
X1385 2126 2131 2133 2 1 ND2S $T=741520 608280 1 0 $X=741520 $Y=602860
X1386 527 526 524 2 1 ND2S $T=745240 507480 0 180 $X=743380 $Y=502060
X1387 2114 2164 530 2 1 ND2S $T=752680 628440 0 180 $X=750820 $Y=623020
X1388 2057 2172 532 2 1 ND2S $T=758260 608280 0 180 $X=756400 $Y=602860
X1389 2153 2179 2172 2 1 ND2S $T=760740 618360 0 180 $X=758880 $Y=612940
X1390 2177 2181 2164 2 1 ND2S $T=761360 628440 1 180 $X=759500 $Y=628060
X1391 2189 2178 536 2 1 ND2S $T=760120 598200 0 0 $X=760120 $Y=597820
X1392 2105 543 541 2 1 ND2S $T=765080 638520 1 0 $X=765080 $Y=633100
X1393 2081 2202 554 2 1 ND2S $T=770660 618360 0 180 $X=768800 $Y=612940
X1394 2201 2207 2178 2 1 ND2S $T=771280 608280 0 180 $X=769420 $Y=602860
X1395 2195 2213 553 2 1 ND2S $T=775620 527640 0 180 $X=773760 $Y=522220
X1396 2205 2215 2213 2 1 ND2S $T=773760 547800 0 0 $X=773760 $Y=547420
X1397 2204 2208 543 2 1 ND2S $T=773760 638520 0 0 $X=773760 $Y=638140
X1398 2211 2217 2202 2 1 ND2S $T=776860 618360 0 0 $X=776860 $Y=617980
X1399 2219 2220 563 2 1 ND2S $T=779960 527640 0 0 $X=779960 $Y=527260
X1400 2199 2235 565 2 1 ND2S $T=779960 557880 1 0 $X=779960 $Y=552460
X1401 2226 2221 2236 2 1 ND2S $T=779960 628440 0 0 $X=779960 $Y=628060
X1402 2229 2224 2220 2 1 ND2S $T=783060 527640 1 0 $X=783060 $Y=522220
X1403 2130 2241 2227 2 1 ND2S $T=783060 557880 0 0 $X=783060 $Y=557500
X1404 2194 2242 568 2 1 ND2S $T=786160 517560 0 180 $X=784300 $Y=512140
X1405 2145 2236 570 2 1 ND2S $T=785540 628440 0 0 $X=785540 $Y=628060
X1406 2253 2255 2241 2 1 ND2S $T=788640 567960 0 180 $X=786780 $Y=562540
X1407 2079 2251 576 2 1 ND2S $T=788640 537720 0 0 $X=788640 $Y=537340
X1408 2254 2256 2242 2 1 ND2S $T=793600 517560 1 180 $X=791740 $Y=517180
X1409 2170 2265 573 2 1 ND2S $T=794840 567960 1 180 $X=792980 $Y=567580
X1410 2259 582 585 2 1 ND2S $T=794220 638520 0 0 $X=794220 $Y=638140
X1411 2243 2270 2251 2 1 ND2S $T=796700 537720 1 180 $X=794840 $Y=537340
X1412 2198 2272 586 2 1 ND2S $T=795460 507480 0 0 $X=795460 $Y=507100
X1413 2258 2266 2265 2 1 ND2S $T=795460 578040 0 0 $X=795460 $Y=577660
X1414 2268 2274 582 2 1 ND2S $T=799800 638520 1 180 $X=797940 $Y=638140
X1415 2197 2269 590 2 1 ND2S $T=800420 517560 1 0 $X=800420 $Y=512140
X1416 2275 2277 2269 2 1 ND2S $T=802900 527640 1 180 $X=801040 $Y=527260
X1417 2281 2278 2235 2 1 ND2S $T=804140 557880 1 180 $X=802280 $Y=557500
X1418 2285 2294 2272 2 1 ND2S $T=810340 517560 1 180 $X=808480 $Y=517180
X1419 601 2298 603 2 1 ND2S $T=810960 507480 1 0 $X=810960 $Y=502060
X1420 2203 2295 604 2 1 ND2S $T=810960 537720 0 0 $X=810960 $Y=537340
X1421 2306 2301 2295 2 1 ND2S $T=817160 537720 1 0 $X=817160 $Y=532300
X1422 2319 2347 2273 2 1 ND2S $T=833900 608280 0 180 $X=832040 $Y=602860
X1423 2322 2367 2328 2 1 ND2S $T=835760 578040 1 180 $X=833900 $Y=577660
X1424 2380 2397 2405 2 1 ND2S $T=848160 598200 1 0 $X=848160 $Y=592780
X1425 2421 2447 2440 2 1 ND2S $T=861800 588120 1 180 $X=859940 $Y=587740
X1426 2440 2442 2401 2 1 ND2S $T=859940 598200 1 0 $X=859940 $Y=592780
X1427 2468 2433 2507 2 1 ND2S $T=871720 588120 0 0 $X=871720 $Y=587740
X1428 2486 2501 2471 2 1 ND2S $T=872960 598200 0 0 $X=872960 $Y=597820
X1429 2480 2498 2401 2 1 ND2S $T=876060 588120 0 180 $X=874200 $Y=582700
X1430 2463 2523 2472 2 1 ND2S $T=879780 628440 0 180 $X=877920 $Y=623020
X1431 2448 2577 2485 2 1 ND2S $T=882260 618360 1 180 $X=880400 $Y=617980
X1432 2424 2567 2471 2 1 ND2S $T=882880 578040 1 180 $X=881020 $Y=577660
X1433 2518 2544 2525 2 1 ND2S $T=884740 618360 0 180 $X=882880 $Y=612940
X1434 667 2539 2538 2 1 ND2S $T=884120 638520 1 0 $X=884120 $Y=633100
X1435 673 2562 2538 2 1 ND2S $T=890940 638520 0 180 $X=889080 $Y=633100
X1436 2553 2557 2538 2 1 ND2S $T=889700 557880 0 0 $X=889700 $Y=557500
X1437 2501 2572 2560 2 1 ND2S $T=891560 608280 0 180 $X=889700 $Y=602860
X1438 2571 2573 2592 2 1 ND2S $T=892800 638520 1 0 $X=892800 $Y=633100
X1439 675 2571 2538 2 1 ND2S $T=892800 638520 0 0 $X=892800 $Y=638140
X1440 2593 2599 2538 2 1 ND2S $T=897140 557880 1 180 $X=895280 $Y=557500
X1441 681 2589 2509 2 1 ND2S $T=896520 628440 0 0 $X=896520 $Y=628060
X1442 686 2592 2509 2 1 ND2S $T=900240 638520 0 180 $X=898380 $Y=633100
X1443 2599 2640 2646 2 1 ND2S $T=910780 557880 1 0 $X=910780 $Y=552460
X1444 2622 2655 2660 2 1 ND2S $T=910780 578040 1 0 $X=910780 $Y=572620
X1445 2639 2646 2504 2 1 ND2S $T=913260 547800 0 0 $X=913260 $Y=547420
X1446 2606 2650 2670 2 1 ND2S $T=913260 618360 1 0 $X=913260 $Y=612940
X1447 2558 2663 2671 2 1 ND2S $T=916360 578040 1 0 $X=916360 $Y=572620
X1448 2568 2697 2634 2 1 ND2S $T=923800 578040 1 180 $X=921940 $Y=577660
X1449 2704 2669 2695 2 1 ND2S $T=926900 557880 1 180 $X=925040 $Y=557500
X1450 2679 2716 2702 2 1 ND2S $T=929380 547800 0 180 $X=927520 $Y=542380
X1451 2708 2681 2727 2 1 ND2S $T=928760 557880 1 0 $X=928760 $Y=552460
X1452 2697 2715 2718 2 1 ND2S $T=929380 578040 1 0 $X=929380 $Y=572620
X1453 2713 2708 2716 2 1 ND2S $T=931240 547800 0 0 $X=931240 $Y=547420
X1454 2732 2727 704 2 1 ND2S $T=934340 557880 1 0 $X=934340 $Y=552460
X1455 2728 2719 2544 2 1 ND2S $T=934340 618360 0 0 $X=934340 $Y=617980
X1456 2685 2741 2718 2 1 ND2S $T=937440 598200 1 0 $X=937440 $Y=592780
X1457 2725 2766 2620 2 1 ND2S $T=944880 567960 0 180 $X=943020 $Y=562540
X1458 2756 2747 2774 2 1 ND2S $T=944880 507480 0 0 $X=944880 $Y=507100
X1459 2620 2778 2754 2 1 ND2S $T=948600 578040 1 0 $X=948600 $Y=572620
X1460 2673 2761 2738 2 1 ND2S $T=949220 608280 0 0 $X=949220 $Y=607900
X1461 2760 2799 2748 2 1 ND2S $T=954180 557880 1 180 $X=952320 $Y=557500
X1462 2353 2774 712 2 1 ND2S $T=952940 507480 1 0 $X=952940 $Y=502060
X1463 2119 2134 1 2133 2135 2 OAI12H $T=744000 618360 0 0 $X=744000 $Y=617980
X1464 2169 2151 1 2164 2171 2 OAI12H $T=762600 628440 0 180 $X=756400 $Y=623020
X1465 2209 2212 1 2213 2223 2 OAI12H $T=773140 537720 0 0 $X=773140 $Y=537340
X1466 2237 2246 1 2242 2263 2 OAI12H $T=789260 527640 1 0 $X=789260 $Y=522220
X1467 2248 2260 1 2235 2238 2 OAI12H $T=793600 547800 0 0 $X=793600 $Y=547420
X1468 2288 2291 1 2295 2297 2 OAI12H $T=809720 527640 1 0 $X=809720 $Y=522220
X1469 2121 2135 2 2151 2128 1 AOI12H $T=741520 628440 0 0 $X=741520 $Y=628060
X1470 2211 2171 2 549 2200 1 AOI12H $T=775620 628440 0 180 $X=769420 $Y=623020
X1471 2229 2223 2 2246 2228 1 AOI12H $T=781820 537720 1 0 $X=781820 $Y=532300
X1472 2243 2238 2 2212 2234 1 AOI12H $T=788640 547800 0 180 $X=782440 $Y=542380
X1473 2226 562 2 583 2247 1 AOI12H $T=785540 638520 0 0 $X=785540 $Y=638140
X1474 2275 2263 2 2291 2283 1 AOI12H $T=802280 527640 1 0 $X=802280 $Y=522220
X1475 2285 2297 2 607 2302 1 AOI12H $T=812200 517560 1 0 $X=812200 $Y=512140
X1476 891 863 880 2 1 XOR2HS $T=280860 598200 1 180 $X=275280 $Y=597820
X1477 968 60 1021 2 1 XOR2HS $T=332940 608280 1 180 $X=327360 $Y=607900
X1478 102 1032 1069 2 1 XOR2HS $T=342240 598200 1 0 $X=342240 $Y=592780
X1479 1155 138 1162 2 1 XOR2HS $T=386880 517560 1 180 $X=381300 $Y=517180
X1480 1178 1149 1192 2 1 XOR2HS $T=388740 527640 0 0 $X=388740 $Y=527260
X1481 1208 1197 1214 2 1 XOR2HS $T=399900 517560 1 0 $X=399900 $Y=512140
X1482 1434 1428 1424 2 1 XOR2HS $T=482360 527640 1 0 $X=482360 $Y=522220
X1483 1610 344 1605 2 1 XOR2HS $T=556140 527640 0 180 $X=550560 $Y=522220
X1484 1620 1633 1641 2 1 XOR2HS $T=559860 527640 0 0 $X=559860 $Y=527260
X1485 2131 2134 2139 2 1 XOR2HS $T=741520 608280 0 0 $X=741520 $Y=607900
X1486 2181 2151 2191 2 1 XOR2HS $T=762600 628440 1 0 $X=762600 $Y=623020
X1487 2208 549 2216 2 1 XOR2HS $T=772520 628440 0 0 $X=772520 $Y=628060
X1488 2206 2207 2218 2 1 XOR2HS $T=773760 608280 1 0 $X=773760 $Y=602860
X1489 2215 2212 2222 2 1 XOR2HS $T=775620 547800 1 0 $X=775620 $Y=542380
X1490 2256 2246 2250 2 1 XOR2HS $T=793600 527640 0 0 $X=793600 $Y=527260
X1491 2271 2266 2279 2 1 XOR2HS $T=799800 578040 0 0 $X=799800 $Y=577660
X1492 2274 583 597 2 1 XOR2HS $T=802280 638520 0 0 $X=802280 $Y=638140
X1493 2278 2260 2284 2 1 XOR2HS $T=802900 567960 1 0 $X=802900 $Y=562540
X1494 2298 607 2310 2 1 XOR2HS $T=815920 507480 1 0 $X=815920 $Y=502060
X1495 2301 2291 2311 2 1 XOR2HS $T=815920 527640 1 0 $X=815920 $Y=522220
X1496 630 626 2332 2 1 XOR2HS $T=837000 507480 0 180 $X=831420 $Y=502060
X1497 2634 2688 2678 2 1 XOR2HS $T=923800 588120 1 180 $X=918220 $Y=587740
X1498 2602 2700 2706 2 1 XOR2HS $T=924420 598200 0 0 $X=924420 $Y=597820
X1499 2629 2761 2768 2 1 XOR2HS $T=941780 608280 1 0 $X=941780 $Y=602860
X1500 861 36 891 2 1 XNR2HS $T=282100 608280 0 0 $X=282100 $Y=607900
X1501 948 1021 1025 2 1 XNR2HS $T=326120 598200 0 0 $X=326120 $Y=597820
X1502 1028 102 1090 2 1 XNR2HS $T=352780 598200 1 0 $X=352780 $Y=592780
X1503 1186 142 1194 2 1 XNR2HS $T=391840 517560 0 0 $X=391840 $Y=517180
X1504 186 1271 1287 2 1 XNR2HS $T=433380 507480 0 0 $X=433380 $Y=507100
X1505 1326 1276 1322 2 1 XNR2HS $T=451360 537720 0 180 $X=445780 $Y=532300
X1506 1395 1414 1401 2 1 XNR2HS $T=476780 507480 1 180 $X=471200 $Y=507100
X1507 1430 236 1441 2 1 XNR2HS $T=482980 507480 0 0 $X=482980 $Y=507100
X1508 1444 1433 1454 2 1 XNR2HS $T=488560 527640 1 0 $X=488560 $Y=522220
X1509 1609 1606 1600 2 1 XNR2HS $T=554280 547800 0 180 $X=548700 $Y=542380
X1510 377 375 1638 2 1 XNR2HS $T=558620 517560 1 0 $X=558620 $Y=512140
X1511 379 1700 1711 2 1 XNR2HS $T=579700 517560 0 0 $X=579700 $Y=517180
X1512 2127 2135 2140 2 1 XNR2HS $T=741520 628440 1 0 $X=741520 $Y=623020
X1513 2179 2158 2192 2 1 XNR2HS $T=763220 618360 1 0 $X=763220 $Y=612940
X1514 2217 2171 2225 2 1 XNR2HS $T=776240 628440 1 0 $X=776240 $Y=623020
X1515 2221 562 2230 2 1 XNR2HS $T=778100 638520 0 0 $X=778100 $Y=638140
X1516 2224 2223 2233 2 1 XNR2HS $T=779960 537720 0 0 $X=779960 $Y=537340
X1517 2173 560 2240 2 1 XNR2HS $T=783060 598200 0 0 $X=783060 $Y=597820
X1518 2255 2257 2264 2 1 XNR2HS $T=794220 567960 1 0 $X=794220 $Y=562540
X1519 2270 2238 2276 2 1 XNR2HS $T=799180 547800 1 0 $X=799180 $Y=542380
X1520 2277 2263 2286 2 1 XNR2HS $T=804760 527640 0 0 $X=804760 $Y=527260
X1521 2190 599 2290 2 1 XNR2HS $T=807240 578040 1 0 $X=807240 $Y=572620
X1522 2294 2297 2305 2 1 XNR2HS $T=813440 517560 0 0 $X=813440 $Y=517180
X1523 2572 2650 2661 2 1 XNR2HS $T=911400 608280 0 0 $X=911400 $Y=607900
X1524 2575 2715 2726 2 1 XNR2HS $T=929380 588120 1 0 $X=929380 $Y=582700
X1525 2747 2723 2734 2 1 XNR2HS $T=939920 507480 1 180 $X=934340 $Y=507100
X1526 2528 2735 2743 2 1 XNR2HS $T=934340 557880 0 0 $X=934340 $Y=557500
X1527 2648 2742 2753 2 1 XNR2HS $T=936200 628440 1 0 $X=936200 $Y=623020
X1528 2617 2730 2755 2 1 XNR2HS $T=936820 598200 0 0 $X=936820 $Y=597820
X1529 2544 2771 2779 2 1 XNR2HS $T=945500 618360 1 0 $X=945500 $Y=612940
X1530 2663 2784 2793 2 1 XNR2HS $T=950460 588120 0 0 $X=950460 $Y=587740
X1531 2699 2788 2807 2 1 XNR2HS $T=954800 547800 1 0 $X=954800 $Y=542380
X1532 2537 2799 2805 2 1 XNR2HS $T=956660 557880 0 0 $X=956660 $Y=557500
X1533 2802 2783 2808 2 1 XNR2HS $T=956660 578040 0 0 $X=956660 $Y=577660
X1534 1389 231 2 1 1416 1285 MUX2 $T=481740 567960 1 180 $X=477400 $Y=567580
X1535 1419 231 2 1 1437 1367 MUX2 $T=493520 567960 0 180 $X=489180 $Y=562540
X1536 257 231 2 1 1456 250 MUX2 $T=497240 537720 1 180 $X=492900 $Y=537340
X1537 255 231 2 1 1477 265 MUX2 $T=496620 547800 0 0 $X=496620 $Y=547420
X1538 2732 2702 2 1 2717 2713 MUX2 $T=936200 547800 0 180 $X=931860 $Y=542380
X1539 755 1 2 758 DELB $T=220100 527640 1 0 $X=220100 $Y=522220
X1540 757 1 2 760 DELB $T=221340 578040 0 0 $X=221340 $Y=577660
X1541 756 1 2 759 DELB $T=221960 547800 1 0 $X=221960 $Y=542380
X1542 761 1 2 763 DELB $T=222580 567960 1 0 $X=222580 $Y=562540
X1543 772 1 2 767 DELB $T=225060 598200 0 0 $X=225060 $Y=597820
X1544 773 1 2 774 DELB $T=225680 628440 0 0 $X=225680 $Y=628060
X1545 776 1 2 787 DELB $T=228780 557880 1 0 $X=228780 $Y=552460
X1546 777 1 2 779 DELB $T=230020 547800 1 0 $X=230020 $Y=542380
X1547 782 1 2 783 DELB $T=232500 578040 0 0 $X=232500 $Y=577660
X1548 781 1 2 770 DELB $T=232500 598200 0 0 $X=232500 $Y=597820
X1549 789 1 2 794 DELB $T=234980 527640 1 0 $X=234980 $Y=522220
X1550 790 1 2 785 DELB $T=234980 547800 1 0 $X=234980 $Y=542380
X1551 788 1 2 780 DELB $T=235600 588120 0 0 $X=235600 $Y=587740
X1552 796 1 2 792 DELB $T=235600 618360 1 0 $X=235600 $Y=612940
X1553 795 1 2 791 DELB $T=236220 608280 1 0 $X=236220 $Y=602860
X1554 797 1 2 775 DELB $T=236840 628440 1 0 $X=236840 $Y=623020
X1555 798 1 2 799 DELB $T=236840 638520 1 0 $X=236840 $Y=633100
X1556 803 1 2 814 DELB $T=240560 547800 1 0 $X=240560 $Y=542380
X1557 801 1 2 811 DELB $T=240560 638520 0 0 $X=240560 $Y=638140
X1558 805 1 2 806 DELB $T=242420 527640 1 0 $X=242420 $Y=522220
X1559 807 1 2 815 DELB $T=243040 578040 0 0 $X=243040 $Y=577660
X1560 793 1 2 812 DELB $T=244900 588120 0 0 $X=244900 $Y=587740
X1561 784 1 2 813 DELB $T=247380 527640 1 0 $X=247380 $Y=522220
X1562 818 1 2 820 DELB $T=248620 567960 1 0 $X=248620 $Y=562540
X1563 809 1 2 816 DELB $T=249860 588120 0 0 $X=249860 $Y=587740
X1564 808 1 2 834 DELB $T=251100 608280 0 0 $X=251100 $Y=607900
X1565 827 1 2 823 DELB $T=252340 547800 0 0 $X=252340 $Y=547420
X1566 828 1 2 821 DELB $T=252960 527640 1 0 $X=252960 $Y=522220
X1567 832 1 2 829 DELB $T=254820 608280 1 0 $X=254820 $Y=602860
X1568 833 1 2 810 DELB $T=255440 638520 1 0 $X=255440 $Y=633100
X1569 831 1 2 837 DELB $T=257300 588120 0 0 $X=257300 $Y=587740
X1570 836 1 2 819 DELB $T=259780 527640 0 0 $X=259780 $Y=527260
X1571 845 1 2 851 DELB $T=260400 537720 0 0 $X=260400 $Y=537340
X1572 850 1 2 860 DELB $T=262260 618360 0 0 $X=262260 $Y=617980
X1573 839 1 2 841 DELB $T=264740 578040 0 0 $X=264740 $Y=577660
X1574 843 1 2 867 DELB $T=265980 527640 0 0 $X=265980 $Y=527260
X1575 854 1 2 857 DELB $T=267840 567960 0 0 $X=267840 $Y=567580
X1576 848 1 2 864 DELB $T=269700 608280 0 0 $X=269700 $Y=607900
X1577 859 1 2 865 DELB $T=269700 638520 1 0 $X=269700 $Y=633100
X1578 40 1 2 887 DELB $T=274660 638520 1 0 $X=274660 $Y=633100
X1579 882 1 2 893 DELB $T=277140 608280 0 0 $X=277140 $Y=607900
X1580 861 1 2 868 DELB $T=277140 628440 1 0 $X=277140 $Y=623020
X1581 872 1 2 56 DELB $T=279620 638520 1 0 $X=279620 $Y=633100
X1582 898 1 2 900 DELB $T=284580 638520 1 0 $X=284580 $Y=633100
X1583 921 1 2 918 DELB $T=293260 638520 1 0 $X=293260 $Y=633100
X1584 926 1 2 917 DELB $T=293880 628440 1 0 $X=293880 $Y=623020
X1585 935 1 2 937 DELB $T=298220 598200 0 0 $X=298220 $Y=597820
X1586 67 1 2 71 DELB $T=298220 638520 1 0 $X=298220 $Y=633100
X1587 73 1 2 955 DELB $T=304420 638520 1 0 $X=304420 $Y=633100
X1588 946 1 2 988 DELB $T=311240 598200 1 0 $X=311240 $Y=592780
X1589 979 1 2 989 DELB $T=311240 628440 1 0 $X=311240 $Y=623020
X1590 76 1 2 82 DELB $T=311860 638520 1 0 $X=311860 $Y=633100
X1591 992 1 2 970 DELB $T=317440 618360 1 0 $X=317440 $Y=612940
X1592 996 1 2 997 DELB $T=319920 638520 1 0 $X=319920 $Y=633100
X1593 1005 1 2 1017 DELB $T=321780 628440 0 0 $X=321780 $Y=628060
X1594 1012 1 2 1011 DELB $T=325500 638520 1 0 $X=325500 $Y=633100
X1595 1030 1 2 1044 DELB $T=330460 618360 1 0 $X=330460 $Y=612940
X1596 1032 1 2 1046 DELB $T=331080 608280 1 0 $X=331080 $Y=602860
X1597 968 1 2 1026 DELB $T=331080 618360 0 0 $X=331080 $Y=617980
X1598 98 1 2 1058 DELB $T=335420 638520 1 0 $X=335420 $Y=633100
X1599 1048 1 2 105 DELB $T=337900 638520 0 0 $X=337900 $Y=638140
X1600 1057 1 2 1067 DELB $T=341000 618360 0 0 $X=341000 $Y=617980
X1601 1070 1 2 1077 DELB $T=345960 618360 0 0 $X=345960 $Y=617980
X1602 1082 1 2 1075 DELB $T=352160 638520 1 0 $X=352160 $Y=633100
X1603 1106 1 2 1107 DELB $T=360840 618360 0 0 $X=360840 $Y=617980
X1604 1108 1 2 1091 DELB $T=360840 628440 1 0 $X=360840 $Y=623020
X1605 1123 1 2 1100 DELB $T=369520 598200 0 0 $X=369520 $Y=597820
X1606 1130 1 2 1131 DELB $T=371380 608280 1 0 $X=371380 $Y=602860
X1607 1161 1 2 1174 DELB $T=381920 608280 1 0 $X=381920 $Y=602860
X1608 1862 1 2 1881 DELB $T=631780 517560 0 0 $X=631780 $Y=517180
X1609 1910 1 2 1985 DELB $T=670840 517560 1 0 $X=670840 $Y=512140
X1610 2025 1 2 2026 DELB $T=694400 507480 0 0 $X=694400 $Y=507100
X1611 2037 1 2 2042 DELB $T=701220 527640 1 0 $X=701220 $Y=522220
X1612 2040 1 2 2049 DELB $T=704940 517560 1 0 $X=704940 $Y=512140
X1613 1965 1 2 2052 DELB $T=707420 537720 1 0 $X=707420 $Y=532300
X1614 2060 1 2 2053 DELB $T=711140 517560 1 0 $X=711140 $Y=512140
X1615 2034 1 2 2067 DELB $T=716100 557880 1 0 $X=716100 $Y=552460
X1616 1932 1 2 2070 DELB $T=717340 537720 1 0 $X=717340 $Y=532300
X1617 2072 1 2 2083 DELB $T=717960 517560 1 0 $X=717960 $Y=512140
X1618 2077 1 2 2093 DELB $T=719820 567960 0 0 $X=719820 $Y=567580
X1619 2039 1 2 2088 DELB $T=722920 557880 1 0 $X=722920 $Y=552460
X1620 2082 1 2 2096 DELB $T=727880 557880 1 0 $X=727880 $Y=552460
X1621 2109 1 2 2112 DELB $T=733460 537720 1 0 $X=733460 $Y=532300
X1622 2080 1 2 2129 DELB $T=735320 578040 1 0 $X=735320 $Y=572620
X1623 529 1 2 2147 DELB $T=748340 517560 0 0 $X=748340 $Y=517180
X1624 2041 1 2 2160 DELB $T=752680 537720 1 0 $X=752680 $Y=532300
X1625 552 1 2 2210 DELB $T=774380 507480 0 0 $X=774380 $Y=507100
X1626 1029 1028 1 2 1009 AN2 $T=331080 608280 0 180 $X=328600 $Y=602860
X1627 1084 1086 1 2 1089 AN2 $T=352160 578040 0 0 $X=352160 $Y=577660
X1628 1097 1104 1 2 1101 AN2 $T=360840 547800 1 180 $X=358360 $Y=547420
X1629 1093 1149 1 2 1159 AN2 $T=378820 527640 0 0 $X=378820 $Y=527260
X1630 1034 1153 1 2 1170 AN2 $T=387500 578040 1 180 $X=385020 $Y=577660
X1631 987 1211 1 2 1226 AN2 $T=405480 567960 1 0 $X=405480 $Y=562540
X1632 972 1248 1 2 1255 AN2 $T=420360 557880 1 0 $X=420360 $Y=552460
X1633 1494 294 1 2 1506 AN2 $T=509640 537720 1 0 $X=509640 $Y=532300
X1634 1986 1995 1 2 2005 AN2 $T=678280 567960 1 0 $X=678280 $Y=562540
X1635 651 2485 1 2 2517 AN2 $T=877300 598200 0 0 $X=877300 $Y=597820
X1636 2480 2468 1 2 2563 AN2 $T=886600 588120 0 0 $X=886600 $Y=587740
X1637 2523 2531 1 2 2570 AN2 $T=889700 628440 1 0 $X=889700 $Y=623020
X1638 2563 2481 1 2 2585 AN2 $T=892180 598200 1 0 $X=892180 $Y=592780
X1639 1945 1938 2 1943 1 1959 AOI12HS $T=659060 578040 1 0 $X=659060 $Y=572620
X1640 2153 2158 2 2163 1 2134 AOI12HS $T=750200 608280 0 0 $X=750200 $Y=607900
X1641 2253 2257 2 2252 1 2260 AOI12HS $T=796080 557880 0 180 $X=791740 $Y=552460
X1642 1086 1084 1092 1 2 1094 OA12 $T=354640 567960 0 0 $X=354640 $Y=567580
X1643 1104 1097 1117 1 2 1105 OA12 $T=368280 557880 0 180 $X=364560 $Y=552460
X1644 1149 1093 1166 1 2 1148 OA12 $T=388120 527640 0 180 $X=384400 $Y=522220
X1645 1153 1034 1119 1 2 1163 OA12 $T=388120 588120 1 180 $X=384400 $Y=587740
X1646 1211 987 1207 1 2 1221 OA12 $T=402380 578040 1 0 $X=402380 $Y=572620
X1647 1248 972 1224 1 2 1252 OA12 $T=419120 547800 1 0 $X=419120 $Y=542380
X1648 1340 1338 1335 1 2 1308 OA12 $T=452600 578040 1 180 $X=448880 $Y=577660
X1649 1350 1338 1353 1 2 1268 OA12 $T=458180 578040 1 180 $X=454460 $Y=577660
X1650 1564 1557 1556 1 2 1544 OA12 $T=533200 578040 0 180 $X=529480 $Y=572620
X1651 787 765 778 2 1 817 QDFFRBS $T=233740 557880 1 0 $X=233740 $Y=552460
X1652 819 765 802 2 1 842 QDFFRBS $T=248000 527640 0 0 $X=248000 $Y=527260
X1653 837 765 826 2 1 856 QDFFRBS $T=256060 588120 1 0 $X=256060 $Y=582700
X1654 864 765 824 2 1 896 QDFFRBS $T=269080 618360 1 0 $X=269080 $Y=612940
X1655 887 765 826 2 1 961 QDFFRBS $T=290780 608280 0 0 $X=290780 $Y=607900
X1656 1080 87 1079 2 1 1106 QDFFRBS $T=350300 618360 1 0 $X=350300 $Y=612940
X1657 182 110 1243 2 1 169 QDFFRBS $T=432140 507480 1 180 $X=420360 $Y=507100
X1658 1315 110 181 2 1 186 QDFFRBS $T=449500 507480 1 0 $X=449500 $Y=502060
X1659 1981 479 2012 2 1 2024 QDFFRBS $T=679520 608280 1 0 $X=679520 $Y=602860
X1660 1998 479 2016 2 1 2030 QDFFRBS $T=682000 628440 1 0 $X=682000 $Y=623020
X1661 2022 437 2032 2 1 2048 QDFFRBS $T=692540 537720 0 0 $X=692540 $Y=537340
X1662 1949 437 2031 2 1 2082 QDFFRBS $T=706800 557880 0 0 $X=706800 $Y=557500
X1663 2096 437 2089 2 1 2120 QDFFRBS $T=726020 567960 1 0 $X=726020 $Y=562540
X1664 2076 437 2157 2 1 2184 QDFFRBS $T=751440 567960 1 0 $X=751440 $Y=562540
X1665 2186 437 2188 2 1 564 QDFFRBS $T=768800 557880 0 0 $X=768800 $Y=557500
X1666 2279 580 2309 2 1 2335 QDFFRBS $T=815300 578040 0 0 $X=815300 $Y=577660
X1667 2798 658 2751 2 1 2732 QDFFRBS $T=956660 537720 0 180 $X=944880 $Y=532300
X1668 1115 1 2 1146 BUF1CK $T=376340 537720 1 0 $X=376340 $Y=532300
X1669 1104 1 2 1147 BUF1CK $T=376960 547800 0 0 $X=376960 $Y=547420
X1670 1086 1 2 1150 BUF1CK $T=380680 578040 1 0 $X=380680 $Y=572620
X1671 1162 1 2 1158 BUF1CK $T=382540 517560 1 0 $X=382540 $Y=512140
X1672 1169 1 2 1165 BUF1CK $T=384400 507480 0 0 $X=384400 $Y=507100
X1673 1171 1 2 1085 BUF1CK $T=387500 567960 1 0 $X=387500 $Y=562540
X1674 1304 1 2 1300 BUF1CK $T=440200 557880 1 0 $X=440200 $Y=552460
X1675 1307 1 2 1269 BUF1CK $T=440820 547800 0 0 $X=440820 $Y=547420
X1676 1326 1 2 1345 BUF1CK $T=454460 537720 1 0 $X=454460 $Y=532300
X1677 1358 1 2 1296 BUF1CK $T=456940 567960 0 0 $X=456940 $Y=567580
X1678 1378 1 2 1299 BUF1CK $T=464380 567960 0 180 $X=461900 $Y=562540
X1679 268 1 2 1358 BUF1CK $T=502820 557880 1 180 $X=500340 $Y=557500
X1680 1624 1 2 1606 BUF1CK $T=558620 557880 1 0 $X=558620 $Y=552460
X1681 1631 1 2 1633 BUF1CK $T=559860 537720 0 0 $X=559860 $Y=537340
X1682 1621 1 2 1645 BUF1CK $T=562960 517560 0 0 $X=562960 $Y=517180
X1683 390 1 2 1656 BUF1CK $T=570400 507480 1 0 $X=570400 $Y=502060
X1684 1646 1 2 1658 BUF1CK $T=571640 527640 0 0 $X=571640 $Y=527260
X1685 399 1 2 1698 BUF1CK $T=584660 507480 1 0 $X=584660 $Y=502060
X1686 1935 1 2 1674 BUF1CK $T=658440 608280 0 180 $X=655960 $Y=602860
X1687 2810 1 2 2804 BUF1CK $T=957900 527640 0 0 $X=957900 $Y=527260
X1688 2701 1 2 2829 BUF1CK $T=965960 567960 1 0 $X=965960 $Y=562540
X1689 2722 1 2 2649 BUF1CK $T=968440 567960 1 0 $X=968440 $Y=562540
X1690 2841 1 2 2837 BUF1CK $T=970920 598200 1 0 $X=970920 $Y=592780
X1691 2844 1 2 2840 BUF1CK $T=974640 527640 1 0 $X=974640 $Y=522220
X1692 33 765 1 2 INV12CK $T=266600 537720 0 0 $X=266600 $Y=537340
X1693 113 33 1 2 INV12CK $T=357740 517560 0 180 $X=347820 $Y=512140
X1694 33 110 1 2 INV12CK $T=359600 507480 0 180 $X=349680 $Y=502060
X1695 113 429 1 2 INV12CK $T=613800 517560 0 0 $X=613800 $Y=517180
X1696 429 437 1 2 INV12CK $T=613800 527640 0 0 $X=613800 $Y=527260
X1697 2085 479 1 2 INV12CK $T=721680 588120 0 0 $X=721680 $Y=587740
X1698 520 2085 1 2 INV12CK $T=735940 588120 0 0 $X=735940 $Y=587740
X1699 2085 580 1 2 INV12CK $T=856840 507480 0 180 $X=846920 $Y=502060
X1700 2085 658 1 2 INV12CK $T=913880 507480 0 0 $X=913880 $Y=507100
X1701 1029 948 1032 1 2 ND2 $T=341000 608280 1 0 $X=341000 $Y=602860
X1702 1297 1289 1278 1 2 ND2 $T=437720 537720 1 180 $X=435860 $Y=537340
X1703 1298 1310 1279 1 2 ND2 $T=443920 547800 1 0 $X=443920 $Y=542380
X1704 1316 139 1325 1 2 ND2 $T=444540 598200 1 0 $X=444540 $Y=592780
X1705 1349 1350 1346 1 2 ND2 $T=455700 547800 1 180 $X=453840 $Y=547420
X1706 1275 1157 1281 1 2 ND2 $T=458180 608280 1 0 $X=458180 $Y=602860
X1707 1364 1340 1372 1 2 ND2 $T=465620 547800 1 0 $X=465620 $Y=542380
X1708 1275 218 1281 1 2 ND2 $T=469960 608280 1 180 $X=468100 $Y=607900
X1709 1397 1375 1405 1 2 ND2 $T=470580 547800 1 0 $X=470580 $Y=542380
X1710 1396 116 1407 1 2 ND2 $T=475540 578040 1 180 $X=473680 $Y=577660
X1711 1425 1368 1427 1 2 ND2 $T=479880 557880 0 0 $X=479880 $Y=557500
X1712 1451 241 1447 1 2 ND2 $T=490420 598200 1 180 $X=488560 $Y=597820
X1713 1458 246 256 1 2 ND2 $T=494760 507480 0 0 $X=494760 $Y=507100
X1714 286 271 270 1 2 ND2 $T=503440 608280 0 180 $X=501580 $Y=602860
X1715 1455 293 1496 1 2 ND2 $T=509640 578040 0 0 $X=509640 $Y=577660
X1716 1558 298 1570 1 2 ND2 $T=532580 507480 1 0 $X=532580 $Y=502060
X1717 1477 1603 1453 1 2 ND2 $T=548700 567960 0 180 $X=546840 $Y=562540
X1718 363 1601 1607 1 2 ND2 $T=549320 507480 0 0 $X=549320 $Y=507100
X1719 330 1619 1436 1 2 ND2 $T=556140 618360 1 180 $X=554280 $Y=617980
X1720 383 1637 1623 1 2 ND2 $T=562340 598200 1 180 $X=560480 $Y=597820
X1721 434 1948 470 1 2 ND2 $T=655340 628440 0 0 $X=655340 $Y=628060
X1722 483 1970 1921 1 2 ND2 $T=671460 628440 0 0 $X=671460 $Y=628060
X1723 903 908 1 911 2 904 OAI12HS $T=285200 537720 0 0 $X=285200 $Y=537340
X1724 1180 959 1 1216 2 1224 OAI12HS $T=403000 537720 0 0 $X=403000 $Y=537340
X1725 1511 1550 1 332 2 1509 OAI12HS $T=533200 517560 0 180 $X=529480 $Y=512140
X1726 459 455 1 1868 2 1906 OAI12HS $T=647900 517560 1 180 $X=644180 $Y=517180
X1727 2206 2185 1 2178 2 2158 OAI12HS $T=765700 608280 0 180 $X=761980 $Y=602860
X1728 2271 2249 1 2265 2 2257 OAI12HS $T=802280 567960 1 180 $X=798560 $Y=567580
X1729 2608 683 1 2519 2 2597 OAI12HS $T=900860 618360 0 180 $X=897140 $Y=612940
X1730 2603 2526 1 2596 2 2611 OAI12HS $T=903960 578040 1 180 $X=900240 $Y=577660
X1731 2707 2617 1 2730 2 2700 OAI12HS $T=931860 598200 0 0 $X=931860 $Y=597820
X1732 2745 2673 1 2738 2 2730 OAI12HS $T=938060 608280 1 0 $X=938060 $Y=602860
X1733 2739 708 1 2780 2 2772 OAI12HS $T=946740 638520 1 0 $X=946740 $Y=633100
X1734 2790 2760 1 2748 2 2788 OAI12HS $T=952940 547800 1 180 $X=949220 $Y=547420
X1735 709 2801 1 2765 2 2781 OAI12HS $T=953560 638520 1 0 $X=953560 $Y=633100
X1736 2808 2796 1 2763 2 2791 OAI12HS $T=957900 588120 0 180 $X=954180 $Y=582700
X1737 2762 2812 1 2818 2 2806 OAI12HS $T=957900 588120 0 0 $X=957900 $Y=587740
X1738 35 1 24 849 844 11 2 OAI22S $T=264740 507480 0 180 $X=261020 $Y=502060
X1739 910 1 883 910 907 906 2 OAI22S $T=288920 567960 0 180 $X=285200 $Y=562540
X1740 906 1 874 923 929 910 2 OAI22S $T=292020 578040 1 0 $X=292020 $Y=572620
X1741 1129 1 1132 1129 1127 1118 2 OAI22S $T=373240 628440 1 180 $X=369520 $Y=628060
X1742 1165 1 136 1158 1156 134 2 OAI22S $T=384400 507480 1 180 $X=380680 $Y=507100
X1743 1172 1 1175 1172 1177 1182 2 OAI22S $T=385020 618360 1 0 $X=385020 $Y=612940
X1744 1219 1 1222 1219 1225 1236 2 OAI22S $T=405480 608280 1 0 $X=405480 $Y=602860
X1745 163 1 162 161 1228 145 2 OAI22S $T=415400 507480 0 180 $X=411680 $Y=502060
X1746 1272 1 1096 1265 1263 1153 2 OAI22S $T=433380 588120 0 180 $X=429660 $Y=582700
X1747 1272 1 179 1265 1280 1261 2 OAI22S $T=432760 567960 0 0 $X=432760 $Y=567580
X1748 168 1 1299 1296 1292 1284 2 OAI22S $T=440820 567960 0 180 $X=437100 $Y=562540
X1749 1284 1 1299 1296 1309 179 2 OAI22S $T=440200 567960 0 0 $X=440200 $Y=567580
X1750 193 1 162 1287 1315 199 2 OAI22S $T=442060 507480 0 0 $X=442060 $Y=507100
X1751 1272 1 1212 1265 1320 1203 2 OAI22S $T=443920 567960 1 0 $X=443920 $Y=562540
X1752 149 1 1299 1296 1337 1211 2 OAI22S $T=455700 567960 1 180 $X=451980 $Y=567580
X1753 1272 1 1342 1265 1352 198 2 OAI22S $T=458800 567960 0 180 $X=455080 $Y=562540
X1754 190 1 1299 1358 1363 149 2 OAI22S $T=463140 567960 1 180 $X=459420 $Y=567580
X1755 198 1 1378 1358 1370 1203 2 OAI22S $T=465000 557880 1 180 $X=461280 $Y=557500
X1756 1342 1 1378 1358 1390 198 2 OAI22S $T=465620 567960 1 0 $X=465620 $Y=562540
X1757 1272 1 160 1265 1399 1362 2 OAI22S $T=474300 547800 1 180 $X=470580 $Y=547420
X1758 1413 1 1406 1265 1418 1415 2 OAI22S $T=476160 547800 0 0 $X=476160 $Y=547420
X1759 236 1 162 174 1440 1441 2 OAI22S $T=483600 517560 1 0 $X=483600 $Y=512140
X1760 1413 1 1415 230 1445 1446 2 OAI22S $T=485460 547800 0 0 $X=485460 $Y=547420
X1761 1362 1 1378 1358 1448 1355 2 OAI22S $T=488560 557880 1 0 $X=488560 $Y=552460
X1762 278 1 1475 268 1471 1433 2 OAI22S $T=503440 557880 0 180 $X=499720 $Y=552460
X1763 1494 1 322 1534 1465 1552 2 OAI22S $T=523900 527640 0 0 $X=523900 $Y=527260
X1764 327 1 1554 327 1502 1566 2 OAI22S $T=528240 608280 0 0 $X=528240 $Y=607900
X1765 1564 1 1522 1557 1464 1338 2 OAI22S $T=533820 567960 0 180 $X=530100 $Y=562540
X1766 278 1 1539 268 1551 1532 2 OAI22S $T=535060 557880 1 180 $X=531340 $Y=557500
X1767 278 1 344 268 1582 349 2 OAI22S $T=535680 527640 1 0 $X=535680 $Y=522220
X1768 1585 1 1575 1542 1578 1559 2 OAI22S $T=540640 537720 1 180 $X=536920 $Y=537340
X1769 1585 1 322 1587 1589 1552 2 OAI22S $T=540640 527640 0 0 $X=540640 $Y=527260
X1770 1613 1 1614 1613 1611 1598 2 OAI22S $T=557380 578040 1 180 $X=553660 $Y=577660
X1771 374 1 1615 374 1612 1608 2 OAI22S $T=557380 638520 1 180 $X=553660 $Y=638140
X1772 1626 1 1627 1626 1625 1622 2 OAI22S $T=562340 578040 0 180 $X=558620 $Y=572620
X1773 1639 1 1637 1639 1640 1630 2 OAI22S $T=566060 618360 0 180 $X=562340 $Y=612940
X1774 1665 1 1659 1665 1670 1655 2 OAI22S $T=574740 588120 0 180 $X=571020 $Y=582700
X1775 1669 1 322 1652 1675 1644 2 OAI22S $T=571640 517560 0 0 $X=571640 $Y=517180
X1776 403 1 395 399 1700 1683 2 OAI22S $T=583420 507480 1 180 $X=579700 $Y=507100
X1777 1701 1 1647 1701 1710 1721 2 OAI22S $T=580320 537720 1 0 $X=580320 $Y=532300
X1778 411 1 1602 411 1755 1742 2 OAI22S $T=598920 638520 1 180 $X=595200 $Y=638140
X1779 1879 1 1909 1879 1916 1904 2 OAI22S $T=652240 578040 0 180 $X=648520 $Y=572620
X1780 1939 1 1940 1939 1937 1929 2 OAI22S $T=657820 588120 0 180 $X=654100 $Y=582700
X1781 1968 1 1970 1968 1957 1948 2 OAI22S $T=669600 628440 0 180 $X=665880 $Y=623020
X1782 2437 1 2405 2442 2443 2337 2 OAI22S $T=864280 588120 0 180 $X=860560 $Y=582700
X1783 2444 1 2474 2431 2478 2480 2 OAI22S $T=869240 567960 0 0 $X=869240 $Y=567580
X1784 654 1 2477 2476 2479 657 2 OAI22S $T=869240 638520 1 0 $X=869240 $Y=633100
X1785 660 1 2474 2419 2490 2492 2 OAI22S $T=871720 608280 1 0 $X=871720 $Y=602860
X1786 2477 1 662 2454 2508 2531 2 OAI22S $T=876060 638520 1 0 $X=876060 $Y=633100
X1787 2549 1 2432 682 2635 687 2 OAI22S $T=906440 628440 1 0 $X=906440 $Y=623020
X1788 691 1 696 2687 2710 701 2 OAI22S $T=926280 638520 1 0 $X=926280 $Y=633100
X1789 354 346 350 1568 1 2 339 AO13S $T=540640 638520 1 180 $X=536300 $Y=638140
X1790 1186 1155 1197 1001 1 142 2 AOI22S $T=394320 527640 0 180 $X=390600 $Y=522220
X1791 173 142 1293 167 1 1208 2 AOI22S $T=422220 527640 0 180 $X=418500 $Y=522220
X1792 173 138 1253 167 1 142 2 AOI22S $T=422840 517560 0 180 $X=419120 $Y=512140
X1793 167 128 1254 171 1 1208 2 AOI22S $T=425320 527640 1 180 $X=421600 $Y=527260
X1794 173 1188 1257 178 1 1220 2 AOI22S $T=430280 537720 0 180 $X=426560 $Y=532300
X1795 1269 1262 1267 1261 1 179 2 AOI22S $T=431520 557880 0 180 $X=427800 $Y=552460
X1796 167 1188 1266 171 1 1220 2 AOI22S $T=432140 527640 1 180 $X=428420 $Y=527260
X1797 1269 1262 1279 168 1 1188 2 AOI22S $T=433380 547800 1 180 $X=429660 $Y=547420
X1798 1269 1262 1278 1188 1 128 2 AOI22S $T=434000 537720 1 180 $X=430280 $Y=537340
X1799 173 168 1291 178 1 128 2 AOI22S $T=437100 537720 0 180 $X=433380 $Y=532300
X1800 1220 1289 1283 1294 1 178 2 AOI22S $T=436480 517560 0 0 $X=436480 $Y=517180
X1801 1304 1295 1298 1284 1 179 2 AOI22S $T=440200 547800 1 180 $X=436480 $Y=547420
X1802 1300 1295 1274 190 1 149 2 AOI22S $T=440200 557880 0 180 $X=436480 $Y=552460
X1803 1304 1295 1297 168 1 1284 2 AOI22S $T=444540 537720 1 180 $X=440820 $Y=537340
X1804 1307 1262 1336 190 1 1261 2 AOI22S $T=448880 547800 1 180 $X=445160 $Y=547420
X1805 1319 1332 1335 1328 1 1294 2 AOI22S $T=451360 588120 0 180 $X=447640 $Y=582700
X1806 1300 1295 1331 149 1 1342 2 AOI22S $T=448880 557880 0 0 $X=448880 $Y=557500
X1807 1347 1323 1316 1328 1 1332 2 AOI22S $T=452600 598200 0 180 $X=448880 $Y=592780
X1808 1307 1333 1346 1248 1 1330 2 AOI22S $T=455700 547800 0 180 $X=451980 $Y=542380
X1809 1304 1295 1349 1344 1 1356 2 AOI22S $T=454460 537720 0 0 $X=454460 $Y=537340
X1810 1288 1354 1353 1328 1 1347 2 AOI22S $T=458180 588120 1 180 $X=454460 $Y=587740
X1811 1347 1359 1275 1369 1 1354 2 AOI22S $T=456940 598200 0 0 $X=456940 $Y=597820
X1812 1307 1333 1372 1344 1 1248 2 AOI22S $T=461280 547800 0 180 $X=457560 $Y=542380
X1813 1304 1295 1364 1356 1 212 2 AOI22S $T=460660 537720 0 0 $X=460660 $Y=537340
X1814 1319 1368 1325 1373 1 1382 2 AOI22S $T=460660 588120 0 0 $X=460660 $Y=587740
X1815 1288 1375 1281 1373 1 1382 2 AOI22S $T=461900 578040 0 0 $X=461900 $Y=577660
X1816 1367 213 1396 1310 1 1294 2 AOI22S $T=471200 557880 0 180 $X=467480 $Y=552460
X1817 1285 213 1404 1289 1 1294 2 AOI22S $T=473060 567960 1 0 $X=473060 $Y=562540
X1818 1307 1333 1405 1415 1 1406 2 AOI22S $T=474300 547800 1 0 $X=474300 $Y=542380
X1819 1307 225 1427 1446 1 1415 2 AOI22S $T=480500 557880 1 0 $X=480500 $Y=552460
X1820 1435 1419 1407 1369 1 1373 2 AOI22S $T=484220 588120 0 180 $X=480500 $Y=582700
X1821 1429 1383 1397 1446 1 1433 2 AOI22S $T=482360 547800 1 0 $X=482360 $Y=542380
X1822 1429 1383 1425 1433 1 1428 2 AOI22S $T=483600 567960 1 0 $X=483600 $Y=562540
X1823 1389 1442 1443 1392 1 1420 2 AOI22S $T=486080 588120 1 0 $X=486080 $Y=582700
X1824 1389 1442 1400 263 1 1369 2 AOI22S $T=486700 578040 0 0 $X=486700 $Y=577660
X1825 1467 1442 1447 1369 1 1373 2 AOI22S $T=491660 598200 0 180 $X=487940 $Y=592780
X1826 1435 1419 1455 1420 1 1392 2 AOI22S $T=493520 588120 1 0 $X=493520 $Y=582700
X1827 263 275 1458 277 1 298 2 AOI22S $T=502820 507480 1 0 $X=502820 $Y=502060
X1828 272 276 1479 1474 1 1420 2 AOI22S $T=502820 588120 1 0 $X=502820 $Y=582700
X1829 272 276 1483 277 1 267 2 AOI22S $T=503440 517560 1 0 $X=503440 $Y=512140
X1830 1388 283 1482 1484 1 1468 2 AOI22S $T=504680 567960 1 0 $X=504680 $Y=562540
X1831 225 1383 1499 1492 1 1489 2 AOI22S $T=510880 557880 0 180 $X=507160 $Y=552460
X1832 1475 300 315 217 1 228 2 AOI22S $T=514600 507480 0 180 $X=510880 $Y=502060
X1833 1511 302 1498 299 1 296 2 AOI22S $T=514600 507480 1 180 $X=510880 $Y=507100
X1834 1511 1383 1500 1494 1 299 2 AOI22S $T=515840 537720 1 180 $X=512120 $Y=537340
X1835 1484 1509 1496 1475 1 1546 2 AOI22S $T=513360 557880 1 0 $X=513360 $Y=552460
X1836 1530 1501 1517 1373 1 273 2 AOI22S $T=518940 598200 0 180 $X=515220 $Y=592780
X1837 1508 1521 1528 1373 1 305 2 AOI22S $T=519560 578040 1 180 $X=515840 $Y=577660
X1838 321 300 310 307 1 1489 2 AOI22S $T=520180 507480 1 180 $X=516460 $Y=507100
X1839 1511 225 1516 1492 1 1489 2 AOI22S $T=520180 547800 0 0 $X=520180 $Y=547420
X1840 1474 1501 1533 1530 1 273 2 AOI22S $T=524520 588120 0 180 $X=520800 $Y=582700
X1841 1429 1383 1523 1532 1 1539 2 AOI22S $T=522660 557880 0 0 $X=522660 $Y=557500
X1842 1542 211 324 300 1 321 2 AOI22S $T=527000 507480 0 180 $X=523280 $Y=502060
X1843 1545 283 340 349 1 1581 2 AOI22S $T=536300 517560 1 0 $X=536300 $Y=512140
X1844 346 235 1568 1586 1 1584 2 AOI22S $T=536920 628440 1 0 $X=536920 $Y=623020
X1845 362 285 1558 349 1 344 2 AOI22S $T=541880 507480 1 180 $X=538160 $Y=507100
X1846 1573 283 1588 1532 1 1468 2 AOI22S $T=543120 567960 0 180 $X=539400 $Y=562540
X1847 1511 348 1570 358 1 1621 2 AOI22S $T=546840 517560 1 0 $X=546840 $Y=512140
X1848 349 370 369 372 1 373 2 AOI22S $T=551800 507480 1 0 $X=551800 $Y=502060
X1849 1532 1509 1616 1539 1 1546 2 AOI22S $T=556140 557880 0 180 $X=552420 $Y=552460
X1850 349 1509 1607 344 1 1546 2 AOI22S $T=553040 507480 0 0 $X=553040 $Y=507100
X1851 370 1509 1632 379 1 1546 2 AOI22S $T=562340 527640 0 180 $X=558620 $Y=522220
X1852 211 1509 381 217 1 1546 2 AOI22S $T=562960 507480 1 180 $X=559240 $Y=507100
X1853 459 455 1895 1868 1 451 2 AOI22S $T=640460 517560 0 180 $X=636740 $Y=512140
X1854 455 459 1894 458 1 451 2 AOI22S $T=641700 507480 1 180 $X=637980 $Y=507100
X1855 2315 2307 2323 2304 1 2262 2 AOI22S $T=819020 628440 0 180 $X=815300 $Y=623020
X1856 2315 2307 2317 2262 1 2261 2 AOI22S $T=819640 618360 0 180 $X=815920 $Y=612940
X1857 2315 2307 2330 2316 1 2304 2 AOI22S $T=827080 618360 1 180 $X=823360 $Y=617980
X1858 2315 2307 2331 2320 1 2316 2 AOI22S $T=827700 628440 1 180 $X=823980 $Y=628060
X1859 2325 2319 2364 2261 1 2245 2 AOI22S $T=828320 618360 0 180 $X=824600 $Y=612940
X1860 2315 619 2334 617 1 2320 2 AOI22S $T=828320 638520 0 180 $X=824600 $Y=633100
X1861 2336 2322 2338 2296 1 2321 2 AOI22S $T=828940 557880 1 180 $X=825220 $Y=557500
X1862 2336 2333 2342 2327 1 2296 2 AOI22S $T=830800 547800 1 180 $X=827080 $Y=547420
X1863 2312 2319 2326 2280 1 2325 2 AOI22S $T=827080 608280 1 0 $X=827080 $Y=602860
X1864 2325 2322 2337 2335 1 2328 2 AOI22S $T=832040 578040 1 180 $X=828320 $Y=577660
X1865 2351 2333 2345 2340 1 2293 2 AOI22S $T=833900 537720 1 180 $X=830180 $Y=537340
X1866 2325 2319 2348 2245 1 2280 2 AOI22S $T=833900 618360 1 180 $X=830180 $Y=617980
X1867 2336 2322 2355 2321 1 2341 2 AOI22S $T=834520 567960 0 180 $X=830800 $Y=562540
X1868 2325 2322 2346 2341 1 2335 2 AOI22S $T=834520 567960 1 180 $X=830800 $Y=567580
X1869 2336 2333 2354 2293 1 2308 2 AOI22S $T=836380 547800 0 180 $X=832660 $Y=542380
X1870 2336 2333 2382 2308 1 2327 2 AOI22S $T=837620 557880 0 180 $X=833900 $Y=552460
X1871 2360 2323 633 2350 1 2331 2 AOI22S $T=837620 628440 0 180 $X=833900 $Y=623020
X1872 2360 2331 2362 2350 1 625 2 AOI22S $T=838240 638520 0 180 $X=834520 $Y=633100
X1873 2351 2358 2366 2357 1 2352 2 AOI22S $T=839480 537720 0 180 $X=835760 $Y=532300
X1874 2370 2342 2365 2359 1 2354 2 AOI22S $T=840100 557880 1 180 $X=836380 $Y=557500
X1875 2351 2358 2378 2361 1 2357 2 AOI22S $T=840720 527640 1 180 $X=837000 $Y=527260
X1876 2351 2333 2368 2352 1 2340 2 AOI22S $T=840720 537720 1 180 $X=837000 $Y=537340
X1877 2370 2355 2379 2359 1 2342 2 AOI22S $T=840720 567960 1 180 $X=837000 $Y=567580
X1878 623 619 625 635 1 617 2 AOI22S $T=840720 638520 1 180 $X=837000 $Y=638140
X1879 2374 2364 2372 2363 1 2323 2 AOI22S $T=841340 608280 1 180 $X=837620 $Y=607900
X1880 2370 2346 2384 2359 1 2338 2 AOI22S $T=841960 578040 0 180 $X=838240 $Y=572620
X1881 2374 2348 2373 2363 1 2317 2 AOI22S $T=843200 618360 1 180 $X=839480 $Y=617980
X1882 2375 2354 2395 2369 1 2368 2 AOI22S $T=843820 547800 1 180 $X=840100 $Y=547420
X1883 2380 2326 2385 2363 1 2364 2 AOI22S $T=843820 608280 0 180 $X=840100 $Y=602860
X1884 2359 2370 2399 2382 1 2338 2 AOI22S $T=846300 567960 0 180 $X=842580 $Y=562540
X1885 2375 2368 2381 2369 1 2378 2 AOI22S $T=843200 547800 1 0 $X=843200 $Y=542380
X1886 2359 2370 2402 2355 1 2337 2 AOI22S $T=846920 567960 1 180 $X=843200 $Y=567580
X1887 638 2317 2414 2363 1 2330 2 AOI22S $T=846920 628440 1 180 $X=843200 $Y=628060
X1888 2377 2358 2398 2383 1 2386 2 AOI22S $T=847540 517560 1 180 $X=843820 $Y=517180
X1889 2392 2358 2400 2386 1 2361 2 AOI22S $T=847540 527640 1 180 $X=843820 $Y=527260
X1890 638 2330 2376 640 1 2334 2 AOI22S $T=843820 638520 1 0 $X=843820 $Y=633100
X1891 2363 638 2387 2348 1 2329 2 AOI22S $T=845060 618360 1 0 $X=845060 $Y=612940
X1892 642 2334 2445 640 1 641 2 AOI22S $T=850020 638520 1 180 $X=846300 $Y=638140
X1893 2388 2382 2408 2369 1 2345 2 AOI22S $T=851260 547800 1 180 $X=847540 $Y=547420
X1894 2367 2380 2415 2346 1 2389 2 AOI22S $T=851880 578040 1 180 $X=848160 $Y=577660
X1895 2377 2358 2403 652 1 2383 2 AOI22S $T=850020 517560 0 0 $X=850020 $Y=517180
X1896 2388 2366 2420 2369 1 2400 2 AOI22S $T=853740 537720 1 180 $X=850020 $Y=537340
X1897 2388 2345 2411 2369 1 2366 2 AOI22S $T=853740 547800 0 180 $X=850020 $Y=542380
X1898 2418 2365 2413 2404 1 2381 2 AOI22S $T=853740 557880 1 180 $X=850020 $Y=557500
X1899 2404 2410 2424 2365 1 2402 2 AOI22S $T=853740 567960 0 180 $X=850020 $Y=562540
X1900 2380 2347 2419 2389 1 2326 2 AOI22S $T=853740 608280 0 180 $X=850020 $Y=602860
X1901 2401 2412 2470 2406 1 2373 2 AOI22S $T=854360 618360 1 180 $X=850640 $Y=617980
X1902 2418 2411 2423 2404 1 2425 2 AOI22S $T=853740 547800 0 0 $X=853740 $Y=547420
X1903 2407 2373 2432 2412 1 2376 2 AOI22S $T=857460 628440 0 180 $X=853740 $Y=623020
X1904 2401 2404 2436 2394 1 2379 2 AOI22S $T=858080 578040 1 180 $X=854360 $Y=577660
X1905 2410 2379 2437 2421 1 2395 2 AOI22S $T=858080 588120 0 180 $X=854360 $Y=582700
X1906 650 2362 2441 649 1 648 2 AOI22S $T=858080 628440 1 180 $X=854360 $Y=628060
X1907 2392 2422 2434 2427 1 652 2 AOI22S $T=859940 517560 1 180 $X=856220 $Y=517180
X1908 2435 2400 2425 2430 1 2403 2 AOI22S $T=860560 527640 0 180 $X=856840 $Y=522220
X1909 2407 2372 2449 2412 1 2362 2 AOI22S $T=861180 618360 0 180 $X=857460 $Y=612940
X1910 2421 2407 2438 633 1 2385 2 AOI22S $T=861800 608280 1 180 $X=858080 $Y=607900
X1911 2446 2428 2453 2411 1 2399 2 AOI22S $T=863040 557880 1 180 $X=859320 $Y=557500
X1912 2439 2398 2444 2429 1 2434 2 AOI22S $T=864280 537720 1 180 $X=860560 $Y=537340
X1913 2439 2378 2457 2429 1 2398 2 AOI22S $T=864280 547800 0 180 $X=860560 $Y=542380
X1914 2428 2381 2466 2404 1 2444 2 AOI22S $T=864900 567960 1 180 $X=861180 $Y=567580
X1915 643 2414 2461 2412 1 2445 2 AOI22S $T=864900 628440 1 180 $X=861180 $Y=628060
X1916 2407 653 2448 2387 1 2414 2 AOI22S $T=861800 628440 1 0 $X=861800 $Y=623020
X1917 2435 2403 2450 2430 1 2455 2 AOI22S $T=862420 527640 0 0 $X=862420 $Y=527260
X1918 643 2445 2463 653 1 654 2 AOI22S $T=866140 638520 0 180 $X=862420 $Y=633100
X1919 2392 2422 2455 655 1 2427 2 AOI22S $T=866760 517560 1 180 $X=863040 $Y=517180
X1920 2428 2408 2465 2446 1 2420 2 AOI22S $T=866760 547800 1 180 $X=863040 $Y=547420
X1921 2410 2384 2516 2421 1 2408 2 AOI22S $T=867380 578040 0 180 $X=863660 $Y=572620
X1922 2392 2422 2469 2460 1 655 2 AOI22S $T=870480 527640 0 180 $X=866760 $Y=522220
X1923 2439 2434 2462 2429 1 2469 2 AOI22S $T=866760 537720 0 0 $X=866760 $Y=537340
X1924 2482 2420 2483 2446 1 2450 2 AOI22S $T=871100 547800 0 180 $X=867380 $Y=542380
X1925 2435 2455 2489 2430 1 2473 2 AOI22S $T=872960 537720 0 180 $X=869240 $Y=532300
X1926 2482 2457 2481 2446 1 2462 2 AOI22S $T=873580 547800 1 180 $X=869860 $Y=547420
X1927 2435 2469 2487 2429 1 2496 2 AOI22S $T=872960 537720 0 0 $X=872960 $Y=537340
X1928 2494 2422 2496 2493 1 2488 2 AOI22S $T=877300 517560 1 180 $X=873580 $Y=517180
X1929 2494 2422 2473 2488 1 2460 2 AOI22S $T=877300 527640 0 180 $X=873580 $Y=522220
X1930 2529 2425 2499 2446 1 2489 2 AOI22S $T=877300 547800 0 180 $X=873580 $Y=542380
X1931 2435 2473 2491 2429 1 2540 2 AOI22S $T=875440 527640 0 0 $X=875440 $Y=527260
X1932 2497 2504 2500 2505 1 2484 2 AOI22S $T=875440 578040 0 0 $X=875440 $Y=577660
X1933 663 2485 2525 2467 1 2509 2 AOI22S $T=881020 618360 0 180 $X=877300 $Y=612940
X1934 2494 2527 2540 2520 1 2493 2 AOI22S $T=884120 517560 1 180 $X=880400 $Y=517180
X1935 2509 2511 2524 665 1 666 2 AOI22S $T=881020 638520 0 0 $X=881020 $Y=638140
X1936 2491 2529 2526 2554 1 2541 2 AOI22S $T=881640 537720 0 0 $X=881640 $Y=537340
X1937 2600 2471 2530 2452 1 2504 2 AOI22S $T=885360 557880 1 180 $X=881640 $Y=557500
X1938 2533 2496 2536 2521 1 2543 2 AOI22S $T=882880 537720 1 0 $X=882880 $Y=532300
X1939 2494 2527 2543 2532 1 2520 2 AOI22S $T=887840 527640 0 180 $X=884120 $Y=522220
X1940 2494 2527 2556 670 1 2532 2 AOI22S $T=890940 517560 1 180 $X=887220 $Y=517180
X1941 2521 2533 2548 2556 1 2540 2 AOI22S $T=890940 527640 1 180 $X=887220 $Y=527260
X1942 2551 2554 2505 2541 1 2564 2 AOI22S $T=887840 547800 1 0 $X=887840 $Y=542380
X1943 2504 2468 2555 2466 1 2565 2 AOI22S $T=888460 567960 0 0 $X=888460 $Y=567580
X1944 2509 2563 2560 671 1 674 2 AOI22S $T=888460 608280 0 0 $X=888460 $Y=607900
X1945 2533 2556 2554 2521 1 2581 2 AOI22S $T=889080 537720 1 0 $X=889080 $Y=532300
X1946 2482 2536 2559 2541 1 2569 2 AOI22S $T=889080 547800 0 0 $X=889080 $Y=547420
X1947 2533 2543 2579 2521 1 2586 2 AOI22S $T=893420 527640 0 0 $X=893420 $Y=527260
X1948 2578 2527 2586 678 1 670 2 AOI22S $T=897760 517560 1 180 $X=894040 $Y=517180
X1949 2482 2487 2565 2541 1 2579 2 AOI22S $T=894040 547800 1 0 $X=894040 $Y=542380
X1950 2533 2586 2569 2595 1 2601 2 AOI22S $T=897140 527640 1 0 $X=897140 $Y=522220
X1951 2598 2569 2512 2541 1 2615 2 AOI22S $T=899000 557880 1 0 $X=899000 $Y=552460
X1952 2578 2612 2581 2609 1 678 2 AOI22S $T=904580 517560 1 180 $X=900860 $Y=517180
X1953 2616 2551 2607 2610 1 2548 2 AOI22S $T=904580 547800 0 180 $X=900860 $Y=542380
X1954 2631 2581 2610 2595 1 2613 2 AOI22S $T=906440 537720 0 180 $X=902720 $Y=532300
X1955 2551 2610 2600 2616 1 2627 2 AOI22S $T=905200 557880 1 0 $X=905200 $Y=552460
X1956 2578 2612 2601 2632 1 2609 2 AOI22S $T=911400 517560 1 180 $X=907680 $Y=517180
X1957 2579 2636 2639 2551 1 2616 2 AOI22S $T=911400 547800 0 180 $X=907680 $Y=542380
X1958 2631 2613 2564 2595 1 2645 2 AOI22S $T=909540 537720 1 0 $X=909540 $Y=532300
X1959 2598 2636 2665 2616 1 2658 2 AOI22S $T=917600 547800 0 180 $X=913880 $Y=542380
X1960 2578 2654 2613 699 1 2632 2 AOI22S $T=914500 517560 0 0 $X=914500 $Y=517180
X1961 2631 2601 2636 2595 1 2682 2 AOI22S $T=915120 527640 1 0 $X=915120 $Y=522220
X1962 2631 2667 2658 2595 1 2680 2 AOI22S $T=915120 537720 0 0 $X=915120 $Y=537340
X1963 2631 2682 2615 2679 1 2667 2 AOI22S $T=921320 527640 0 0 $X=921320 $Y=527260
X1964 2578 2654 2682 2714 1 699 2 AOI22S $T=921940 527640 1 0 $X=921940 $Y=522220
X1965 2631 2645 2627 2679 1 2705 2 AOI22S $T=921940 537720 1 0 $X=921940 $Y=532300
X1966 2702 2654 2645 2711 1 2714 2 AOI22S $T=927520 527640 0 0 $X=927520 $Y=527260
X1967 2702 2654 2667 2736 1 2711 2 AOI22S $T=934340 527640 0 0 $X=934340 $Y=527260
X1968 2702 2654 2680 2732 1 2758 2 AOI22S $T=935580 537720 1 0 $X=935580 $Y=532300
X1969 2702 2654 2705 2758 1 2736 2 AOI22S $T=940540 527640 0 0 $X=940540 $Y=527260
X1970 200 254 1 2 BUF2 $T=491660 618360 1 0 $X=491660 $Y=612940
X1971 447 446 1 2 BUF2 $T=633640 507480 0 180 $X=630540 $Y=502060
X1972 840 20 1 2 INV2 $T=257920 517560 1 180 $X=256060 $Y=517180
X1973 858 37 1 2 INV2 $T=267840 588120 1 0 $X=267840 $Y=582700
X1974 949 59 1 2 INV2 $T=306280 527640 0 0 $X=306280 $Y=527260
X1975 1025 94 1 2 INV2 $T=331080 527640 1 180 $X=329220 $Y=527260
X1976 102 1029 1 2 INV2 $T=337900 608280 0 180 $X=336040 $Y=602860
X1977 1008 103 1 2 INV2 $T=337900 588120 0 0 $X=337900 $Y=587740
X1978 1294 1379 1 2 INV2 $T=465000 588120 1 0 $X=465000 $Y=582700
X1979 1379 1392 1 2 INV2 $T=467480 578040 0 0 $X=467480 $Y=577660
X1980 1318 223 1 2 INV2 $T=468100 618360 1 0 $X=468100 $Y=612940
X1981 213 1393 1 2 INV2 $T=473060 567960 1 180 $X=471200 $Y=567580
X1982 1393 1420 1 2 INV2 $T=474300 588120 1 0 $X=474300 $Y=582700
X1983 1411 248 1 2 INV2 $T=489180 608280 0 0 $X=489180 $Y=607900
X1984 254 234 1 2 INV2 $T=494140 628440 0 180 $X=492280 $Y=623020
X1985 230 1429 1 2 INV2 $T=492900 547800 1 0 $X=492900 $Y=542380
X1986 1462 258 1 2 INV2 $T=496620 608280 0 180 $X=494760 $Y=602860
X1987 1473 1294 1 2 INV2 $T=497240 517560 0 180 $X=495380 $Y=512140
X1988 1474 1398 1 2 INV2 $T=500960 598200 1 0 $X=500960 $Y=592780
X1989 1508 1417 1 2 INV2 $T=511500 598200 1 180 $X=509640 $Y=597820
X1990 1564 1460 1 2 INV2 $T=531960 578040 1 180 $X=530100 $Y=577660
X1991 338 348 1 2 INV2 $T=535680 507480 0 0 $X=535680 $Y=507100
X1992 341 1378 1 2 INV2 $T=535680 547800 1 0 $X=535680 $Y=542380
X1993 341 1581 1 2 INV2 $T=537540 547800 1 0 $X=537540 $Y=542380
X1994 331 1564 1 2 INV2 $T=544980 527640 1 0 $X=544980 $Y=522220
X1995 274 1726 1 2 INV2 $T=585900 608280 1 0 $X=585900 $Y=602860
X1996 407 335 1 2 INV2 $T=590860 507480 1 0 $X=590860 $Y=502060
X1997 1592 421 1 2 INV2 $T=604500 628440 1 0 $X=604500 $Y=623020
X1998 1618 436 1 2 INV2 $T=620620 608280 0 0 $X=620620 $Y=607900
X1999 1507 450 1 2 INV2 $T=625580 578040 0 0 $X=625580 $Y=577660
X2000 1623 1935 1 2 INV2 $T=649140 598200 1 0 $X=649140 $Y=592780
X2001 505 506 1 2 INV2 $T=705560 588120 1 0 $X=705560 $Y=582700
X2002 426 511 1 2 INV2 $T=719820 608280 0 0 $X=719820 $Y=607900
X2003 2122 2173 1 2 INV2 $T=755780 527640 0 0 $X=755780 $Y=527260
X2004 2786 2789 1 2 INV2 $T=951080 618360 1 180 $X=949220 $Y=617980
X2005 2701 2820 1 2 INV2 $T=965960 598200 1 180 $X=964100 $Y=597820
X2006 2722 2825 1 2 INV2 $T=969060 598200 0 0 $X=969060 $Y=597820
X2007 24 838 1 24 27 852 2 MOAI1S $T=256680 517560 1 0 $X=256680 $Y=512140
X2008 39 38 1 39 38 32 2 MOAI1S $T=273420 507480 0 180 $X=269700 $Y=502060
X2009 927 924 1 927 924 919 2 MOAI1S $T=296980 537720 0 180 $X=293260 $Y=532300
X2010 978 977 1 978 977 1014 2 MOAI1S $T=311240 557880 0 0 $X=311240 $Y=557500
X2011 965 975 1 993 964 1004 2 MOAI1S $T=316200 557880 1 0 $X=316200 $Y=552460
X2012 1014 1006 1 1014 1006 1031 2 MOAI1S $T=326120 557880 0 0 $X=326120 $Y=557500
X2013 1010 1018 1 1010 1018 1047 2 MOAI1S $T=328600 547800 1 0 $X=328600 $Y=542380
X2014 958 985 1 1019 1001 1050 2 MOAI1S $T=332940 537720 0 0 $X=332940 $Y=537340
X2015 1045 1042 1 1045 1042 1052 2 MOAI1S $T=335420 537720 1 0 $X=335420 $Y=532300
X2016 1083 1003 1 1083 1003 1093 2 MOAI1S $T=352160 527640 1 0 $X=352160 $Y=522220
X2017 1085 1087 1 1098 1081 1092 2 MOAI1S $T=355880 567960 1 0 $X=355880 $Y=562540
X2018 1096 1078 1 1099 1109 1119 2 MOAI1S $T=358360 588120 0 0 $X=358360 $Y=587740
X2019 118 100 1 118 100 121 2 MOAI1S $T=363320 507480 0 0 $X=363320 $Y=507100
X2020 1115 1088 1 1114 1110 1117 2 MOAI1S $T=368280 547800 0 180 $X=364560 $Y=542380
X2021 1120 1085 1 1124 1128 1134 2 MOAI1S $T=367040 567960 1 0 $X=367040 $Y=562540
X2022 112 124 1 112 124 126 2 MOAI1S $T=369520 507480 1 0 $X=369520 $Y=502060
X2023 1133 128 1 1137 1140 1138 2 MOAI1S $T=373240 527640 1 0 $X=373240 $Y=522220
X2024 1120 1096 1 1135 1128 1151 2 MOAI1S $T=375720 588120 1 0 $X=375720 $Y=582700
X2025 1120 1150 1 1139 1128 1143 2 MOAI1S $T=380680 578040 0 180 $X=376960 $Y=572620
X2026 1133 1146 1 1141 1140 1164 2 MOAI1S $T=378820 537720 1 0 $X=378820 $Y=532300
X2027 1133 1147 1 1142 1128 1160 2 MOAI1S $T=379440 547800 0 0 $X=379440 $Y=547420
X2028 1093 1166 1 1093 1166 1178 2 MOAI1S $T=383160 527640 0 0 $X=383160 $Y=527260
X2029 1133 142 1 134 1194 1200 2 MOAI1S $T=390600 507480 0 0 $X=390600 $Y=507100
X2030 1181 1180 1 1189 1128 1176 2 MOAI1S $T=394320 547800 1 180 $X=390600 $Y=547420
X2031 1168 1037 1 1195 1167 1207 2 MOAI1S $T=391840 578040 1 0 $X=391840 $Y=572620
X2032 1133 1149 1 1192 1140 1198 2 MOAI1S $T=399280 527640 0 180 $X=395560 $Y=522220
X2033 1120 1153 1 1187 1128 1193 2 MOAI1S $T=401140 588120 1 180 $X=397420 $Y=587740
X2034 1212 954 1 1206 1204 1201 2 MOAI1S $T=401760 547800 1 180 $X=398040 $Y=547420
X2035 1181 149 1 1199 1209 1210 2 MOAI1S $T=398660 567960 1 0 $X=398660 $Y=562540
X2036 1229 160 1 1231 145 1230 2 MOAI1S $T=412920 537720 1 180 $X=409200 $Y=537340
X2037 1229 1208 1 1214 145 1223 2 MOAI1S $T=413540 517560 1 180 $X=409820 $Y=517180
X2038 1181 1211 1 1233 1209 1244 2 MOAI1S $T=409820 567960 0 0 $X=409820 $Y=567580
X2039 1181 1212 1 1234 1209 1241 2 MOAI1S $T=410440 567960 1 0 $X=410440 $Y=562540
X2040 1229 1326 1 1322 174 1311 2 MOAI1S $T=449500 527640 1 180 $X=445780 $Y=527260
X2041 1360 1355 1 1351 1348 1334 2 MOAI1S $T=458180 527640 0 180 $X=454460 $Y=522220
X2042 1304 1248 1 1203 1272 1384 2 MOAI1S $T=459420 547800 0 0 $X=459420 $Y=547420
X2043 1360 1365 1 1371 1377 1380 2 MOAI1S $T=460660 527640 1 0 $X=460660 $Y=522220
X2044 1369 1375 1 1350 1398 1402 2 MOAI1S $T=468100 598200 1 0 $X=468100 $Y=592780
X2045 1414 1229 1 1401 174 1386 2 MOAI1S $T=475540 517560 1 180 $X=471820 $Y=517180
X2046 1369 1368 1 1340 1398 1422 2 MOAI1S $T=475540 588120 0 0 $X=475540 $Y=587740
X2047 1229 1428 1 1424 199 1412 2 MOAI1S $T=482360 527640 1 180 $X=478640 $Y=527260
X2048 225 212 1 1378 1355 1452 2 MOAI1S $T=489180 537720 0 0 $X=489180 $Y=537340
X2049 1433 1229 1 1454 199 1466 2 MOAI1S $T=490420 537720 1 0 $X=490420 $Y=532300
X2050 309 1520 1 309 1520 1534 2 MOAI1S $T=519560 517560 0 0 $X=519560 $Y=517180
X2051 1531 1529 1 1531 1529 1536 2 MOAI1S $T=522040 537720 1 0 $X=522040 $Y=532300
X2052 1542 1572 1 1542 1572 1587 2 MOAI1S $T=534440 537720 1 0 $X=534440 $Y=532300
X2053 1606 359 1 1600 1552 1628 2 MOAI1S $T=556140 547800 1 0 $X=556140 $Y=542380
X2054 1617 1619 1 1617 1619 1634 2 MOAI1S $T=558000 628440 1 0 $X=558000 $Y=623020
X2055 359 1633 1 1641 1644 1649 2 MOAI1S $T=562340 537720 0 0 $X=562340 $Y=537340
X2056 1645 359 1 1638 1644 1662 2 MOAI1S $T=565440 517560 0 0 $X=565440 $Y=517180
X2057 1825 1805 1 1825 1805 1835 2 MOAI1S $T=619380 547800 0 0 $X=619380 $Y=547420
X2058 442 1583 1 442 1583 1868 2 MOAI1S $T=628680 507480 0 0 $X=628680 $Y=507100
X2059 1870 1880 1 1870 1880 1890 2 MOAI1S $T=635500 557880 0 0 $X=635500 $Y=557500
X2060 454 457 1 454 457 1898 2 MOAI1S $T=637980 638520 0 0 $X=637980 $Y=638140
X2061 1896 1893 1 1896 1893 1891 2 MOAI1S $T=644800 628440 1 180 $X=641080 $Y=628060
X2062 1888 1883 1 1888 1883 1911 2 MOAI1S $T=641700 567960 0 0 $X=641700 $Y=567580
X2063 1885 1907 1 1885 1907 1920 2 MOAI1S $T=646660 618360 1 0 $X=646660 $Y=612940
X2064 1879 1911 1 1879 1911 1892 2 MOAI1S $T=652240 567960 1 180 $X=648520 $Y=567580
X2065 484 485 1 484 485 487 2 MOAI1S $T=673940 638520 0 0 $X=673940 $Y=638140
X2066 2020 2101 1 2020 2101 2111 2 MOAI1S $T=730360 547800 0 0 $X=730360 $Y=547420
X2067 2416 2395 1 2337 2397 2394 2 MOAI1S $T=851880 588120 0 180 $X=848160 $Y=582700
X2068 2401 2402 1 2405 2413 2431 2 MOAI1S $T=850020 578040 1 0 $X=850020 $Y=572620
X2069 651 2376 1 2329 2397 2406 2 MOAI1S $T=854980 608280 1 180 $X=851260 $Y=607900
X2070 2416 2423 1 2433 2399 2452 2 MOAI1S $T=856840 567960 1 0 $X=856840 $Y=562540
X2071 2407 2385 1 2347 2447 2454 2 MOAI1S $T=859940 608280 1 0 $X=859940 $Y=602860
X2072 651 2441 1 2433 2372 2467 2 MOAI1S $T=864280 618360 1 0 $X=864280 $Y=612940
X2073 2401 2387 1 2472 2461 2476 2 MOAI1S $T=868000 628440 0 0 $X=868000 $Y=628060
X2074 2504 2512 1 2474 2462 2495 2 MOAI1S $T=880400 547800 1 180 $X=876680 $Y=547420
X2075 2552 2559 1 2480 2443 2546 2 MOAI1S $T=889700 588120 0 180 $X=885980 $Y=582700
X2076 2509 672 1 2477 669 2550 2 MOAI1S $T=890940 638520 1 180 $X=887220 $Y=638140
X2077 2522 2419 1 682 684 2618 2 MOAI1S $T=897140 608280 1 0 $X=897140 $Y=602860
X2078 2522 2415 1 2603 2607 2605 2 MOAI1S $T=899000 567960 1 0 $X=899000 $Y=562540
X2079 2564 2616 1 2616 2638 2651 2 MOAI1S $T=907680 537720 0 0 $X=907680 $Y=537340
X2080 2705 2679 1 2679 2717 2638 2 MOAI1S $T=928760 537720 1 0 $X=928760 $Y=532300
X2081 2720 2707 1 2737 2741 2746 2 MOAI1S $T=934960 588120 0 0 $X=934960 $Y=587740
X2082 903 936 877 915 2 886 1 AOI13HS $T=293880 527640 1 180 $X=290160 $Y=527260
X2083 378 1836 441 259 2 1846 1 AOI13HS $T=624960 638520 0 0 $X=624960 $Y=638140
X2084 2805 2796 2743 2792 2 2762 1 AOI13HS $T=956040 578040 0 180 $X=952320 $Y=572620
X2085 2797 2801 2693 2769 2 2739 1 AOI13HS $T=957280 618360 1 180 $X=953560 $Y=617980
X2086 1355 1 1326 1371 2 1276 ND3 $T=461280 537720 0 180 $X=458800 $Y=532300
X2087 1476 1 1482 1472 2 1463 ND3 $T=501580 567960 1 180 $X=499100 $Y=567580
X2088 1526 1 308 306 2 314 ND3 $T=518940 517560 0 180 $X=516460 $Y=512140
X2089 1515 1 1489 1575 2 1492 ND3 $T=518320 537720 0 0 $X=518320 $Y=537340
X2090 1526 1 308 229 2 314 ND3 $T=523900 517560 0 180 $X=521420 $Y=512140
X2091 1535 1 1540 1548 2 1547 ND3 $T=524520 608280 1 0 $X=524520 $Y=602860
X2092 1529 1 1543 1559 2 1531 ND3 $T=528860 537720 1 0 $X=528860 $Y=532300
X2093 1527 1 1556 1574 2 1533 ND3 $T=530100 588120 1 0 $X=530100 $Y=582700
X2094 438 1 415 439 2 435 ND3 $T=622480 507480 0 180 $X=620000 $Y=502060
X2095 1870 1 1651 1848 2 1486 ND3 $T=633020 557880 0 180 $X=630540 $Y=552460
X2096 1885 1 1726 1872 2 371 ND3 $T=638600 628440 1 180 $X=636120 $Y=628060
X2097 1896 1 1726 1859 2 462 ND3 $T=642940 638520 1 0 $X=642940 $Y=633100
X2098 2459 1 2471 2456 2 2436 ND3 $T=866760 567960 0 180 $X=864280 $Y=562540
X2099 2457 1 2416 2459 2 2428 ND3 $T=868620 557880 1 180 $X=866140 $Y=557500
X2100 2471 1 2465 2503 2 2416 ND3 $T=870480 567960 1 0 $X=870480 $Y=562540
X2101 2421 1 2468 2477 2 657 ND3 $T=871100 608280 0 0 $X=871100 $Y=607900
X2102 661 1 2485 2506 2 2470 ND3 $T=874200 628440 0 180 $X=871720 $Y=623020
X2103 2503 1 2500 2537 2 2510 ND3 $T=876060 567960 1 0 $X=876060 $Y=562540
X2104 2555 1 2534 2568 2 2567 ND3 $T=889080 578040 0 0 $X=889080 $Y=577660
X2105 2566 1 689 691 2 2626 ND3 $T=908920 638520 0 0 $X=908920 $Y=638140
X2106 2666 1 2644 695 2 2625 ND3 $T=914500 638520 0 180 $X=912020 $Y=633100
X2107 2621 1 2653 2657 2 2535 ND3 $T=912640 628440 0 0 $X=912640 $Y=628060
X2108 2664 1 2672 2685 2 2576 ND3 $T=916980 588120 1 0 $X=916980 $Y=582700
X2109 2629 1 2602 2694 2 2617 ND3 $T=918840 598200 0 0 $X=918840 $Y=597820
X2110 2690 1 2582 2691 2 2675 ND3 $T=921940 567960 1 180 $X=919460 $Y=567580
X2111 2677 1 2692 2693 2 2698 ND3 $T=921940 618360 0 0 $X=921940 $Y=617980
X2112 2668 1 2674 2692 2 2683 ND3 $T=925040 628440 0 180 $X=922560 $Y=623020
X2113 2686 1 2674 2752 2 2698 ND3 $T=928140 618360 1 0 $X=928140 $Y=612940
X2114 2657 1 2674 2731 2 2719 ND3 $T=928760 618360 0 0 $X=928760 $Y=617980
X2115 2528 1 2537 2729 2 2724 ND3 $T=930620 567960 1 0 $X=930620 $Y=562540
X2116 2712 1 2731 2739 2 2689 ND3 $T=933720 628440 0 0 $X=933720 $Y=628060
X2117 2691 1 2748 2750 2 2729 ND3 $T=939920 567960 0 180 $X=937440 $Y=562540
X2118 2767 1 2748 2775 2 2773 ND3 $T=944880 578040 0 0 $X=944880 $Y=577660
X2119 2637 1 2748 2776 2 2766 ND3 $T=946740 557880 1 0 $X=946740 $Y=552460
X2120 2778 1 2775 2795 2 2766 ND3 $T=949220 567960 1 0 $X=949220 $Y=562540
X2121 1913 1963 1913 1963 2 1 1951 MAOI1 $T=667740 608280 0 180 $X=662780 $Y=602860
X2122 2447 2367 2410 2384 2 1 2484 MAOI1 $T=866760 588120 1 0 $X=866760 $Y=582700
X2123 2584 2483 2504 2651 2 1 2660 MAOI1 $T=910160 567960 0 0 $X=910160 $Y=567580
X2124 968 60 1 948 932 945 2 MOAI1 $T=305660 608280 0 180 $X=301320 $Y=602860
X2125 936 919 1 936 972 919 2 MOAI1 $T=306900 537720 1 0 $X=306900 $Y=532300
X2126 1492 1536 1 1492 1549 1536 2 MOAI1 $T=523900 547800 1 0 $X=523900 $Y=542380
X2127 359 1563 1 1552 1591 1596 2 MOAI1 $T=542500 547800 1 0 $X=542500 $Y=542380
X2128 1563 1578 1 1563 1596 1578 2 MOAI1 $T=546840 537720 1 0 $X=546840 $Y=532300
X2129 359 1658 1 1605 1653 1552 2 MOAI1 $T=571640 527640 1 180 $X=567300 $Y=527260
X2130 390 387 1 1656 1652 387 2 MOAI1 $T=572260 507480 1 180 $X=567920 $Y=507100
X2131 1689 370 1 1689 1703 1698 2 MOAI1 $T=584660 507480 0 180 $X=580320 $Y=502060
X2132 359 379 1 1644 1744 1711 2 MOAI1 $T=587140 527640 1 0 $X=587140 $Y=522220
X2133 448 1872 1 448 1877 1872 2 MOAI1 $T=633020 638520 1 0 $X=633020 $Y=633100
X2134 471 1951 1 471 1960 1951 2 MOAI1 $T=657820 608280 0 0 $X=657820 $Y=607900
X2135 2048 2087 1 2048 2101 2087 2 MOAI1 $T=721680 537720 0 0 $X=721680 $Y=537340
X2136 855 36 861 2 863 871 1 AO22 $T=266600 598200 0 0 $X=266600 $Y=597820
X2137 958 88 89 79 2 1039 1 1043 MUX3 $T=326740 517560 0 0 $X=326740 $Y=517180
X2138 1081 1085 1087 2 1 1124 XOR3 $T=351540 557880 0 0 $X=351540 $Y=557500
X2139 1078 1096 1109 2 1 1135 XOR3 $T=359600 588120 1 0 $X=359600 $Y=582700
X2140 1110 1115 1088 2 1 1141 XOR3 $T=364560 537720 1 0 $X=364560 $Y=532300
X2141 1116 1043 1113 2 1 1137 XOR3 $T=365800 527640 0 0 $X=365800 $Y=527260
X2142 1167 1168 1037 2 1 1199 XOR3 $T=383780 567960 0 0 $X=383780 $Y=567580
X2143 1204 1212 954 2 1 1234 XOR3 $T=401140 557880 0 0 $X=401140 $Y=557500
X2144 42 38 39 1 2 63 MAO222 $T=275280 507480 1 0 $X=275280 $Y=502060
X2145 65 63 64 1 2 70 MAO222 $T=295120 507480 1 0 $X=295120 $Y=502060
X2146 874 910 66 1 2 960 AO12 $T=301940 557880 0 0 $X=301940 $Y=557500
X2147 1180 959 1201 1 2 1216 AO12 $T=402380 547800 1 0 $X=402380 $Y=542380
X2148 1438 1416 1258 1 2 220 AO12 $T=478640 578040 0 180 $X=474920 $Y=572620
X2149 1438 1456 253 1 2 261 AO12 $T=493520 557880 1 0 $X=493520 $Y=552460
X2150 1453 1456 1464 1 2 259 AO12 $T=494760 547800 1 0 $X=494760 $Y=542380
X2151 1477 1438 280 1 2 1507 AO12 $T=502820 547800 0 0 $X=502820 $Y=547420
X2152 1543 1511 1551 1 2 1557 AO12 $T=526380 557880 0 0 $X=526380 $Y=557500
X2153 2537 2724 2754 1 2 2735 AO12 $T=942400 557880 0 180 $X=938680 $Y=552460
X2154 2756 2723 2759 1 2 2787 AO12 $T=940540 517560 0 0 $X=940540 $Y=517180
X2155 102 1 2 1080 DELA $T=350920 618360 0 0 $X=350920 $Y=617980
X2156 2290 1 2 2300 DELA $T=815920 578040 1 0 $X=815920 $Y=572620
X2157 953 1 2 942 BUF1S $T=303800 628440 0 0 $X=303800 $Y=628060
X2158 2107 1 2 2108 BUF1S $T=732220 537720 0 0 $X=732220 $Y=537340
X2159 2108 1 2 2110 BUF1S $T=732840 578040 1 0 $X=732840 $Y=572620
X2160 1333 1262 1 2 BUF2CK $T=448880 547800 1 0 $X=448880 $Y=542380
X2161 1406 1365 1 2 BUF2CK $T=475540 527640 0 0 $X=475540 $Y=527260
X2162 225 1333 1 2 BUF2CK $T=478020 547800 1 0 $X=478020 $Y=542380
X2163 1398 1497 1 2 BUF2CK $T=505920 598200 1 0 $X=505920 $Y=592780
X2164 2240 2 1 2244 BUF3 $T=788020 598200 1 0 $X=788020 $Y=592780
X2165 1479 1 1517 313 2 ND2P $T=520800 598200 1 180 $X=517080 $Y=597820
X2166 2312 2319 2329 2273 2 1 MXL2HS $T=824600 608280 0 0 $X=824600 $Y=607900
X2167 2681 2598 2659 2627 2 1 MXL2HS $T=921940 557880 0 180 $X=916360 $Y=552460
X2168 2676 2598 2684 2615 2 1 MXL2HS $T=918220 547800 0 0 $X=918220 $Y=547420
X2169 2680 2679 2676 2696 2 1 MXL2HS $T=920080 547800 1 0 $X=920080 $Y=542380
X2170 1006 2 1004 1020 1 AN2B1S $T=322400 557880 1 0 $X=322400 $Y=552460
X2171 358 2 1620 1609 1 AN2B1S $T=560480 537720 0 180 $X=557380 $Y=532300
X2172 70 69 86 100 1 2 MAO222P $T=321160 507480 1 0 $X=321160 $Y=502060
X2173 1252 2 1255 1 1276 NR2P $T=429040 547800 0 180 $X=425320 $Y=542380
X2174 1494 2 294 1 1504 NR2P $T=513980 527640 0 180 $X=510260 $Y=522220
X2175 1504 2 240 1 1515 NR2P $T=513360 537720 1 0 $X=513360 $Y=532300
X2176 904 908 911 908 903 904 1 2 899 OA222 $T=289540 547800 1 180 $X=283960 $Y=547420
X2177 2829 2823 2819 2669 2769 2722 1 2 2794 OA222 $T=962860 557880 0 180 $X=957280 $Y=552460
X2178 1084 1086 1092 2 1 1139 XNR3 $T=363320 578040 1 0 $X=363320 $Y=572620
X2179 1117 1104 1097 2 1 1142 XNR3 $T=365800 547800 0 0 $X=365800 $Y=547420
X2180 1034 1153 1119 2 1 1187 XNR3 $T=378820 598200 1 0 $X=378820 $Y=592780
X2181 959 1180 1201 2 1 1189 XNR3 $T=387500 547800 1 0 $X=387500 $Y=542380
X2182 1224 160 972 2 1 1231 XNR3 $T=420360 547800 1 180 $X=409200 $Y=547420
X2183 987 1211 1207 2 1 1233 XNR3 $T=423460 578040 1 180 $X=412300 $Y=577660
X2184 172 152 1 1253 1258 1283 2 OAI112HS $T=424700 517560 0 0 $X=424700 $Y=517180
X2185 1468 240 1 1495 1501 1499 2 OAI112HS $T=508400 557880 0 0 $X=508400 $Y=557500
X2186 230 1489 1 1498 1522 1503 2 OAI112HS $T=509640 517560 0 0 $X=509640 $Y=517180
X2187 230 1492 1 1500 1514 1510 2 OAI112HS $T=510260 547800 1 0 $X=510260 $Y=542380
X2188 1497 1522 1 1537 330 1544 2 OAI112HS $T=522660 578040 0 0 $X=522660 $Y=577660
X2189 1497 351 1 1590 1592 1594 2 OAI112HS $T=542500 598200 1 0 $X=542500 $Y=592780
X2190 1514 1564 1 1588 371 1603 2 OAI112HS $T=557380 557880 1 180 $X=553040 $Y=557500
X2191 1497 1514 1 1524 383 1616 2 OAI112HS $T=561720 628440 1 0 $X=561720 $Y=623020
X2192 2548 2498 1 2530 2528 2513 2 OAI112HS $T=885980 567960 1 180 $X=881640 $Y=567580
X2193 2549 688 1 2628 2648 2647 2 OAI112HS $T=907060 618360 0 0 $X=907060 $Y=617980
X2194 2691 2718 1 2750 2762 2757 2 OAI112HS $T=937440 578040 1 0 $X=937440 $Y=572620
X2195 2686 2738 1 2752 2769 2764 2 OAI112HS $T=941160 608280 0 0 $X=941160 $Y=607900
X2196 2637 2748 1 2776 2782 2760 2 OAI112HS $T=945500 557880 0 0 $X=945500 $Y=557500
X2197 1016 90 1 2 BUF6 $T=326120 598200 1 0 $X=326120 $Y=592780
X2198 1408 1409 1350 1417 2 1 226 OA112 $T=473680 598200 1 0 $X=473680 $Y=592780
X2199 1408 1431 1340 1417 2 1 239 OA112 $T=481120 598200 1 0 $X=481120 $Y=592780
X2200 326 1553 1522 335 2 1 1569 OA112 $T=528860 527640 1 0 $X=528860 $Y=522220
X2201 343 347 353 352 2 1 1583 OA112 $T=536300 507480 1 0 $X=536300 $Y=502060
X2202 1528 1579 351 1564 2 1 1599 OA112 $T=536300 588120 1 0 $X=536300 $Y=582700
X2203 1540 1565 351 352 2 1 366 OA112 $T=541880 588120 0 0 $X=541880 $Y=587740
X2204 1338 1514 1 1512 303 292 2 OAI112H $T=518940 567960 0 180 $X=511500 $Y=562540
X2205 1497 423 1 419 422 1632 2 OAI112H $T=609460 517560 0 180 $X=602020 $Y=512140
X2206 2820 2726 710 2816 2768 2825 1 2 2831 AO222S $T=961620 608280 1 0 $X=961620 $Y=602860
X2207 2820 2827 725 2816 2779 2825 1 2 2836 AO222S $T=977740 598200 1 180 $X=971540 $Y=597820
X2208 936 886 1 940 936 2 940 938 915 OAI222S $T=304420 527640 1 180 $X=298840 $Y=527260
X2209 2568 2641 1 2649 2652 2 2656 2642 2669 OAI222S $T=910160 588120 0 0 $X=910160 $Y=587740
X2210 2649 2661 1 2641 2678 2 2624 2623 2669 OAI222S $T=917600 598200 1 0 $X=917600 $Y=592780
X2211 2809 2793 1 2811 2753 2 2815 715 2817 OAI222S $T=956040 628440 1 0 $X=956040 $Y=623020
X2212 2693 2722 1 2805 2701 2 2821 2834 2815 OAI222S $T=957280 578040 1 0 $X=957280 $Y=572620
X2213 2701 2795 1 2649 2755 2 2826 2828 2815 OAI222S $T=960380 567960 1 0 $X=960380 $Y=562540
X2214 2706 2649 1 2782 2829 2 2838 2833 2815 OAI222S $T=965340 557880 0 0 $X=965340 $Y=557500
X2215 2815 2837 1 2701 2762 2 2722 2835 2739 OAI222S $T=970920 598200 0 180 $X=965340 $Y=592780
X2216 2816 717 2825 2765 2763 2820 1 2 2832 AO222 $T=961000 618360 1 0 $X=961000 $Y=612940
X2217 2816 719 2825 709 2808 2820 1 2 2824 AO222 $T=967200 628440 1 180 $X=961000 $Y=628060
X2218 2614 2 2594 2605 2620 1 NR3 $T=903960 557880 1 180 $X=900860 $Y=557500
X2219 2630 2 2619 2618 2617 1 NR3 $T=907680 608280 0 180 $X=904580 $Y=602860
X2220 2779 2 2768 2803 2797 1 NR3 $T=958520 608280 0 180 $X=955420 $Y=602860
X2221 2782 2795 2725 2 2807 1 2792 AN4B1S $T=955420 567960 1 0 $X=955420 $Y=562540
X2222 697 1 2703 2722 2 ND2T $T=924420 567960 0 0 $X=924420 $Y=567580
X2223 711 1 714 2785 2 ND2T $T=953560 628440 0 0 $X=953560 $Y=628060
X2224 977 911 2 967 964 1 OR3B2S $T=310620 547800 1 180 $X=306900 $Y=547420
X2225 2508 2524 2 2545 2539 1 OR3B2S $T=880400 628440 0 0 $X=880400 $Y=628060
X2226 2495 2456 2 2561 2557 1 OR3B2S $T=882880 557880 1 0 $X=882880 $Y=552460
X2227 2550 2506 2 2583 2562 1 OR3B2S $T=886600 628440 0 0 $X=886600 $Y=628060
X2228 2673 2755 2 2803 2706 1 OR3B2S $T=949220 608280 1 0 $X=949220 $Y=602860
X2229 2793 2806 2791 2789 2 2703 1 MUXB2T $T=958520 598200 1 180 $X=949220 $Y=597820
X2230 2753 2772 2781 2785 2 2786 1 MUXB2P $T=945500 628440 0 0 $X=945500 $Y=628060
X2231 698 2703 2 2701 1 ND2F $T=923180 578040 1 0 $X=923180 $Y=572620
X2232 2405 2438 2347 2442 2 1 2486 OA22 $T=858080 598200 0 0 $X=858080 $Y=597820
X2233 2474 2450 2498 2491 2 1 2510 OA22 $T=874820 557880 0 0 $X=874820 $Y=557500
X2234 2492 2415 2474 2489 2 1 2513 OA22 $T=875440 567960 0 0 $X=875440 $Y=567580
X2235 2424 2534 2466 2542 2 1 2582 OA22 $T=881640 578040 1 0 $X=881640 $Y=572620
X2236 2549 2463 2531 2448 2 1 2535 OA22 $T=887220 628440 0 180 $X=882880 $Y=623020
X2237 2549 671 2531 2438 2 1 2566 OA22 $T=887220 618360 1 0 $X=887220 $Y=612940
X2238 2584 2499 2534 2453 2 1 2558 OA22 $T=892800 567960 0 180 $X=888460 $Y=562540
X2239 2591 2559 2534 2437 2 1 2576 OA22 $T=897760 578040 1 180 $X=893420 $Y=577660
X2240 2591 2526 2534 2516 2 1 2622 OA22 $T=900240 578040 1 0 $X=900240 $Y=572620
X2241 2531 2432 2608 687 2 1 2625 OA22 $T=900860 628440 0 0 $X=900860 $Y=628060
X2242 2591 2607 2659 2603 2 1 2671 OA22 $T=913260 567960 1 0 $X=913260 $Y=562540
X2243 2531 2449 682 692 2 1 2647 OA22 $T=913880 618360 0 0 $X=913880 $Y=617980
X2244 2570 2589 2577 1 2 2606 AN3S $T=895280 618360 0 0 $X=895280 $Y=617980
X2245 1268 188 1257 1254 1 2 ND3P $T=429660 588120 0 0 $X=429660 $Y=587740
X2246 1303 1327 1293 1290 1 2 ND3P $T=438340 527640 1 0 $X=438340 $Y=522220
X2247 393 1683 1669 394 1 2 ND3P $T=572260 507480 0 0 $X=572260 $Y=507100
X2248 1788 426 1794 1795 1 2 ND3P $T=607600 507480 0 0 $X=607600 $Y=507100
X2249 1543 322 1 1549 1567 1552 2 OAI22H $T=528240 547800 1 0 $X=528240 $Y=542380
X2250 403 322 1 1703 1733 1644 2 OAI22H $T=585280 507480 0 0 $X=585280 $Y=507100
X2251 1308 1291 1266 2 1 1318 AN3 $T=441440 578040 0 0 $X=441440 $Y=577660
X2252 1443 1439 1449 2 1 249 AN3 $T=487320 608280 1 0 $X=487320 $Y=602860
X2253 279 1483 1478 2 1 291 AN3 $T=504680 517560 0 0 $X=504680 $Y=517180
X2254 1438 1437 1327 1 2 216 AO12T $T=486700 567960 1 180 $X=481740 $Y=567580
X2255 210 1354 1382 2 1388 1 1402 AO112 $T=464380 598200 0 0 $X=464380 $Y=597820
X2256 1411 1332 1382 2 1388 1 1422 AO112 $T=474300 598200 0 0 $X=474300 $Y=597820
X2257 1404 1400 200 1 2 AN2P $T=473680 578040 0 180 $X=469960 $Y=572620
X2258 128 178 2 1310 1303 1294 1 AOI22H $T=438340 537720 1 0 $X=438340 $Y=532300
X2259 950 1 2 953 BUF12CK $T=301320 618360 0 0 $X=301320 $Y=617980
X2260 30 842 853 847 46 1 2 FA1P $T=261640 547800 0 0 $X=261640 $Y=547420
X2261 786 764 800 11 14 1 2 804 MUX3T $T=234360 507480 0 0 $X=234360 $Y=507100
.ENDS
***************************************
.SUBCKT AO12P B2 B1 A1 O GND VCC
** N=7 EP=6 IP=0 FDC=0
.ENDS
***************************************
.SUBCKT OA112P A1 B1 C1 C2 O GND VCC
** N=8 EP=7 IP=0 FDC=0
.ENDS
***************************************
.SUBCKT BUF4 I O GND VCC
** N=5 EP=4 IP=0 FDC=0
.ENDS
***************************************
.SUBCKT NR2T O I2 GND I1 VCC
** N=6 EP=5 IP=0 FDC=0
.ENDS
***************************************
.SUBCKT NR2F I1 VCC GND I2 O
** N=6 EP=5 IP=0 FDC=0
.ENDS
***************************************
.SUBCKT INV4 I O GND VCC
** N=5 EP=4 IP=0 FDC=0
.ENDS
***************************************
.SUBCKT OR3B2 I1 B1 VCC O B2 GND
** N=7 EP=6 IP=0 FDC=0
.ENDS
***************************************
.SUBCKT BUF3CK I GND VCC O
** N=5 EP=4 IP=0 FDC=0
.ENDS
***************************************
.SUBCKT ICV_7 1 2 3 4 5 6 7 8 9 10 11 12 13 14 15 16 17 18 19 20
+ 21 22 23 24 25 26 27 28 29 30 31 32 33 34 35 36 37 38 39 40
+ 41 42 43 44 45 46 47 48 49 50 51 52 53 54 55 56 57 58 59 60
+ 61 62 63 64 65 66 67 68 69 70 71 72 73 74 75 76 77 78 79 80
+ 81 82 83 84 85 86 87 88 89 90 91 92 93 94 95 96 97 98 99 100
+ 101 102 103 104 105 106 107 108 109 110 111 112 113 114 115 116 117 118 119 120
+ 121 122 123 124 125 126 127 128 129 130 131 132 133 134 135 136 137 138 139 140
+ 141 142 143 144 145 146 147 148 149 150 151 152 153 154 155 156 157 158 159 160
+ 161 162 163 164 165 166 167 168 169 170 171 172 173 174 175 176 177 178 179 180
+ 181 182 183 184 185 186 187 188 189 190 191 192 193 194 195 196 197 198 199 200
+ 201 202 203 204 205 206 207 208 209 210 211 212 213 214 215 216 217 218 219 220
+ 221 222 223 224 225 226 227 228 229 230 231 232 233 234 235 236 237 238 239 240
+ 241 242 243 244 245 246 247 248 249 250 251 252 253 254 255 256 257 258 259 260
+ 261 262 263 264 265 266 267 268 269 270 271 272 273 274 275 276 277 278 279 280
+ 281 282 283 284 285 286 287 288 289 290 291 292 293 294 295 296 297 298 299 300
+ 301 302 303 304 305 306 307 308 309 310 311 312 313 314 315 316 317 318 319 320
+ 321 322 323 324 325 326 327 328 329 330 331 332 333 334 335 336 337 338 339 340
+ 341 342 343 344 345 346 347 348 349 350 351 352 353 354 355 356 357 358 359 360
+ 361 362 363 364 365 366 367 368 369 370 371 372 373 374 375 376 377 378 379 380
+ 381 382 383 384 385 386 387 388 389 390 391 392 393 394 395 396 397 398 399 400
+ 401 402 403 404 405 406 407 408 409 410 411 412 413 414 415 416 417 418 419 420
+ 421 422 423 424 425 426 427 428 429 430 431 432 433 434 435 436 437 438 439 440
+ 441 442 443 444 445 446 447 448 449 450 451 452 453 454 455 456 457 458 459 460
+ 461 462 463 464 465 466 467 468 469 470 471 472 473 474 475 476 477 478 479 480
+ 481 482 483 484 485 486 487 488 489 490 491 492 493 494 495 496 497 498 499 500
+ 501 502 503 504 505 506 507 508 509 510 511 512 513 514 515 516 517 518 519 520
+ 521 522 523 524 525 526 527 528 529 530 531 532 533 534 535 536 537 538 539 540
+ 541 542 543 544 545 546 547 548 549 550 551 552 553 554 555 556 557 558 559 560
+ 561 562 563 564 565 566 567 568 569 570 571 572 573 574 575 576 577 578 579 580
+ 581 582 583 584 585 586 587 588 589 590 591 592 593 594 595 596 597 598 599 600
+ 601 602 603 604 605 606 607 608 609 610 611 612 613 614 615 616 617 618 619 620
+ 621 622 623 624 625 626 627 628 629 630 631 632 633 634 635 636 637 638 639 640
+ 641 642 643 644 645 646 647 648 649 650 651 652 653 654 655 656 657 658 659 660
+ 661 662 663 664 665 666 667 668 669 670 671 672 673 674 675 676 677 678 679 680
+ 681 682 683 684 685 686 687 688 689 690 691 692 693 694 695 696 697 698 699 700
+ 701 702 703 704 705 706 707 708 709 710 711 712 713 714 715 716 717 718 719 720
+ 721 722 723 724 725 726 727 728 729 730 731 732 733 770
** N=2156 EP=734 IP=10292 FDC=0
X0 731 729 729 729 732 730 733 YA2GSD $T=1199700 434770 0 90 $X=1060200 $Y=437620
X1 24 2 1 777 BUF1 $T=236220 426840 0 180 $X=233740 $Y=421420
X2 797 2 1 13 BUF1 $T=236220 426840 1 180 $X=233740 $Y=426460
X3 777 2 1 21 BUF1 $T=233740 457080 0 0 $X=233740 $Y=456700
X4 28 2 1 783 BUF1 $T=244280 487320 1 180 $X=241800 $Y=486940
X5 801 2 1 30 BUF1 $T=242420 426840 0 0 $X=242420 $Y=426460
X6 25 2 1 12 BUF1 $T=245520 457080 1 180 $X=243040 $Y=456700
X7 810 2 1 33 BUF1 $T=246140 467160 1 0 $X=246140 $Y=461740
X8 11 2 1 800 BUF1 $T=248000 477240 0 0 $X=248000 $Y=476860
X9 830 2 1 42 BUF1 $T=256680 436920 1 0 $X=256680 $Y=431500
X10 54 2 1 36 BUF1 $T=277760 467160 1 180 $X=275280 $Y=466780
X11 799 2 1 61 BUF1 $T=287060 426840 1 0 $X=287060 $Y=421420
X12 63 2 1 888 BUF1 $T=292020 477240 0 180 $X=289540 $Y=471820
X13 888 2 1 64 BUF1 $T=290780 426840 1 0 $X=290780 $Y=421420
X14 89 2 1 97 BUF1 $T=329840 497400 0 0 $X=329840 $Y=497020
X15 981 2 1 1030 BUF1 $T=344100 467160 0 0 $X=344100 $Y=466780
X16 105 2 1 975 BUF1 $T=347200 477240 0 180 $X=344720 $Y=471820
X17 105 2 1 993 BUF1 $T=349680 467160 0 0 $X=349680 $Y=466780
X18 1042 2 1 977 BUF1 $T=355260 457080 1 180 $X=352780 $Y=456700
X19 1042 2 1 1047 BUF1 $T=356500 457080 1 0 $X=356500 $Y=451660
X20 1042 2 1 110 BUF1 $T=360220 467160 1 180 $X=357740 $Y=466780
X21 1064 2 1 1008 BUF1 $T=365800 467160 0 180 $X=363320 $Y=461740
X22 95 2 1 128 BUF1 $T=370140 467160 1 0 $X=370140 $Y=461740
X23 134 2 1 1042 BUF1 $T=378820 477240 0 180 $X=376340 $Y=471820
X24 132 2 1 998 BUF1 $T=378820 487320 1 180 $X=376340 $Y=486940
X25 951 2 1 1096 BUF1 $T=389980 457080 1 0 $X=389980 $Y=451660
X26 943 2 1 1102 BUF1 $T=394320 457080 1 0 $X=394320 $Y=451660
X27 134 2 1 1100 BUF1 $T=394320 477240 1 0 $X=394320 $Y=471820
X28 1077 2 1 1109 BUF1 $T=396800 436920 1 0 $X=396800 $Y=431500
X29 149 2 1 132 BUF1 $T=400520 497400 1 180 $X=398040 $Y=497020
X30 1093 2 1 1116 BUF1 $T=400520 477240 1 0 $X=400520 $Y=471820
X31 1094 2 1 1122 BUF1 $T=408580 487320 1 0 $X=408580 $Y=481900
X32 1122 2 1 1161 BUF1 $T=414160 477240 0 0 $X=414160 $Y=476860
X33 960 2 1 1148 BUF1 $T=417260 447000 0 0 $X=417260 $Y=446620
X34 171 2 1 1169 BUF1 $T=417880 426840 1 0 $X=417880 $Y=421420
X35 177 2 1 178 BUF1 $T=420360 497400 0 0 $X=420360 $Y=497020
X36 166 2 1 1144 BUF1 $T=421600 447000 0 0 $X=421600 $Y=446620
X37 965 2 1 1171 BUF1 $T=422840 436920 1 0 $X=422840 $Y=431500
X38 1140 2 1 1198 BUF1 $T=434620 416760 0 0 $X=434620 $Y=416380
X39 200 2 1 208 BUF1 $T=437720 416760 1 0 $X=437720 $Y=411340
X40 1212 2 1 156 BUF1 $T=443300 416760 0 180 $X=440820 $Y=411340
X41 1217 2 1 1121 BUF1 $T=443920 447000 0 180 $X=441440 $Y=441580
X42 1218 2 1 1207 BUF1 $T=446400 477240 1 0 $X=446400 $Y=471820
X43 1229 2 1 1196 BUF1 $T=449500 467160 1 0 $X=449500 $Y=461740
X44 1212 2 1 1228 BUF1 $T=457560 426840 0 180 $X=455080 $Y=421420
X45 1286 2 1 1244 BUF1 $T=459420 457080 1 0 $X=459420 $Y=451660
X46 1261 2 1 1160 BUF1 $T=463140 467160 1 180 $X=460660 $Y=466780
X47 184 2 1 1272 BUF1 $T=461900 497400 1 0 $X=461900 $Y=491980
X48 1189 2 1 1266 BUF1 $T=465000 426840 1 0 $X=465000 $Y=421420
X49 1250 2 1 1289 BUF1 $T=468720 487320 1 0 $X=468720 $Y=481900
X50 1299 2 1 1220 BUF1 $T=474300 477240 1 0 $X=474300 $Y=471820
X51 1303 2 1 1292 BUF1 $T=476160 457080 1 0 $X=476160 $Y=451660
X52 1314 2 1 1218 BUF1 $T=481740 457080 0 180 $X=479260 $Y=451660
X53 1252 2 1 1250 BUF1 $T=482980 477240 0 180 $X=480500 $Y=471820
X54 1228 2 1 261 BUF1 $T=486080 477240 1 0 $X=486080 $Y=471820
X55 1340 2 1 1268 BUF1 $T=494760 457080 0 0 $X=494760 $Y=456700
X56 1298 2 1 276 BUF1 $T=496000 497400 0 0 $X=496000 $Y=497020
X57 1356 2 1 279 BUF1 $T=502820 497400 1 180 $X=500340 $Y=497020
X58 1361 2 1 1235 BUF1 $T=504060 436920 1 180 $X=501580 $Y=436540
X59 281 2 1 1349 BUF1 $T=502200 487320 1 0 $X=502200 $Y=481900
X60 281 2 1 283 BUF1 $T=502820 487320 0 0 $X=502820 $Y=486940
X61 287 2 1 255 BUF1 $T=508400 416760 0 180 $X=505920 $Y=411340
X62 290 2 1 1340 BUF1 $T=509020 487320 0 180 $X=506540 $Y=481900
X63 1267 2 1 294 BUF1 $T=507160 467160 0 0 $X=507160 $Y=466780
X64 1314 2 1 1311 BUF1 $T=509020 426840 1 0 $X=509020 $Y=421420
X65 250 2 1 1378 BUF1 $T=510260 416760 0 0 $X=510260 $Y=416380
X66 1391 2 1 1299 BUF1 $T=520800 467160 1 180 $X=518320 $Y=466780
X67 1349 2 1 1407 BUF1 $T=524520 477240 0 0 $X=524520 $Y=476860
X68 330 2 1 267 BUF1 $T=530720 497400 1 180 $X=528240 $Y=497020
X69 1437 2 1 1368 BUF1 $T=536920 457080 1 180 $X=534440 $Y=456700
X70 1314 2 1 1421 BUF1 $T=538160 436920 1 180 $X=535680 $Y=436540
X71 1448 2 1 343 BUF1 $T=538160 487320 0 0 $X=538160 $Y=486940
X72 1432 2 1 346 BUF1 $T=538780 436920 1 0 $X=538780 $Y=431500
X73 344 2 1 349 BUF1 $T=539400 416760 1 0 $X=539400 $Y=411340
X74 1453 2 1 242 BUF1 $T=539400 416760 0 0 $X=539400 $Y=416380
X75 345 2 1 1411 BUF1 $T=540020 457080 0 0 $X=540020 $Y=456700
X76 287 2 1 357 BUF1 $T=543740 426840 0 0 $X=543740 $Y=426460
X77 361 2 1 364 BUF1 $T=548080 426840 0 0 $X=548080 $Y=426460
X78 318 2 1 1468 BUF1 $T=548080 436920 1 0 $X=548080 $Y=431500
X79 1391 2 1 1465 BUF1 $T=549320 457080 0 0 $X=549320 $Y=456700
X80 1465 2 1 360 BUF1 $T=549940 416760 0 0 $X=549940 $Y=416380
X81 269 2 1 371 BUF1 $T=553660 497400 1 0 $X=553660 $Y=491980
X82 1455 2 1 366 BUF1 $T=556140 416760 0 0 $X=556140 $Y=416380
X83 345 2 1 375 BUF1 $T=558620 457080 0 0 $X=558620 $Y=456700
X84 378 2 1 365 BUF1 $T=561720 447000 0 180 $X=559240 $Y=441580
X85 382 2 1 1496 BUF1 $T=562340 487320 0 0 $X=562340 $Y=486940
X86 1459 2 1 1481 BUF1 $T=562960 457080 0 0 $X=562960 $Y=456700
X87 1453 2 1 1487 BUF1 $T=564820 416760 0 0 $X=564820 $Y=416380
X88 1421 2 1 379 BUF1 $T=569160 457080 1 180 $X=566680 $Y=456700
X89 1510 2 1 300 BUF1 $T=571640 457080 1 180 $X=569160 $Y=456700
X90 394 2 1 1456 BUF1 $T=574740 487320 0 0 $X=574740 $Y=486940
X91 290 2 1 1533 BUF1 $T=577840 477240 1 0 $X=577840 $Y=471820
X92 402 2 1 1400 BUF1 $T=582800 426840 1 180 $X=580320 $Y=426460
X93 1542 2 1 1530 BUF1 $T=581560 457080 0 0 $X=581560 $Y=456700
X94 408 2 1 404 BUF1 $T=583420 497400 0 0 $X=583420 $Y=497020
X95 409 2 1 1536 BUF1 $T=584660 477240 1 0 $X=584660 $Y=471820
X96 1437 2 1 1554 BUF1 $T=586520 436920 1 0 $X=586520 $Y=431500
X97 330 2 1 1552 BUF1 $T=591480 497400 0 0 $X=591480 $Y=497020
X98 1536 2 1 1584 BUF1 $T=592720 457080 1 0 $X=592720 $Y=451660
X99 411 2 1 1542 BUF1 $T=598920 477240 0 180 $X=596440 $Y=471820
X100 1372 2 1 424 BUF1 $T=601400 416760 1 0 $X=601400 $Y=411340
X101 1587 2 1 1585 BUF1 $T=607600 457080 1 180 $X=605120 $Y=456700
X102 1554 2 1 1586 BUF1 $T=608840 447000 0 0 $X=608840 $Y=446620
X103 1574 2 1 435 BUF1 $T=616280 416760 0 180 $X=613800 $Y=411340
X104 298 2 1 438 BUF1 $T=615040 426840 1 0 $X=615040 $Y=421420
X105 1586 2 1 1605 BUF1 $T=615660 487320 1 0 $X=615660 $Y=481900
X106 319 2 1 447 BUF1 $T=620000 447000 0 0 $X=620000 $Y=446620
X107 1417 2 1 459 BUF1 $T=621860 416760 0 0 $X=621860 $Y=416380
X108 1622 2 1 443 BUF1 $T=627440 436920 0 180 $X=624960 $Y=431500
X109 1616 2 1 455 BUF1 $T=628060 467160 1 0 $X=628060 $Y=461740
X110 450 2 1 467 BUF1 $T=634880 467160 0 0 $X=634880 $Y=466780
X111 465 2 1 1638 BUF1 $T=641080 487320 0 0 $X=641080 $Y=486940
X112 352 2 1 1667 BUF1 $T=646040 467160 1 0 $X=646040 $Y=461740
X113 1673 2 1 473 BUF1 $T=652860 487320 1 180 $X=650380 $Y=486940
X114 1556 2 1 484 BUF1 $T=652240 436920 0 0 $X=652240 $Y=436540
X115 1688 2 1 471 BUF1 $T=656580 487320 1 180 $X=654100 $Y=486940
X116 464 2 1 1685 BUF1 $T=655340 467160 1 0 $X=655340 $Y=461740
X117 413 2 1 491 BUF1 $T=658440 416760 1 0 $X=658440 $Y=411340
X118 1691 2 1 1671 BUF1 $T=659060 467160 1 0 $X=659060 $Y=461740
X119 1606 2 1 493 BUF1 $T=663400 416760 1 0 $X=663400 $Y=411340
X120 1638 2 1 492 BUF1 $T=663400 457080 1 0 $X=663400 $Y=451660
X121 495 2 1 1701 BUF1 $T=664020 416760 0 0 $X=664020 $Y=416380
X122 1675 2 1 1693 BUF1 $T=665260 426840 0 0 $X=665260 $Y=426460
X123 1727 2 1 1664 BUF1 $T=668980 487320 0 180 $X=666500 $Y=481900
X124 337 2 1 495 BUF1 $T=667120 416760 0 0 $X=667120 $Y=416380
X125 1675 2 1 497 BUF1 $T=668980 416760 1 0 $X=668980 $Y=411340
X126 456 2 1 496 BUF1 $T=670220 467160 1 0 $X=670220 $Y=461740
X127 1717 2 1 1706 BUF1 $T=671460 447000 1 0 $X=671460 $Y=441580
X128 1700 2 1 1726 BUF1 $T=673320 447000 0 0 $X=673320 $Y=446620
X129 1663 2 1 1720 BUF1 $T=673940 447000 1 0 $X=673940 $Y=441580
X130 428 2 1 500 BUF1 $T=674560 416760 0 0 $X=674560 $Y=416380
X131 1720 2 1 1735 BUF1 $T=681380 436920 0 0 $X=681380 $Y=436540
X132 504 2 1 502 BUF1 $T=682620 416760 1 0 $X=682620 $Y=411340
X133 479 2 1 1751 BUF1 $T=685720 457080 0 0 $X=685720 $Y=456700
X134 1769 2 1 1727 BUF1 $T=693160 447000 1 180 $X=690680 $Y=446620
X135 1766 2 1 1666 BUF1 $T=693160 477240 1 180 $X=690680 $Y=476860
X136 508 2 1 514 BUF1 $T=696260 426840 0 0 $X=696260 $Y=426460
X137 1740 2 1 510 BUF1 $T=698740 436920 0 0 $X=698740 $Y=436540
X138 503 2 1 515 BUF1 $T=701220 416760 1 0 $X=701220 $Y=411340
X139 1535 2 1 520 BUF1 $T=705560 416760 1 0 $X=705560 $Y=411340
X140 1809 2 1 519 BUF1 $T=711760 426840 0 180 $X=709280 $Y=421420
X141 1607 2 1 1842 BUF1 $T=717340 436920 0 0 $X=717340 $Y=436540
X142 1667 2 1 524 BUF1 $T=717340 467160 0 0 $X=717340 $Y=466780
X143 1885 2 1 1870 BUF1 $T=760120 457080 0 180 $X=757640 $Y=451660
X144 549 2 1 1885 BUF1 $T=767560 436920 1 180 $X=765080 $Y=436540
X145 1903 2 1 549 BUF1 $T=771900 436920 1 180 $X=769420 $Y=436540
X146 553 2 1 567 BUF1 $T=779960 497400 0 0 $X=779960 $Y=497020
X147 553 2 1 1910 BUF1 $T=784300 487320 1 0 $X=784300 $Y=481900
X148 576 2 1 579 BUF1 $T=788020 497400 0 0 $X=788020 $Y=497020
X149 1911 2 1 1903 BUF1 $T=792360 447000 0 180 $X=789880 $Y=441580
X150 1910 2 1 1911 BUF1 $T=797320 457080 0 0 $X=797320 $Y=456700
X151 589 2 1 595 BUF1 $T=801040 426840 1 0 $X=801040 $Y=421420
X152 1911 2 1 1926 BUF1 $T=809100 467160 0 0 $X=809100 $Y=466780
X153 610 2 1 637 BUF1 $T=812200 436920 1 0 $X=812200 $Y=431500
X154 1926 2 1 617 BUF1 $T=815300 477240 1 0 $X=815300 $Y=471820
X155 636 2 1 1957 BUF1 $T=834520 416760 0 0 $X=834520 $Y=416380
X156 617 2 1 1942 BUF1 $T=834520 467160 0 0 $X=834520 $Y=466780
X157 2025 2 1 2013 BUF1 $T=881640 447000 1 180 $X=879160 $Y=446620
X158 2025 2 1 1984 BUF1 $T=884740 457080 1 180 $X=882260 $Y=456700
X159 676 2 1 2025 BUF1 $T=896520 467160 0 0 $X=896520 $Y=466780
X160 2062 2 1 2084 BUF1 $T=920080 477240 0 0 $X=920080 $Y=476860
X161 2088 2 1 2129 BUF1 $T=969680 447000 0 0 $X=969680 $Y=446620
X162 729 2 1 730 BUF1 $T=975260 467160 0 0 $X=975260 $Y=466780
X163 772 6 14 2 1 22 QDFFRBN $T=220720 416760 1 0 $X=220720 $Y=411340
X164 4 6 783 2 1 786 QDFFRBN $T=220720 447000 0 0 $X=220720 $Y=446620
X165 787 6 783 2 1 803 QDFFRBN $T=231880 436920 0 0 $X=231880 $Y=436540
X166 802 6 14 2 1 789 QDFFRBN $T=245520 416760 0 180 $X=233740 $Y=411340
X167 784 6 783 2 1 29 QDFFRBN $T=233740 477240 0 0 $X=233740 $Y=476860
X168 791 6 783 2 1 805 QDFFRBN $T=234360 457080 1 0 $X=234360 $Y=451660
X169 793 6 783 2 1 809 QDFFRBN $T=235600 477240 1 0 $X=235600 $Y=471820
X170 785 6 28 2 1 794 QDFFRBN $T=236220 497400 1 0 $X=236220 $Y=491980
X171 792 6 783 2 1 819 QDFFRBN $T=241180 447000 1 0 $X=241180 $Y=441580
X172 995 90 977 2 1 936 QDFFRBN $T=331700 447000 1 180 $X=319920 $Y=446620
X173 989 90 977 2 1 951 QDFFRBN $T=326740 467160 0 0 $X=326740 $Y=466780
X174 973 90 977 2 1 943 QDFFRBN $T=327980 457080 1 0 $X=327980 $Y=451660
X175 1002 90 977 2 1 1023 QDFFRBN $T=332940 457080 0 0 $X=332940 $Y=456700
X176 1026 104 110 2 1 113 QDFFRBN $T=344100 497400 0 0 $X=344100 $Y=497020
X177 1027 90 977 2 1 981 QDFFRBN $T=358980 467160 0 180 $X=347200 $Y=461740
X178 1031 104 110 2 1 1048 QDFFRBN $T=347200 487320 0 0 $X=347200 $Y=486940
X179 1029 90 110 2 1 1051 QDFFRBN $T=350300 477240 1 0 $X=350300 $Y=471820
X180 1003 90 118 2 1 960 QDFFRBN $T=350920 426840 1 0 $X=350920 $Y=421420
X181 1038 90 110 2 1 1056 QDFFRBN $T=352780 477240 0 0 $X=352780 $Y=476860
X182 1039 90 1047 2 1 965 QDFFRBN $T=353400 436920 1 0 $X=353400 $Y=431500
X183 1046 90 1047 2 1 1025 QDFFRBN $T=358980 447000 1 0 $X=358980 $Y=441580
X184 1050 90 1042 2 1 1064 QDFFRBN $T=361460 457080 1 0 $X=361460 $Y=451660
X185 1055 90 1042 2 1 1060 QDFFRBN $T=363320 477240 1 0 $X=363320 $Y=471820
X186 1061 90 1047 2 1 1077 QDFFRBN $T=368280 436920 1 0 $X=368280 $Y=431500
X187 1063 90 1047 2 1 138 QDFFRBN $T=370140 426840 0 0 $X=370140 $Y=426460
X188 1066 90 134 2 1 1078 QDFFRBN $T=370760 477240 0 0 $X=370760 $Y=476860
X189 1069 90 1042 2 1 1074 QDFFRBN $T=373240 467160 1 0 $X=373240 $Y=461740
X190 1080 90 134 2 1 1092 QDFFRBN $T=380680 477240 1 0 $X=380680 $Y=471820
X191 1081 90 134 2 1 1093 QDFFRBN $T=380680 487320 1 0 $X=380680 $Y=481900
X192 1087 90 1100 2 1 1112 QDFFRBN $T=391220 467160 0 0 $X=391220 $Y=466780
X193 1089 90 1100 2 1 1120 QDFFRBN $T=392460 457080 0 0 $X=392460 $Y=456700
X194 1114 90 1100 2 1 1094 QDFFRBN $T=404240 477240 1 180 $X=392460 $Y=476860
X195 1227 104 233 2 1 230 QDFFRBN $T=448880 497400 0 0 $X=448880 $Y=497020
X196 1263 104 233 2 1 1298 QDFFRBN $T=462520 497400 0 0 $X=462520 $Y=497020
X197 351 354 365 2 1 318 QDFFRBN $T=543120 416760 1 0 $X=543120 $Y=411340
X198 1488 354 365 2 1 1458 QDFFRBN $T=564200 436920 0 180 $X=552420 $Y=431500
X199 1484 354 378 2 1 1475 QDFFRBN $T=569160 447000 1 180 $X=557380 $Y=446620
X200 1802 518 522 2 1 1819 QDFFRBN $T=707420 497400 1 0 $X=707420 $Y=491980
X201 1798 518 522 2 1 1828 QDFFRBN $T=711140 487320 1 0 $X=711140 $Y=481900
X202 1818 518 522 2 1 1849 QDFFRBN $T=717340 497400 0 0 $X=717340 $Y=497020
X203 1826 518 522 2 1 1859 QDFFRBN $T=722300 497400 1 0 $X=722300 $Y=491980
X204 532 518 1870 2 1 538 QDFFRBN $T=737800 477240 1 0 $X=737800 $Y=471820
X205 1861 518 1870 2 1 1886 QDFFRBN $T=739040 467160 0 0 $X=739040 $Y=466780
X206 1838 518 1870 2 1 1891 QDFFRBN $T=748340 477240 0 0 $X=748340 $Y=476860
X207 1872 518 1870 2 1 1892 QDFFRBN $T=750200 487320 0 0 $X=750200 $Y=486940
X208 1860 518 1870 2 1 1899 QDFFRBN $T=754540 477240 1 0 $X=754540 $Y=471820
X209 1890 518 1885 2 1 1904 QDFFRBN $T=762600 457080 1 0 $X=762600 $Y=451660
X210 1883 518 1885 2 1 1902 QDFFRBN $T=763220 447000 0 0 $X=763220 $Y=446620
X211 547 518 553 2 1 558 QDFFRBN $T=765700 497400 0 0 $X=765700 $Y=497020
X212 548 518 553 2 1 566 QDFFRBN $T=768800 487320 1 0 $X=768800 $Y=481900
X213 1896 551 549 2 1 1908 QDFFRBN $T=770040 436920 1 0 $X=770040 $Y=431500
X214 1901 551 549 2 1 1900 QDFFRBN $T=782440 416760 1 180 $X=770660 $Y=416380
X215 1893 551 549 2 1 1907 QDFFRBN $T=771280 426840 1 0 $X=771280 $Y=421420
X216 559 551 1885 2 1 1915 QDFFRBN $T=778100 457080 1 0 $X=778100 $Y=451660
X217 1912 551 1910 2 1 562 QDFFRBN $T=792980 467160 0 180 $X=781200 $Y=461740
X218 1913 551 1910 2 1 563 QDFFRBN $T=793600 477240 1 180 $X=781820 $Y=476860
X219 568 551 1903 2 1 1916 QDFFRBN $T=783060 426840 0 0 $X=783060 $Y=426460
X220 588 551 1903 2 1 573 QDFFRBN $T=799800 426840 0 180 $X=788020 $Y=421420
X221 1925 551 567 2 1 575 QDFFRBN $T=800420 497400 0 180 $X=788640 $Y=491980
X222 1923 551 1910 2 1 578 QDFFRBN $T=801660 487320 0 180 $X=789880 $Y=481900
X223 1924 551 567 2 1 582 QDFFRBN $T=802900 497400 1 180 $X=791120 $Y=497020
X224 584 551 1911 2 1 596 QDFFRBN $T=792980 447000 0 0 $X=792980 $Y=446620
X225 1918 551 1926 2 1 598 QDFFRBN $T=794840 467160 0 0 $X=794840 $Y=466780
X226 597 551 1903 2 1 1919 QDFFRBN $T=807240 447000 0 180 $X=795460 $Y=441580
X227 600 551 1903 2 1 1921 QDFFRBN $T=808480 426840 1 180 $X=796700 $Y=426460
X228 601 551 1903 2 1 1920 QDFFRBN $T=808480 436920 0 180 $X=796700 $Y=431500
X229 1917 551 1910 2 1 1922 QDFFRBN $T=809100 477240 0 180 $X=797320 $Y=471820
X230 590 551 1926 2 1 609 QDFFRBN $T=801040 477240 0 0 $X=801040 $Y=476860
X231 592 551 1911 2 1 1930 QDFFRBN $T=802280 457080 1 0 $X=802280 $Y=451660
X232 593 551 1911 2 1 612 QDFFRBN $T=802900 457080 0 0 $X=802900 $Y=456700
X233 618 551 1911 2 1 604 QDFFRBN $T=820880 447000 1 180 $X=809100 $Y=446620
X234 607 551 617 2 1 621 QDFFRBN $T=811580 487320 1 0 $X=811580 $Y=481900
X235 1946 551 617 2 1 615 QDFFRBN $T=826460 477240 1 180 $X=814680 $Y=476860
X236 624 551 1926 2 1 606 QDFFRBN $T=827080 467160 0 180 $X=815300 $Y=461740
X237 629 551 1942 2 1 1933 QDFFRBN $T=831420 457080 1 180 $X=819640 $Y=456700
X238 630 551 617 2 1 1937 QDFFRBN $T=831420 477240 0 180 $X=819640 $Y=471820
X239 623 551 1942 2 1 641 QDFFRBN $T=824600 447000 0 0 $X=824600 $Y=446620
X240 631 551 1942 2 1 1967 QDFFRBN $T=830180 467160 1 0 $X=830180 $Y=461740
X241 643 551 1942 2 1 650 QDFFRBN $T=837620 457080 0 0 $X=837620 $Y=456700
X242 1969 551 649 2 1 651 QDFFRBN $T=838860 497400 0 0 $X=838860 $Y=497020
X243 647 551 1984 2 1 1978 QDFFRBN $T=843200 447000 0 0 $X=843200 $Y=446620
X244 658 551 1942 2 1 1948 QDFFRBN $T=858700 467160 0 180 $X=846920 $Y=461740
X245 654 551 1984 2 1 2002 QDFFRBN $T=853740 457080 1 0 $X=853740 $Y=451660
X246 668 666 1984 2 1 1994 QDFFRBN $T=872960 447000 1 180 $X=861180 $Y=446620
X247 670 666 1942 2 1 2006 QDFFRBN $T=876060 467160 0 180 $X=864280 $Y=461740
X248 2040 666 1984 2 1 2009 QDFFRBN $T=879780 457080 0 180 $X=868000 $Y=451660
X249 2015 666 676 2 1 2027 QDFFRBN $T=872960 477240 1 0 $X=872960 $Y=471820
X250 671 666 2013 2 1 2029 QDFFRBN $T=877300 436920 0 0 $X=877300 $Y=436540
X251 2020 666 676 2 1 678 QDFFRBN $T=877300 477240 0 0 $X=877300 $Y=476860
X252 680 666 2013 2 1 2023 QDFFRBN $T=892800 416760 0 180 $X=881020 $Y=411340
X253 2028 666 2025 2 1 2043 QDFFRBN $T=885360 447000 0 0 $X=885360 $Y=446620
X254 2045 666 2013 2 1 2033 QDFFRBN $T=901480 436920 1 180 $X=889700 $Y=436540
X255 2036 666 2013 2 1 2031 QDFFRBN $T=904580 426840 1 180 $X=892800 $Y=426460
X256 2038 666 676 2 1 2037 QDFFRBN $T=904580 477240 1 180 $X=892800 $Y=476860
X257 2044 666 676 2 1 684 QDFFRBN $T=907060 497400 1 180 $X=895280 $Y=497020
X258 2042 666 2025 2 1 2048 QDFFRBN $T=895900 447000 1 0 $X=895900 $Y=441580
X259 2067 666 2025 2 1 2047 QDFFRBN $T=913880 457080 0 180 $X=902100 $Y=451660
X260 2054 666 2062 2 1 2071 QDFFRBN $T=905200 477240 1 0 $X=905200 $Y=471820
X261 2055 666 2062 2 1 2076 QDFFRBN $T=907060 457080 0 0 $X=907060 $Y=456700
X262 2056 666 2088 2 1 2083 QDFFRBN $T=918840 436920 0 0 $X=918840 $Y=436540
X263 2075 666 2088 2 1 2122 QDFFRBN $T=920080 447000 0 0 $X=920080 $Y=446620
X264 2078 666 2084 2 1 2074 QDFFRBN $T=933100 497400 0 180 $X=921320 $Y=491980
X265 2105 666 2084 2 1 704 QDFFRBN $T=938680 477240 1 180 $X=926900 $Y=476860
X266 2106 666 2084 2 1 2070 QDFFRBN $T=938680 487320 0 180 $X=926900 $Y=481900
X267 2107 666 2084 2 1 705 QDFFRBN $T=939300 497400 1 180 $X=927520 $Y=497020
X268 2085 666 2088 2 1 2099 QDFFRBN $T=933720 436920 0 0 $X=933720 $Y=436540
X269 2119 666 2084 2 1 707 QDFFRBN $T=947360 497400 0 180 $X=935580 $Y=491980
X270 2112 666 2084 2 1 716 QDFFRBN $T=944880 497400 0 0 $X=944880 $Y=497020
X271 2140 666 2088 2 1 2120 QDFFRBN $T=958520 436920 1 180 $X=946740 $Y=436540
X272 2126 666 2129 2 1 2121 QDFFRBN $T=961000 457080 1 180 $X=949220 $Y=456700
X273 2132 666 2129 2 1 2137 QDFFRBN $T=953560 467160 0 0 $X=953560 $Y=466780
X274 2115 666 2129 2 1 2117 QDFFRBN $T=954800 447000 0 0 $X=954800 $Y=446620
X275 2127 666 721 2 1 717 QDFFRBN $T=974640 497400 1 180 $X=962860 $Y=497020
X276 2138 666 2129 2 1 2151 QDFFRBN $T=964720 457080 1 0 $X=964720 $Y=451660
X277 2146 666 2129 2 1 2153 QDFFRBN $T=966580 467160 1 0 $X=966580 $Y=461740
X278 2155 666 2088 2 1 2148 QDFFRBN $T=978980 447000 0 180 $X=967200 $Y=441580
X279 1157 172 1 2 INV3 $T=430900 477240 1 0 $X=430900 $Y=471820
X280 1240 1219 1 2 INV3 $T=470580 467160 0 0 $X=470580 $Y=466780
X281 1292 1240 1 2 INV3 $T=471820 457080 0 0 $X=471820 $Y=456700
X282 1372 298 1 2 INV3 $T=512740 426840 0 0 $X=512740 $Y=426460
X283 1433 308 1 2 INV3 $T=538160 447000 1 180 $X=535680 $Y=446620
X284 1439 1314 1 2 INV3 $T=536300 436920 1 0 $X=536300 $Y=431500
X285 786 2 773 1 INV1S $T=226300 457080 0 180 $X=225060 $Y=451660
X286 16 2 771 1 INV1S $T=226920 426840 1 180 $X=225680 $Y=426460
X287 794 2 774 1 INV1S $T=228780 487320 1 180 $X=227540 $Y=486940
X288 774 2 798 1 INV1S $T=237460 487320 0 0 $X=237460 $Y=486940
X289 29 2 11 1 INV1S $T=244280 497400 1 180 $X=243040 $Y=497020
X290 805 2 799 1 INV1S $T=246760 457080 0 0 $X=246760 $Y=456700
X291 809 2 810 1 INV1S $T=247380 477240 1 0 $X=247380 $Y=471820
X292 35 2 14 1 INV1S $T=249240 416760 1 180 $X=248000 $Y=416380
X293 803 2 801 1 INV1S $T=252340 436920 1 0 $X=252340 $Y=431500
X294 819 2 797 1 INV1S $T=253580 457080 0 180 $X=252340 $Y=451660
X295 826 2 832 1 INV1S $T=255440 447000 1 0 $X=255440 $Y=441580
X296 41 2 830 1 INV1S $T=256680 457080 0 0 $X=256680 $Y=456700
X297 821 2 837 1 INV1S $T=260400 447000 1 0 $X=260400 $Y=441580
X298 850 2 842 1 INV1S $T=265360 467160 0 180 $X=264120 $Y=461740
X299 881 2 886 1 INV1S $T=282100 457080 1 0 $X=282100 $Y=451660
X300 798 2 58 1 INV1S $T=284580 497400 1 0 $X=284580 $Y=491980
X301 798 2 892 1 INV1S $T=285200 477240 1 0 $X=285200 $Y=471820
X302 923 2 914 1 INV1S $T=298220 487320 0 180 $X=296980 $Y=481900
X303 921 2 919 1 INV1S $T=300700 487320 1 180 $X=299460 $Y=486940
X304 926 2 925 1 INV1S $T=303180 487320 0 180 $X=301940 $Y=481900
X305 73 2 72 1 INV1S $T=307520 497400 1 180 $X=306280 $Y=497020
X306 936 2 945 1 INV1S $T=317440 447000 0 0 $X=317440 $Y=446620
X307 943 2 961 1 INV1S $T=317440 457080 1 0 $X=317440 $Y=451660
X308 951 2 970 1 INV1S $T=317440 457080 0 0 $X=317440 $Y=456700
X309 88 2 908 1 INV1S $T=326740 487320 1 180 $X=325500 $Y=486940
X310 960 2 994 1 INV1S $T=331700 426840 0 0 $X=331700 $Y=426460
X311 1023 2 1007 1 INV1S $T=342240 467160 1 180 $X=341000 $Y=466780
X312 1033 2 1015 1 INV1S $T=350300 477240 0 180 $X=349060 $Y=471820
X313 1025 2 1017 1 INV1S $T=349680 447000 0 0 $X=349680 $Y=446620
X314 35 2 118 1 INV1S $T=353400 416760 0 0 $X=353400 $Y=416380
X315 1033 2 987 1 INV1S $T=355260 467160 1 180 $X=354020 $Y=466780
X316 1048 2 1021 1 INV1S $T=362080 487320 1 180 $X=360840 $Y=486940
X317 1051 2 1024 1 INV1S $T=363320 477240 0 180 $X=362080 $Y=471820
X318 1056 2 108 1 INV1S $T=367660 477240 1 180 $X=366420 $Y=476860
X319 1060 2 1054 1 INV1S $T=368900 477240 1 180 $X=367660 $Y=476860
X320 1001 2 986 1 INV1S $T=371380 447000 0 0 $X=371380 $Y=446620
X321 133 2 131 1 INV1S $T=375100 416760 0 180 $X=373860 $Y=411340
X322 1078 2 1065 1 INV1S $T=378200 487320 0 180 $X=376960 $Y=481900
X323 135 2 1085 1 INV1S $T=379440 416760 0 0 $X=379440 $Y=416380
X324 965 2 978 1 INV1S $T=380680 436920 0 0 $X=380680 $Y=436540
X325 141 2 1033 1 INV1S $T=384400 477240 1 180 $X=383160 $Y=476860
X326 146 2 1076 1 INV1S $T=389980 457080 1 180 $X=388740 $Y=456700
X327 1092 2 146 1 INV1S $T=388740 477240 0 0 $X=388740 $Y=476860
X328 138 2 1095 1 INV1S $T=391220 426840 1 0 $X=391220 $Y=421420
X329 132 2 141 1 INV1S $T=394320 487320 0 0 $X=394320 $Y=486940
X330 1034 2 150 1 INV1S $T=397420 497400 1 0 $X=397420 $Y=491980
X331 1107 2 1106 1 INV1S $T=401760 436920 1 180 $X=400520 $Y=436540
X332 945 2 1113 1 INV1S $T=401140 457080 1 0 $X=401140 $Y=451660
X333 1118 2 105 1 INV1S $T=403000 497400 1 180 $X=401760 $Y=497020
X334 1112 2 142 1 INV1S $T=403620 467160 1 0 $X=403620 $Y=461740
X335 150 2 155 1 INV1S $T=405480 497400 0 0 $X=405480 $Y=497020
X336 157 2 1118 1 INV1S $T=407960 497400 1 180 $X=406720 $Y=497020
X337 1131 2 1124 1 INV1S $T=409820 416760 1 180 $X=408580 $Y=416380
X338 1131 2 1107 1 INV1S $T=409820 416760 1 0 $X=409820 $Y=411340
X339 1118 2 161 1 INV1S $T=409820 497400 0 0 $X=409820 $Y=497020
X340 1120 2 127 1 INV1S $T=411680 477240 0 180 $X=410440 $Y=471820
X341 170 2 1141 1 INV1S $T=414160 457080 1 0 $X=414160 $Y=451660
X342 1122 2 1133 1 INV1S $T=414780 487320 1 0 $X=414780 $Y=481900
X343 1132 2 1140 1 INV1S $T=416020 416760 0 0 $X=416020 $Y=416380
X344 1132 2 1105 1 INV1S $T=420980 447000 1 180 $X=419740 $Y=446620
X345 1131 2 1165 1 INV1S $T=420360 416760 0 0 $X=420360 $Y=416380
X346 1132 2 179 1 INV1S $T=420980 467160 1 0 $X=420980 $Y=461740
X347 1131 2 1168 1 INV1S $T=423460 416760 1 0 $X=423460 $Y=411340
X348 207 2 210 1 INV1S $T=438960 497400 0 0 $X=438960 $Y=497020
X349 1136 2 1189 1 INV1S $T=444540 426840 0 0 $X=444540 $Y=426460
X350 1241 2 1181 1 INV1S $T=454460 467160 1 180 $X=453220 $Y=466780
X351 1254 2 1217 1 INV1S $T=460040 447000 0 180 $X=458800 $Y=441580
X352 1269 2 1243 1 INV1S $T=462520 447000 0 180 $X=461280 $Y=441580
X353 1243 2 1262 1 INV1S $T=461900 447000 0 0 $X=461900 $Y=446620
X354 187 2 1254 1 INV1S $T=463760 436920 0 180 $X=462520 $Y=431500
X355 1254 2 1267 1 INV1S $T=463140 447000 0 0 $X=463140 $Y=446620
X356 1288 2 1282 1 INV1S $T=470580 447000 0 0 $X=470580 $Y=446620
X357 244 2 1212 1 INV1S $T=476160 416760 0 180 $X=474920 $Y=411340
X358 246 2 1191 1 INV1S $T=478020 477240 1 0 $X=478020 $Y=471820
X359 1305 2 1307 1 INV1S $T=478640 426840 0 0 $X=478640 $Y=426460
X360 1218 2 1288 1 INV1S $T=480500 447000 0 0 $X=480500 $Y=446620
X361 1298 2 268 1 INV1S $T=485460 497400 0 0 $X=485460 $Y=497020
X362 146 2 1313 1 INV1S $T=487940 487320 0 0 $X=487940 $Y=486940
X363 1365 2 1336 1 INV1S $T=504680 477240 0 180 $X=503440 $Y=471820
X364 1314 2 1319 1 INV1S $T=506540 436920 0 180 $X=505300 $Y=431500
X365 1368 2 1365 1 INV1S $T=507780 477240 1 180 $X=506540 $Y=476860
X366 292 2 286 1 INV1S $T=511500 497400 1 180 $X=510260 $Y=497020
X367 296 2 238 1 INV1S $T=512740 467160 0 0 $X=512740 $Y=466780
X368 1357 2 1377 1 INV1S $T=513360 457080 1 0 $X=513360 $Y=451660
X369 1352 2 1405 1 INV1S $T=523900 467160 1 0 $X=523900 $Y=461740
X370 297 2 1382 1 INV1S $T=526380 426840 0 180 $X=525140 $Y=421420
X371 285 2 1409 1 INV1S $T=527000 436920 0 0 $X=527000 $Y=436540
X372 330 2 1356 1 INV1S $T=528860 497400 0 180 $X=527620 $Y=491980
X373 1422 2 1361 1 INV1S $T=530720 436920 1 180 $X=529480 $Y=436540
X374 1421 2 1286 1 INV1S $T=530720 457080 1 180 $X=529480 $Y=456700
X375 318 2 1430 1 INV1S $T=530720 447000 1 0 $X=530720 $Y=441580
X376 1433 2 1305 1 INV1S $T=533820 436920 0 180 $X=532580 $Y=431500
X377 1422 2 1391 1 INV1S $T=532580 457080 0 0 $X=532580 $Y=456700
X378 1405 2 1438 1 INV1S $T=535060 487320 0 0 $X=535060 $Y=486940
X379 1441 2 1448 1 INV1S $T=536300 487320 0 0 $X=536300 $Y=486940
X380 1443 2 1441 1 INV1S $T=538160 487320 0 180 $X=536920 $Y=481900
X381 1433 2 1434 1 INV1S $T=538780 447000 0 180 $X=537540 $Y=441580
X382 1314 2 1444 1 INV1S $T=537540 477240 1 0 $X=537540 $Y=471820
X383 1433 2 1459 1 INV1S $T=541880 447000 1 0 $X=541880 $Y=441580
X384 1454 2 352 1 INV1S $T=543120 497400 0 0 $X=543120 $Y=497020
X385 1458 2 1440 1 INV1S $T=545600 436920 1 180 $X=544360 $Y=436540
X386 1420 2 1466 1 INV1S $T=548080 457080 0 0 $X=548080 $Y=456700
X387 1420 2 1455 1 INV1S $T=549320 457080 1 0 $X=549320 $Y=451660
X388 1475 2 1450 1 INV1S $T=551800 457080 0 180 $X=550560 $Y=451660
X389 363 2 382 1 INV1S $T=563580 497400 0 180 $X=562340 $Y=491980
X390 381 2 1478 1 INV1S $T=564200 426840 1 180 $X=562960 $Y=426460
X391 382 2 1500 1 INV1S $T=566060 497400 0 180 $X=564820 $Y=491980
X392 1496 2 1517 1 INV1S $T=569160 436920 1 0 $X=569160 $Y=431500
X393 404 2 400 1 INV1S $T=585900 497400 0 180 $X=584660 $Y=491980
X394 1510 2 1550 1 INV1S $T=586520 477240 0 0 $X=586520 $Y=476860
X395 383 2 1545 1 INV1S $T=591480 477240 0 0 $X=591480 $Y=476860
X396 1559 2 1571 1 INV1S $T=597060 467160 0 0 $X=597060 $Y=466780
X397 1525 2 1582 1 INV1S $T=601400 477240 0 0 $X=601400 $Y=476860
X398 420 2 1577 1 INV1S $T=601400 487320 0 0 $X=601400 $Y=486940
X399 1564 2 1581 1 INV1S $T=602640 487320 0 0 $X=602640 $Y=486940
X400 1533 2 1597 1 INV1S $T=607600 477240 1 0 $X=607600 $Y=471820
X401 1597 2 1587 1 INV1S $T=611940 477240 1 180 $X=610700 $Y=476860
X402 1597 2 1599 1 INV1S $T=611940 477240 0 0 $X=611940 $Y=476860
X403 436 2 1610 1 INV1S $T=620000 416760 1 0 $X=620000 $Y=411340
X404 1614 2 441 1 INV1S $T=621860 426840 1 180 $X=620620 $Y=426460
X405 1622 2 1619 1 INV1S $T=626820 426840 1 180 $X=625580 $Y=426460
X406 1590 2 1614 1 INV1S $T=625580 467160 1 0 $X=625580 $Y=461740
X407 450 2 1622 1 INV1S $T=630540 467160 1 0 $X=630540 $Y=461740
X408 1627 2 1635 1 INV1S $T=631780 467160 1 0 $X=631780 $Y=461740
X409 1633 2 1631 1 INV1S $T=633020 447000 1 0 $X=633020 $Y=441580
X410 421 2 463 1 INV1S $T=634260 447000 1 0 $X=634260 $Y=441580
X411 1643 2 453 1 INV1S $T=637980 447000 1 180 $X=636740 $Y=446620
X412 1643 2 1645 1 INV1S $T=639220 447000 1 180 $X=637980 $Y=446620
X413 1639 2 1649 1 INV1S $T=637980 457080 1 0 $X=637980 $Y=451660
X414 1574 2 477 1 INV1S $T=639840 436920 0 0 $X=639840 $Y=436540
X415 455 2 1653 1 INV1S $T=640460 447000 0 0 $X=640460 $Y=446620
X416 1539 2 1652 1 INV1S $T=641080 467160 1 0 $X=641080 $Y=461740
X417 1653 2 1643 1 INV1S $T=641700 447000 0 0 $X=641700 $Y=446620
X418 302 2 1663 1 INV1S $T=646040 447000 0 0 $X=646040 $Y=446620
X419 352 2 476 1 INV1S $T=646660 467160 0 0 $X=646660 $Y=466780
X420 302 2 1669 1 INV1S $T=647280 447000 0 0 $X=647280 $Y=446620
X421 1679 2 1672 1 INV1S $T=653480 497400 0 180 $X=652240 $Y=491980
X422 1702 2 1694 1 INV1S $T=665880 447000 0 180 $X=664640 $Y=441580
X423 1717 2 1690 1 INV1S $T=671460 447000 0 180 $X=670220 $Y=441580
X424 1719 2 1717 1 INV1S $T=673320 426840 0 0 $X=673320 $Y=426460
X425 1728 2 1703 1 INV1S $T=675180 436920 0 0 $X=675180 $Y=436540
X426 1614 2 1732 1 INV1S $T=675800 426840 0 0 $X=675800 $Y=426460
X427 1614 2 1736 1 INV1S $T=677040 467160 0 0 $X=677040 $Y=466780
X428 1720 2 1738 1 INV1S $T=679520 436920 0 180 $X=678280 $Y=431500
X429 1740 2 1739 1 INV1S $T=678900 467160 0 0 $X=678900 $Y=466780
X430 1728 2 503 1 INV1S $T=679520 426840 0 0 $X=679520 $Y=426460
X431 1738 2 1728 1 INV1S $T=679520 436920 1 0 $X=679520 $Y=431500
X432 1739 2 1691 1 INV1S $T=679520 457080 0 0 $X=679520 $Y=456700
X433 1728 2 1742 1 INV1S $T=682000 447000 1 0 $X=682000 $Y=441580
X434 1751 2 1729 1 INV1S $T=685720 426840 1 0 $X=685720 $Y=421420
X435 1754 2 506 1 INV1S $T=688200 497400 0 0 $X=688200 $Y=497020
X436 496 2 1767 1 INV1S $T=690680 467160 1 0 $X=690680 $Y=461740
X437 1774 2 507 1 INV1S $T=692540 497400 1 180 $X=691300 $Y=497020
X438 1777 2 1782 1 INV1S $T=694400 497400 0 0 $X=694400 $Y=497020
X439 1773 2 1783 1 INV1S $T=696260 477240 0 0 $X=696260 $Y=476860
X440 1785 2 1787 1 INV1S $T=697500 477240 0 0 $X=697500 $Y=476860
X441 503 2 513 1 INV1S $T=701220 426840 1 0 $X=701220 $Y=421420
X442 1752 2 1795 1 INV1S $T=703080 497400 1 0 $X=703080 $Y=491980
X443 514 2 1788 1 INV1S $T=703700 426840 1 0 $X=703700 $Y=421420
X444 1674 2 1798 1 INV1S $T=705560 477240 0 0 $X=705560 $Y=476860
X445 1804 2 1810 1 INV1S $T=709280 447000 0 0 $X=709280 $Y=446620
X446 1805 2 1813 1 INV1S $T=711140 457080 0 0 $X=711140 $Y=456700
X447 1792 2 1814 1 INV1S $T=712380 467160 0 0 $X=712380 $Y=466780
X448 1808 2 1812 1 INV1S $T=712380 477240 1 0 $X=712380 $Y=471820
X449 1607 2 1809 1 INV1S $T=713000 436920 0 0 $X=713000 $Y=436540
X450 1791 2 1817 1 INV1S $T=714240 457080 1 0 $X=714240 $Y=451660
X451 1521 2 516 1 INV1S $T=716720 426840 0 180 $X=715480 $Y=421420
X452 1835 2 1845 1 INV1S $T=731600 416760 0 0 $X=731600 $Y=416380
X453 1837 2 1827 1 INV1S $T=732840 467160 1 0 $X=732840 $Y=461740
X454 1820 2 1826 1 INV1S $T=732840 487320 0 0 $X=732840 $Y=486940
X455 1851 2 1854 1 INV1S $T=735320 416760 0 0 $X=735320 $Y=416380
X456 1862 2 1858 1 INV1S $T=739660 447000 0 180 $X=738420 $Y=441580
X457 1856 2 1866 1 INV1S $T=744000 447000 1 0 $X=744000 $Y=441580
X458 458 2 569 1 INV1S $T=784300 426840 1 0 $X=784300 $Y=421420
X459 1842 2 572 1 INV1S $T=786160 416760 0 0 $X=786160 $Y=416380
X460 430 2 1914 1 INV1S $T=791740 457080 0 0 $X=791740 $Y=456700
X461 1914 2 585 1 INV1S $T=793600 436920 1 0 $X=793600 $Y=431500
X462 1732 2 591 1 INV1S $T=800420 416760 1 0 $X=800420 $Y=411340
X463 587 2 599 1 INV1S $T=803520 487320 0 0 $X=803520 $Y=486940
X464 520 2 530 1 INV1S $T=804140 416760 1 0 $X=804140 $Y=411340
X465 603 2 1929 1 INV1S $T=807240 487320 0 0 $X=807240 $Y=486940
X466 1842 2 613 1 INV1S $T=809720 426840 0 0 $X=809720 $Y=426460
X467 1928 2 605 1 INV1S $T=809720 497400 0 0 $X=809720 $Y=497020
X468 422 2 611 1 INV1S $T=812200 426840 1 0 $X=812200 $Y=421420
X469 1521 2 619 1 INV1S $T=815920 426840 0 0 $X=815920 $Y=426460
X470 599 2 1938 1 INV1S $T=819020 447000 1 0 $X=819020 $Y=441580
X471 1943 2 1947 1 INV1S $T=824600 487320 1 0 $X=824600 $Y=481900
X472 579 2 620 1 INV1S $T=826460 426840 1 180 $X=825220 $Y=426460
X473 1934 2 1949 1 INV1S $T=827700 416760 0 0 $X=827700 $Y=416380
X474 633 2 635 1 INV1S $T=832040 416760 1 0 $X=832040 $Y=411340
X475 1953 2 1955 1 INV1S $T=832660 497400 1 0 $X=832660 $Y=491980
X476 1963 2 1968 1 INV1S $T=837620 477240 0 0 $X=837620 $Y=476860
X477 1966 2 1974 1 INV1S $T=842580 436920 0 0 $X=842580 $Y=436540
X478 1976 2 2007 1 INV1S $T=848160 436920 0 0 $X=848160 $Y=436540
X479 1960 2 1991 1 INV1S $T=848160 447000 1 0 $X=848160 $Y=441580
X480 1972 2 1980 1 INV1S $T=848160 477240 1 0 $X=848160 $Y=471820
X481 1993 2 1996 1 INV1S $T=860560 487320 1 0 $X=860560 $Y=481900
X482 2010 2 2016 1 INV1S $T=872340 477240 0 0 $X=872340 $Y=476860
X483 2052 2 2050 1 INV1S $T=905820 416760 0 180 $X=904580 $Y=411340
X484 2046 2 2063 1 INV1S $T=906440 487320 0 0 $X=906440 $Y=486940
X485 2061 2 2053 1 INV1S $T=908920 477240 1 180 $X=907680 $Y=476860
X486 2059 2 2065 1 INV1S $T=910780 416760 0 0 $X=910780 $Y=416380
X487 1992 2 2075 1 INV1S $T=913880 447000 1 0 $X=913880 $Y=441580
X488 2091 2 2068 1 INV1S $T=917600 416760 1 180 $X=916360 $Y=416380
X489 2025 2 2072 1 INV1S $T=916360 457080 1 0 $X=916360 $Y=451660
X490 2072 2 2062 1 INV1S $T=920700 457080 0 180 $X=919460 $Y=451660
X491 2072 2 2088 1 INV1S $T=922560 457080 1 0 $X=922560 $Y=451660
X492 2080 2 2073 1 INV1S $T=925040 426840 0 0 $X=925040 $Y=426460
X493 2089 2 2069 1 INV1S $T=928140 426840 1 180 $X=926900 $Y=426460
X494 2087 2 2098 1 INV1S $T=931240 426840 0 0 $X=931240 $Y=426460
X495 2094 2 2103 1 INV1S $T=934960 426840 1 0 $X=934960 $Y=421420
X496 2109 2 2113 1 INV1S $T=941160 426840 1 0 $X=941160 $Y=421420
X497 2121 2 2093 1 INV1S $T=947980 467160 0 180 $X=946740 $Y=461740
X498 2123 2 2110 1 INV1S $T=948600 416760 1 180 $X=947360 $Y=416380
X499 715 2 2131 1 INV1S $T=952320 426840 0 0 $X=952320 $Y=426460
X500 2125 2 2135 1 INV1S $T=954180 416760 0 0 $X=954180 $Y=416380
X501 2117 2 2128 1 INV1S $T=959760 477240 0 180 $X=958520 $Y=471820
X502 2124 2 2118 1 INV1S $T=958520 477240 0 0 $X=958520 $Y=476860
X503 2137 2 2130 1 INV1S $T=959760 487320 0 180 $X=958520 $Y=481900
X504 720 2 2140 1 INV1S $T=964720 436920 1 180 $X=963480 $Y=436540
X505 2151 2 2142 1 INV1S $T=968440 467160 1 180 $X=967200 $Y=466780
X506 2148 2 2139 1 INV1S $T=968440 497400 0 180 $X=967200 $Y=491980
X507 2154 2 2146 1 INV1S $T=971540 436920 1 180 $X=970300 $Y=436540
X508 728 2 2150 1 INV1S $T=976500 416760 1 180 $X=975260 $Y=416380
X509 46 37 2 38 43 1 811 FA1 $T=264120 416760 0 180 $X=248620 $Y=411340
X510 839 828 2 820 847 1 816 FA1 $T=266600 426840 0 180 $X=251100 $Y=421420
X511 827 843 2 853 836 1 860 FA1 $T=255440 477240 0 0 $X=255440 $Y=476860
X512 851 839 2 811 48 1 831 FA1 $T=272800 416760 1 180 $X=257300 $Y=416380
X513 57 862 2 858 874 1 847 FA1 $T=282720 426840 0 180 $X=267220 $Y=421420
X514 67 890 2 885 907 1 874 FA1 $T=296360 416760 1 180 $X=280860 $Y=416380
X515 917 912 2 909 924 1 898 FA1 $T=306900 447000 1 180 $X=291400 $Y=446620
X516 895 928 2 927 925 1 902 FA1 $T=293880 477240 0 0 $X=293880 $Y=476860
X517 1083 1093 2 1079 1068 1 1101 FA1 $T=381300 497400 0 0 $X=381300 $Y=497020
X518 1640 1644 2 1635 1648 1 1674 FA1 $T=636120 477240 0 0 $X=636120 $Y=476860
X519 1678 1634 2 1649 1655 1 1648 FA1 $T=655340 457080 0 180 $X=639840 $Y=451660
X520 1689 1662 2 1660 483 1 1651 FA1 $T=656580 436920 0 180 $X=641080 $Y=431500
X521 1802 1783 2 1787 1800 1 1776 FA1 $T=709900 487320 1 180 $X=694400 $Y=486940
X522 1818 1782 2 1795 1776 1 512 FA1 $T=713620 497400 1 180 $X=698120 $Y=497020
X523 1797 1779 2 1789 1756 1 1830 FA1 $T=706180 447000 1 0 $X=706180 $Y=441580
X524 1834 1812 2 1814 1807 1 1800 FA1 $T=724780 477240 1 180 $X=709280 $Y=476860
X525 1846 1813 2 1817 1811 1 1807 FA1 $T=725400 467160 0 180 $X=709900 $Y=461740
X526 1839 1775 2 1810 1830 1 1811 FA1 $T=727260 447000 1 180 $X=711760 $Y=446620
X527 1857 1833 2 1827 1850 1 1820 FA1 $T=735320 477240 0 180 $X=719820 $Y=471820
X528 1838 1857 2 1834 1640 1 1872 FA1 $T=727260 477240 0 0 $X=727260 $Y=476860
X529 1867 1863 2 1866 1873 1 1850 FA1 $T=753300 457080 0 180 $X=737800 $Y=451660
X530 1884 1877 2 1868 1889 1 1873 FA1 $T=762600 447000 0 180 $X=747100 $Y=441580
X531 545 542 2 1880 1882 1 539 FA1 $T=764460 497400 1 180 $X=748960 $Y=497020
X532 1887 1881 2 541 540 1 1875 FA1 $T=765080 416760 0 180 $X=749580 $Y=411340
X533 1879 1878 2 1874 1875 1 1889 FA1 $T=753920 426840 0 0 $X=753920 $Y=426460
X534 552 1892 2 1871 1895 1 1882 FA1 $T=772520 497400 0 180 $X=757020 $Y=491980
X535 554 1894 2 1886 1897 1 1888 FA1 $T=775000 467160 1 180 $X=759500 $Y=466780
X536 560 1899 2 1891 1888 1 1895 FA1 $T=778720 477240 1 180 $X=763220 $Y=476860
X537 564 550 2 1900 557 1 1898 FA1 $T=780580 416760 0 180 $X=765080 $Y=411340
X538 561 1902 2 1904 1905 1 1897 FA1 $T=780580 457080 1 180 $X=765080 $Y=456700
X539 577 1907 2 1908 1898 1 1905 FA1 $T=789880 436920 1 180 $X=774380 $Y=436540
X540 648 656 2 1994 1989 1 2004 FA1 $T=845680 497400 1 0 $X=845680 $Y=491980
X541 2014 2001 2 1991 1997 1 1992 FA1 $T=871100 447000 0 180 $X=855600 $Y=441580
X542 2035 1986 2 2007 2003 1 1997 FA1 $T=876060 436920 0 180 $X=860560 $Y=431500
X543 2021 2000 2 1995 2005 1 2003 FA1 $T=877300 426840 1 180 $X=861800 $Y=426460
X544 660 669 2 2009 2018 1 2022 FA1 $T=863040 497400 1 0 $X=863040 $Y=491980
X545 672 2011 2 665 661 1 2005 FA1 $T=879160 416760 0 180 $X=863660 $Y=411340
X546 2015 2029 2 2031 2017 1 2034 FA1 $T=874820 447000 1 0 $X=874820 $Y=441580
X547 2040 2024 2 2023 679 1 2017 FA1 $T=892800 426840 0 180 $X=877300 $Y=421420
X548 2020 1929 2 2037 2026 1 2046 FA1 $T=880400 487320 1 0 $X=880400 $Y=481900
X549 2032 2043 2 2033 2034 1 2051 FA1 $T=888460 457080 0 0 $X=888460 $Y=456700
X550 2038 2048 2 2047 2051 1 2058 FA1 $T=892180 467160 1 0 $X=892180 $Y=461740
X551 2039 2050 2 687 683 1 2057 FA1 $T=894040 416760 0 0 $X=894040 $Y=416380
X552 2049 2068 2 2065 2057 1 2077 FA1 $T=906440 426840 1 0 $X=906440 $Y=421420
X553 2056 2069 2 2073 2077 1 2082 FA1 $T=907060 436920 1 0 $X=907060 $Y=431500
X554 2054 2076 2 2079 2058 1 2086 FA1 $T=910780 467160 1 0 $X=910780 $Y=461740
X555 692 699 2 2074 2060 1 703 FA1 $T=910780 497400 0 0 $X=910780 $Y=497020
X556 2078 2093 2 2096 2090 1 2108 FA1 $T=921320 477240 1 0 $X=921320 $Y=471820
X557 2085 2103 2 2098 2082 1 2114 FA1 $T=925660 436920 1 0 $X=925660 $Y=431500
X558 2106 2097 2 2102 2086 1 2090 FA1 $T=944880 467160 0 180 $X=929380 $Y=461740
X559 2126 2110 2 2113 2114 1 2100 FA1 $T=951080 426840 1 180 $X=935580 $Y=426460
X560 2105 2121 2 2128 2108 1 2134 FA1 $T=939920 477240 1 0 $X=939920 $Y=471820
X561 2119 2117 2 2118 2134 1 2111 FA1 $T=956040 477240 1 180 $X=940540 $Y=476860
X562 2112 2124 2 2130 2111 1 2133 FA1 $T=940540 487320 1 0 $X=940540 $Y=481900
X563 2115 2131 2 2135 2100 1 2136 FA1 $T=943640 436920 1 0 $X=943640 $Y=431500
X564 2127 2137 2 2139 2133 1 2143 FA1 $T=951080 497400 1 0 $X=951080 $Y=491980
X565 2116 724 2 726 2136 1 2147 FA1 $T=960380 426840 1 0 $X=960380 $Y=421420
X566 2138 2150 2 725 2149 1 2154 FA1 $T=961620 436920 1 0 $X=961620 $Y=431500
X567 718 2142 2 2148 2143 1 2152 FA1 $T=962860 487320 1 0 $X=962860 $Y=481900
X568 778 2 3 15 779 1 790 FA1S $T=220720 447000 1 0 $X=220720 $Y=441580
X569 779 2 771 17 776 1 795 FA1S $T=221340 436920 1 0 $X=221340 $Y=431500
X570 776 2 773 18 7 1 788 FA1S $T=221340 457080 0 0 $X=221340 $Y=456700
X571 780 2 9 19 778 1 796 FA1S $T=221960 467160 0 0 $X=221960 $Y=466780
X572 782 2 5 8 780 1 781 FA1S $T=223820 477240 1 0 $X=223820 $Y=471820
X573 20 2 23 26 782 1 775 FA1S $T=236220 497400 1 180 $X=224440 $Y=497020
X574 813 2 807 804 823 1 826 FA1S $T=244900 436920 0 0 $X=244900 $Y=436540
X575 815 2 814 806 822 1 829 FA1S $T=244900 487320 0 0 $X=244900 $Y=486940
X576 34 2 39 808 815 1 861 FA1S $T=245520 497400 0 0 $X=245520 $Y=497020
X577 824 2 833 817 813 1 843 FA1S $T=250480 467160 1 0 $X=250480 $Y=461740
X578 836 2 816 845 840 1 821 FA1S $T=265980 457080 0 180 $X=254200 $Y=451660
X579 822 2 818 825 866 1 833 FA1S $T=254820 467160 0 0 $X=254820 $Y=466780
X580 44 2 829 854 824 1 846 FA1S $T=258540 487320 0 0 $X=258540 $Y=486940
X581 850 2 837 832 872 1 857 FA1S $T=262260 447000 1 0 $X=262260 $Y=441580
X582 55 2 879 861 873 1 50 FA1S $T=282100 497400 0 180 $X=270320 $Y=491980
X583 870 2 865 871 875 1 840 FA1S $T=282720 457080 1 180 $X=270940 $Y=456700
X584 873 2 884 834 878 1 854 FA1S $T=283960 487320 1 180 $X=272180 $Y=486940
X585 878 2 812 887 870 1 853 FA1S $T=285200 477240 1 180 $X=273420 $Y=476860
X586 872 2 886 863 869 1 859 FA1S $T=274040 447000 0 0 $X=274040 $Y=446620
X587 866 2 877 895 893 1 871 FA1S $T=289540 467160 1 180 $X=277760 $Y=466780
X588 894 2 883 917 896 1 862 FA1S $T=291400 436920 0 180 $X=279620 $Y=431500
X589 823 2 891 904 894 1 881 FA1S $T=293880 447000 0 180 $X=282100 $Y=441580
X590 62 2 59 70 903 1 879 FA1S $T=293880 497400 1 180 $X=282100 $Y=497020
X591 899 2 905 914 902 1 887 FA1S $T=294500 487320 0 180 $X=282720 $Y=481900
X592 875 2 889 901 898 1 904 FA1S $T=283340 457080 0 0 $X=283340 $Y=456700
X593 903 2 897 919 899 1 884 FA1S $T=297600 487320 1 180 $X=285820 $Y=486940
X594 896 2 910 900 911 1 890 FA1S $T=300080 426840 1 180 $X=288300 $Y=426460
X595 893 2 920 941 913 1 901 FA1S $T=302560 467160 1 180 $X=290780 $Y=466780
X596 924 2 937 938 916 1 900 FA1S $T=305660 447000 0 180 $X=293880 $Y=441580
X597 71 2 68 915 934 1 74 FA1S $T=296360 416760 1 0 $X=296360 $Y=411340
X598 907 2 922 942 931 1 915 FA1S $T=309380 416760 1 180 $X=297600 $Y=416380
X599 913 2 946 950 918 1 912 FA1S $T=310620 457080 1 180 $X=298840 $Y=456700
X600 911 2 932 948 929 1 942 FA1S $T=301320 436920 1 0 $X=301320 $Y=431500
X601 940 2 76 955 952 1 923 FA1S $T=314960 487320 0 180 $X=303180 $Y=481900
X602 75 2 956 982 940 1 921 FA1S $T=314960 487320 1 180 $X=303180 $Y=486940
X603 928 2 971 966 968 1 941 FA1S $T=320540 477240 0 180 $X=308760 $Y=471820
X604 934 2 944 969 953 1 82 FA1S $T=309380 416760 1 0 $X=309380 $Y=411340
X605 952 2 988 983 78 1 926 FA1S $T=323020 477240 1 180 $X=311240 $Y=476860
X606 931 2 962 980 947 1 953 FA1S $T=325500 426840 0 180 $X=313720 $Y=421420
X607 969 2 958 963 954 1 984 FA1S $T=314340 416760 0 0 $X=314340 $Y=416380
X608 992 2 1000 1004 991 1 1013 FA1S $T=324880 436920 0 0 $X=324880 $Y=436540
X609 98 2 990 984 992 1 1020 FA1S $T=327980 416760 0 0 $X=327980 $Y=416380
X610 1005 2 997 1007 1006 1 955 FA1S $T=340380 487320 0 180 $X=328600 $Y=481900
X611 102 2 103 1021 1014 1 99 FA1S $T=344100 497400 1 180 $X=332320 $Y=497020
X612 1014 2 100 1024 1005 1 982 FA1S $T=345960 497400 0 180 $X=334180 $Y=491980
X613 1028 2 1035 1022 1016 1 1041 FA1S $T=342240 447000 1 0 $X=342240 $Y=441580
X614 1053 2 116 1054 976 1 114 FA1S $T=367660 497400 1 180 $X=355880 $Y=497020
X615 1058 2 1036 127 117 1 1049 FA1S $T=372620 416760 0 180 $X=360840 $Y=411340
X616 1068 2 123 1065 1053 1 1067 FA1S $T=368900 497400 1 0 $X=368900 $Y=491980
X617 1620 2 1612 1615 1618 1 1633 FA1S $T=621240 447000 1 0 $X=621240 $Y=441580
X618 1625 2 446 1610 449 1 1637 FA1S $T=622480 416760 1 0 $X=622480 $Y=411340
X619 1627 2 1620 1632 1626 1 1639 FA1S $T=624960 457080 0 0 $X=624960 $Y=456700
X620 1634 2 1642 1631 1636 1 1646 FA1S $T=628680 436920 1 0 $X=628680 $Y=431500
X621 1642 2 470 1647 1628 1 1630 FA1S $T=642320 426840 0 180 $X=630540 $Y=421420
X622 1636 2 1630 1629 460 1 1656 FA1S $T=630540 426840 0 0 $X=630540 $Y=426460
X623 1655 2 1661 1646 1651 1 1681 FA1S $T=637360 447000 1 0 $X=637360 $Y=441580
X624 1660 2 1657 1637 472 1 482 FA1S $T=641080 416760 1 0 $X=641080 $Y=411340
X625 1670 2 1680 1686 481 1 1657 FA1S $T=655340 426840 0 180 $X=643560 $Y=421420
X626 1661 2 1670 1656 1625 1 1662 FA1S $T=646040 426840 0 0 $X=646040 $Y=426460
X627 480 2 1672 1677 1668 1 485 FA1S $T=646660 497400 0 0 $X=646660 $Y=497020
X628 489 2 1679 1682 1687 1 1705 FA1S $T=655340 497400 1 0 $X=655340 $Y=491980
X629 1733 2 1722 1725 1724 1 1759 FA1S $T=673940 497400 1 0 $X=673940 $Y=491980
X630 501 2 1716 1733 1705 1 1754 FA1S $T=674560 497400 0 0 $X=674560 $Y=497020
X631 1743 2 1730 1699 1734 1 1763 FA1S $T=675800 467160 1 0 $X=675800 $Y=461740
X632 1746 2 1721 1704 1747 1 1757 FA1S $T=677040 477240 0 0 $X=677040 $Y=476860
X633 1752 2 1741 1743 1757 1 1773 FA1S $T=680760 487320 0 0 $X=680760 $Y=486940
X634 1774 2 1713 1746 1759 1 1777 FA1S $T=688820 497400 1 0 $X=688820 $Y=491980
X635 1791 2 1780 1731 1761 1 1804 FA1S $T=696260 457080 1 0 $X=696260 $Y=451660
X636 1792 2 1784 1758 1772 1 1805 FA1S $T=698120 467160 1 0 $X=698120 $Y=461740
X637 1785 2 1768 1763 1796 1 1808 FA1S $T=698740 477240 1 0 $X=698740 $Y=471820
X638 1803 2 1794 1799 1801 1 1821 FA1S $T=704320 426840 0 0 $X=704320 $Y=426460
X639 1816 2 521 517 1806 1 1824 FA1S $T=709900 416760 0 0 $X=709900 $Y=416380
X640 1832 2 1815 1841 523 1 1844 FA1S $T=719820 426840 0 0 $X=719820 $Y=426460
X641 1835 2 1822 1829 1840 1 1851 FA1S $T=721680 416760 1 0 $X=721680 $Y=411340
X642 1836 2 1821 1847 1816 1 1855 FA1S $T=722920 436920 1 0 $X=722920 $Y=431500
X643 1837 2 1848 1831 1825 1 1856 FA1S $T=722920 457080 1 0 $X=722920 $Y=451660
X644 1848 2 1823 1843 1852 1 1862 FA1S $T=729120 447000 0 0 $X=729120 $Y=446620
X645 1853 2 1824 1845 528 1 1865 FA1S $T=730980 426840 1 0 $X=730980 $Y=421420
X646 1860 2 1846 1867 1678 1 1861 FA1S $T=734700 457080 0 0 $X=734700 $Y=456700
X647 1863 2 1803 1858 1836 1 1877 FA1S $T=737180 436920 0 0 $X=737180 $Y=436540
X648 1864 2 535 1854 534 1 537 FA1S $T=737800 416760 1 0 $X=737800 $Y=411340
X649 1868 2 1832 1855 1853 1 1878 FA1S $T=739660 426840 0 0 $X=739660 $Y=426460
X650 1874 2 1844 1865 1864 1 1881 FA1S $T=744000 426840 1 0 $X=744000 $Y=421420
X651 1876 2 1839 1884 1681 1 1890 FA1S $T=748960 447000 0 0 $X=748960 $Y=446620
X652 1883 2 1797 1879 1689 1 1896 FA1S $T=751440 436920 1 0 $X=751440 $Y=431500
X653 1893 2 1790 1887 544 1 1901 FA1S $T=758260 426840 1 0 $X=758260 $Y=421420
X654 1934 2 1927 1931 1932 1 622 FA1S $T=812820 416760 0 0 $X=812820 $Y=416380
X655 1944 2 1941 1940 1935 1 1966 FA1S $T=819640 436920 0 0 $X=819640 $Y=436540
X656 1960 2 1944 1952 1951 1 1976 FA1S $T=830800 447000 1 0 $X=830800 $Y=441580
X657 1965 2 1954 1962 1958 1 1975 FA1S $T=833280 426840 0 0 $X=833280 $Y=426460
X658 1970 2 1956 644 1977 1 1979 FA1S $T=837620 416760 0 0 $X=837620 $Y=416380
X659 1973 2 1975 1950 1970 1 1982 FA1S $T=838860 426840 1 0 $X=838860 $Y=421420
X660 1986 2 1965 1974 1973 1 2000 FA1S $T=848160 426840 0 0 $X=848160 $Y=426460
X661 1990 2 1979 1949 653 1 659 FA1S $T=850640 416760 1 0 $X=850640 $Y=411340
X662 1995 2 652 1982 1990 1 2011 FA1S $T=851880 426840 1 0 $X=851880 $Y=421420
X663 2028 2 675 2021 677 1 2036 FA1S $T=879160 426840 0 0 $X=879160 $Y=426460
X664 2026 2 2019 673 2030 1 682 FA1S $T=880400 497400 1 0 $X=880400 $Y=491980
X665 2030 2 2027 674 2022 1 681 FA1S $T=881020 497400 0 0 $X=881020 $Y=497020
X666 2042 2 2039 2035 690 1 2045 FA1S $T=892800 436920 1 0 $X=892800 $Y=431500
X667 2059 2 693 691 694 1 2052 FA1S $T=905820 416760 1 0 $X=905820 $Y=411340
X668 2060 2 2070 689 2064 1 697 FA1S $T=907680 497400 1 0 $X=907680 $Y=491980
X669 2080 2 696 700 698 1 2091 FA1S $T=918840 416760 1 0 $X=918840 $Y=411340
X670 2087 2 702 701 706 1 2089 FA1S $T=921940 426840 1 0 $X=921940 $Y=421420
X671 2109 2 711 708 710 1 2094 FA1S $T=943640 416760 0 180 $X=931860 $Y=411340
X672 2125 2 712 713 714 1 2123 FA1S $T=946740 416760 1 0 $X=946740 $Y=411340
X673 2144 2 719 722 2147 1 2132 FA1S $T=970920 416760 1 180 $X=959140 $Y=416380
X674 2149 2 727 728 2144 1 2155 FA1S $T=966580 416760 1 0 $X=966580 $Y=411340
X675 31 2 804 801 1 NR2 $T=248000 426840 1 180 $X=246140 $Y=426460
X676 32 2 807 797 1 NR2 $T=248000 436920 0 180 $X=246140 $Y=431500
X677 31 2 812 797 1 NR2 $T=248620 457080 0 180 $X=246760 $Y=451660
X678 32 2 814 11 1 NR2 $T=251100 497400 0 180 $X=249240 $Y=491980
X679 32 2 828 801 1 NR2 $T=251720 426840 0 0 $X=251720 $Y=426460
X680 36 2 818 800 1 NR2 $T=253580 467160 1 180 $X=251720 $Y=466780
X681 32 2 825 810 1 NR2 $T=251720 477240 1 0 $X=251720 $Y=471820
X682 31 2 806 810 1 NR2 $T=251720 487320 1 0 $X=251720 $Y=481900
X683 36 2 820 13 1 NR2 $T=252340 416760 0 0 $X=252340 $Y=416380
X684 835 2 841 831 1 NR2 $T=262260 436920 0 180 $X=260400 $Y=431500
X685 848 2 852 851 1 NR2 $T=269700 426840 0 0 $X=269700 $Y=426460
X686 53 2 863 42 1 NR2 $T=274040 457080 0 180 $X=272180 $Y=451660
X687 54 2 865 33 1 NR2 $T=277140 467160 0 180 $X=275280 $Y=461740
X688 60 2 858 13 1 NR2 $T=280240 416760 0 180 $X=278380 $Y=411340
X689 60 2 877 800 1 NR2 $T=283340 467160 0 180 $X=281480 $Y=461740
X690 888 2 883 33 1 NR2 $T=285820 426840 1 180 $X=283960 $Y=426460
X691 888 2 885 13 1 NR2 $T=285200 426840 1 0 $X=285200 $Y=421420
X692 888 2 889 800 1 NR2 $T=288920 457080 0 180 $X=287060 $Y=451660
X693 60 2 891 33 1 NR2 $T=287680 447000 0 0 $X=287680 $Y=446620
X694 54 2 897 58 1 NR2 $T=287680 497400 1 0 $X=287680 $Y=491980
X695 908 2 918 892 1 NR2 $T=295120 467160 0 180 $X=293260 $Y=461740
X696 60 2 905 892 1 NR2 $T=293880 477240 1 0 $X=293880 $Y=471820
X697 908 2 916 800 1 NR2 $T=294500 436920 0 0 $X=294500 $Y=436540
X698 69 2 910 33 1 NR2 $T=298220 426840 0 180 $X=296360 $Y=421420
X699 69 2 909 800 1 NR2 $T=298220 457080 1 180 $X=296360 $Y=456700
X700 69 2 920 892 1 NR2 $T=299460 467160 1 0 $X=299460 $Y=461740
X701 63 2 927 892 1 NR2 $T=299460 477240 1 0 $X=299460 $Y=471820
X702 33 2 929 908 1 NR2 $T=300080 436920 0 0 $X=300080 $Y=436540
X703 69 2 922 13 1 NR2 $T=301940 426840 1 0 $X=301940 $Y=421420
X704 908 2 947 13 1 NR2 $T=307520 426840 0 180 $X=305660 $Y=421420
X705 945 2 938 933 1 NR2 $T=310000 447000 0 180 $X=308140 $Y=441580
X706 908 2 954 30 1 NR2 $T=310620 426840 1 0 $X=310620 $Y=421420
X707 69 2 944 30 1 NR2 $T=311240 416760 0 0 $X=311240 $Y=416380
X708 961 2 950 939 1 NR2 $T=314340 457080 1 180 $X=312480 $Y=456700
X709 970 2 966 949 1 NR2 $T=319300 467160 1 180 $X=317440 $Y=466780
X710 978 2 948 964 1 NR2 $T=323640 426840 1 180 $X=321780 $Y=426460
X711 83 2 976 72 1 NR2 $T=322400 487320 1 0 $X=322400 $Y=481900
X712 64 2 86 61 1 NR2 $T=323020 416760 1 0 $X=323020 $Y=411340
X713 986 2 963 974 1 NR2 $T=324880 436920 0 180 $X=323020 $Y=431500
X714 87 2 991 799 1 NR2 $T=324880 447000 0 180 $X=323020 $Y=441580
X715 87 2 968 72 1 NR2 $T=324880 467160 1 180 $X=323020 $Y=466780
X716 994 2 980 957 1 NR2 $T=327360 426840 1 180 $X=325500 $Y=426460
X717 87 2 983 89 1 NR2 $T=326120 487320 1 0 $X=326120 $Y=481900
X718 77 2 990 61 1 NR2 $T=330460 426840 0 180 $X=328600 $Y=421420
X719 95 2 979 89 1 NR2 $T=331080 477240 1 180 $X=329220 $Y=476860
X720 77 2 997 89 1 NR2 $T=333560 497400 0 180 $X=331700 $Y=491980
X721 77 2 1012 830 1 NR2 $T=334800 436920 1 0 $X=334800 $Y=431500
X722 64 2 1019 830 1 NR2 $T=335420 426840 1 0 $X=335420 $Y=421420
X723 87 2 1016 830 1 NR2 $T=337900 447000 1 0 $X=337900 $Y=441580
X724 1017 2 1004 959 1 NR2 $T=339760 447000 1 180 $X=337900 $Y=446620
X725 1008 2 1006 999 1 NR2 $T=342860 477240 0 180 $X=341000 $Y=471820
X726 128 2 1071 830 1 NR2 $T=377580 457080 0 180 $X=375720 $Y=451660
X727 144 2 1034 141 1 NR2 $T=389360 467160 0 180 $X=387500 $Y=461740
X728 1095 2 1098 148 1 NR2 $T=396180 416760 0 0 $X=396180 $Y=416380
X729 1103 2 154 1108 1 NR2 $T=401760 416760 1 0 $X=401760 $Y=411340
X730 1115 2 1138 1139 1 NR2 $T=411060 436920 1 0 $X=411060 $Y=431500
X731 1142 2 175 1128 1 NR2 $T=415400 426840 0 0 $X=415400 $Y=426460
X732 1146 2 1153 1150 1 NR2 $T=417260 447000 1 0 $X=417260 $Y=441580
X733 1151 2 1134 1149 1 NR2 $T=418500 497400 1 0 $X=418500 $Y=491980
X734 1159 2 1166 1151 1 NR2 $T=425320 497400 0 180 $X=423460 $Y=491980
X735 1237 2 1238 1204 1 NR2 $T=452600 426840 0 180 $X=450740 $Y=421420
X736 1224 2 228 1242 1 NR2 $T=453840 497400 1 0 $X=453840 $Y=491980
X737 1236 2 1258 1247 1 NR2 $T=456940 467160 1 0 $X=456940 $Y=461740
X738 1245 2 236 1259 1 NR2 $T=458800 487320 0 0 $X=458800 $Y=486940
X739 1260 2 239 1253 1 NR2 $T=462520 477240 0 0 $X=462520 $Y=476860
X740 1274 2 241 1273 1 NR2 $T=465620 497400 1 0 $X=465620 $Y=491980
X741 1295 2 245 1306 1 NR2 $T=474300 477240 0 0 $X=474300 $Y=476860
X742 1302 2 1320 1318 1 NR2 $T=483600 457080 0 180 $X=481740 $Y=451660
X743 1310 2 1323 1317 1 NR2 $T=482980 447000 0 0 $X=482980 $Y=446620
X744 1322 2 252 1297 1 NR2 $T=483600 477240 1 0 $X=483600 $Y=471820
X745 1321 2 1327 1329 1 NR2 $T=486080 436920 0 0 $X=486080 $Y=436540
X746 1339 2 1332 1343 1 NR2 $T=492280 447000 1 0 $X=492280 $Y=441580
X747 1330 2 1346 1347 1 NR2 $T=496000 457080 1 0 $X=496000 $Y=451660
X748 1353 2 1351 1366 1 NR2 $T=504060 447000 1 0 $X=504060 $Y=441580
X749 1328 2 1374 1369 1 NR2 $T=506540 457080 0 0 $X=506540 $Y=456700
X750 127 2 295 244 1 NR2 $T=509640 416760 1 0 $X=509640 $Y=411340
X751 1384 2 1380 1373 1 NR2 $T=514600 436920 1 180 $X=512740 $Y=436540
X752 1359 2 1396 1379 1 NR2 $T=512740 457080 0 0 $X=512740 $Y=456700
X753 1393 2 1403 1399 1 NR2 $T=522040 436920 0 0 $X=522040 $Y=436540
X754 1394 2 1406 1401 1 NR2 $T=522040 457080 1 0 $X=522040 $Y=451660
X755 1412 2 1296 1427 1 NR2 $T=527620 426840 1 0 $X=527620 $Y=421420
X756 331 2 1225 1424 1 NR2 $T=532580 416760 1 180 $X=530720 $Y=416380
X757 331 2 1449 1432 1 NR2 $T=541260 426840 1 180 $X=539400 $Y=426460
X758 1395 2 1470 1447 1 NR2 $T=540020 467160 1 0 $X=540020 $Y=461740
X759 1452 2 1418 1457 1 NR2 $T=542500 477240 1 0 $X=542500 $Y=471820
X760 1414 2 1460 1461 1 NR2 $T=545600 457080 0 0 $X=545600 $Y=456700
X761 1462 2 1381 1471 1 NR2 $T=548080 477240 1 0 $X=548080 $Y=471820
X762 1480 2 1483 373 1 NR2 $T=556760 416760 1 0 $X=556760 $Y=411340
X763 1477 2 1490 1482 1 NR2 $T=557380 467160 1 0 $X=557380 $Y=461740
X764 1464 2 1494 1493 1 NR2 $T=561100 426840 1 0 $X=561100 $Y=421420
X765 1506 2 1491 1498 1 NR2 $T=567920 487320 0 180 $X=566060 $Y=481900
X766 1272 2 1512 1466 1 NR2 $T=566680 467160 1 0 $X=566680 $Y=461740
X767 1512 2 1538 1515 1 NR2 $T=571640 467160 1 0 $X=571640 $Y=461740
X768 1537 2 1531 406 1 NR2 $T=580940 426840 1 0 $X=580940 $Y=421420
X769 1555 2 1561 1534 1 NR2 $T=589620 487320 0 180 $X=587760 $Y=481900
X770 1456 2 1555 1466 1 NR2 $T=587760 497400 1 0 $X=587760 $Y=491980
X771 1544 2 1564 416 1 NR2 $T=590240 416760 1 0 $X=590240 $Y=411340
X772 1545 2 1559 1552 1 NR2 $T=590240 467160 1 0 $X=590240 $Y=461740
X773 418 2 420 1552 1 NR2 $T=595820 497400 1 0 $X=595820 $Y=491980
X774 350 2 427 1581 1 NR2 $T=602020 497400 1 0 $X=602020 $Y=491980
X775 443 2 1612 1417 1 NR2 $T=621240 436920 1 0 $X=621240 $Y=431500
X776 453 2 1628 1417 1 NR2 $T=628680 426840 0 180 $X=626820 $Y=421420
X777 1622 2 1626 454 1 NR2 $T=626820 447000 0 0 $X=626820 $Y=446620
X778 466 2 1647 454 1 NR2 $T=636740 416760 1 0 $X=636740 $Y=411340
X779 488 2 1680 454 1 NR2 $T=657200 416760 1 180 $X=655340 $Y=416380
X780 1706 2 1700 1684 1 NR2 $T=665880 447000 1 180 $X=664020 $Y=446620
X781 1638 2 1710 1714 1 NR2 $T=667120 467160 0 0 $X=667120 $Y=466780
X782 337 2 1711 1675 1 NR2 $T=667120 487320 0 0 $X=667120 $Y=486940
X783 1641 2 1725 1711 1 NR2 $T=670220 477240 0 0 $X=670220 $Y=476860
X784 1708 2 1716 1709 1 NR2 $T=670220 487320 0 0 $X=670220 $Y=486940
X785 1701 2 1697 504 1 NR2 $T=685720 416760 1 0 $X=685720 $Y=411340
X786 1760 2 1789 1781 1 NR2 $T=696880 416760 0 0 $X=696880 $Y=416380
X787 1788 2 511 426 1 NR2 $T=699360 426840 0 180 $X=697500 $Y=421420
X788 1767 2 1786 1793 1 NR2 $T=701840 457080 0 0 $X=701840 $Y=456700
X789 1788 2 1794 440 1 NR2 $T=704940 436920 1 180 $X=703080 $Y=436540
X790 476 2 1806 1535 1 NR2 $T=707420 416760 1 180 $X=705560 $Y=416380
X791 476 2 1801 516 1 NR2 $T=707420 426840 1 0 $X=707420 $Y=421420
X792 510 2 1799 1809 1 NR2 $T=708660 436920 0 0 $X=708660 $Y=436540
X793 1788 2 1815 1809 1 NR2 $T=713620 426840 1 0 $X=713620 $Y=421420
X794 492 2 1823 516 1 NR2 $T=719200 436920 0 180 $X=717340 $Y=431500
X795 492 2 1825 1809 1 NR2 $T=719200 457080 0 180 $X=717340 $Y=451660
X796 492 2 1829 426 1 NR2 $T=723540 416760 0 0 $X=723540 $Y=416380
X797 1930 2 1928 594 1 NR2 $T=805380 497400 0 180 $X=803520 $Y=491980
X798 620 2 1931 426 1 NR2 $T=820880 426840 0 180 $X=819020 $Y=421420
X799 620 2 1941 619 1 NR2 $T=823360 426840 1 180 $X=821500 $Y=426460
X800 620 2 1951 613 1 NR2 $T=827700 426840 0 0 $X=827700 $Y=426460
X801 1957 2 1956 619 1 NR2 $T=834520 416760 1 180 $X=832660 $Y=416380
X802 638 2 1958 619 1 NR2 $T=834520 426840 0 180 $X=832660 $Y=421420
X803 1967 2 1953 634 1 NR2 $T=835140 487320 1 180 $X=833280 $Y=486940
X804 642 2 1954 640 1 NR2 $T=837620 416760 0 180 $X=835760 $Y=411340
X805 1957 2 1962 613 1 NR2 $T=836380 426840 1 0 $X=836380 $Y=421420
X806 642 2 646 613 1 NR2 $T=839480 416760 1 0 $X=839480 $Y=411340
X807 1978 2 1972 645 1 NR2 $T=844440 467160 1 180 $X=842580 $Y=466780
X808 638 2 1977 520 1 NR2 $T=845060 416760 1 0 $X=845060 $Y=411340
X809 2071 2 2061 695 1 NR2 $T=915740 477240 1 180 $X=913880 $Y=476860
X810 60 72 2 1 956 OR2 $T=310620 497400 0 0 $X=310620 $Y=497020
X811 1101 1094 2 1 1104 OR2 $T=395560 487320 1 0 $X=395560 $Y=481900
X812 1084 1298 2 1 1300 OR2 $T=473060 497400 1 0 $X=473060 $Y=491980
X813 1424 1412 2 1 1136 OR2 $T=529480 416760 1 180 $X=527000 $Y=416380
X814 1427 331 2 1 1132 OR2 $T=532580 426840 1 180 $X=530100 $Y=426460
X815 1412 338 2 1 1425 OR2 $T=535680 426840 0 180 $X=533200 $Y=421420
X816 1412 1432 2 1 1439 OR2 $T=533820 426840 0 0 $X=533820 $Y=426460
X817 1828 1859 2 1 533 OR2 $T=737800 487320 1 0 $X=737800 $Y=481900
X818 616 1933 2 1 1936 OR2 $T=815300 497400 1 0 $X=815300 $Y=491980
X819 628 1948 2 1 1964 OR2 $T=828940 487320 1 0 $X=828940 $Y=481900
X820 657 2002 2 1 1999 OR2 $T=859940 477240 1 0 $X=859940 $Y=471820
X821 664 2006 2 1 2012 OR2 $T=866760 477240 1 0 $X=866760 $Y=471820
X822 2120 2122 2 1 2092 OR2 $T=947980 447000 0 0 $X=947980 $Y=446620
X823 40 817 803 2 1 ND2S $T=253580 457080 1 180 $X=251720 $Y=456700
X824 40 834 819 2 1 ND2S $T=259780 487320 0 180 $X=257920 $Y=481900
X825 40 808 809 2 1 ND2S $T=257920 497400 1 0 $X=257920 $Y=491980
X826 40 845 805 2 1 ND2S $T=260400 457080 0 0 $X=260400 $Y=456700
X827 805 869 56 2 1 ND2S $T=275900 457080 1 0 $X=275900 $Y=451660
X828 29 933 935 2 1 ND2S $T=305040 467160 1 0 $X=305040 $Y=461740
X829 805 959 935 2 1 ND2S $T=311860 447000 0 0 $X=311860 $Y=446620
X830 819 957 935 2 1 ND2S $T=313720 447000 1 0 $X=313720 $Y=441580
X831 73 949 81 2 1 ND2S $T=316820 497400 0 0 $X=316820 $Y=497020
X832 803 974 935 2 1 ND2S $T=319300 447000 0 180 $X=317440 $Y=441580
X833 809 964 935 2 1 ND2S $T=321780 467160 1 0 $X=321780 $Y=461740
X834 107 1036 109 2 1 ND2S $T=349680 416760 0 0 $X=349680 $Y=416380
X835 119 1045 115 2 1 ND2S $T=360220 497400 0 180 $X=358360 $Y=491980
X836 1085 1082 143 2 1 ND2S $T=383160 416760 1 0 $X=383160 $Y=411340
X837 1110 1117 1104 2 1 ND2S $T=402380 487320 1 180 $X=400520 $Y=486940
X838 151 160 156 2 1 ND2S $T=406100 416760 1 0 $X=406100 $Y=411340
X839 172 1147 1144 2 1 ND2S $T=414780 477240 1 0 $X=414780 $Y=471820
X840 1135 1156 1148 2 1 ND2S $T=419740 457080 1 180 $X=417880 $Y=456700
X841 1193 1172 1184 2 1 ND2S $T=431520 457080 0 180 $X=429660 $Y=451660
X842 1187 1174 1192 2 1 ND2S $T=432140 487320 1 0 $X=432140 $Y=481900
X843 195 1186 1109 2 1 ND2S $T=434620 436920 1 180 $X=432760 $Y=436540
X844 1197 1155 1188 2 1 ND2S $T=437100 467160 1 180 $X=435240 $Y=466780
X845 195 1206 192 2 1 ND2S $T=438960 447000 1 0 $X=438960 $Y=441580
X846 195 1216 211 2 1 ND2S $T=443300 436920 1 180 $X=441440 $Y=436540
X847 1215 1163 1210 2 1 ND2S $T=443300 467160 0 180 $X=441440 $Y=461740
X848 1135 1213 1109 2 1 ND2S $T=445160 436920 0 180 $X=443300 $Y=431500
X849 195 1231 231 2 1 ND2S $T=453840 436920 0 0 $X=453840 $Y=436540
X850 1225 1270 222 2 1 ND2S $T=461280 416760 0 180 $X=459420 $Y=411340
X851 1278 1179 1265 2 1 ND2S $T=466860 447000 0 180 $X=465000 $Y=441580
X852 1285 1309 1280 2 1 ND2S $T=471820 457080 1 180 $X=469960 $Y=456700
X853 1304 1315 1300 2 1 ND2S $T=479260 497400 1 180 $X=477400 $Y=497020
X854 1267 256 1023 2 1 ND2S $T=486700 447000 1 180 $X=484840 $Y=446620
X855 255 258 249 2 1 ND2S $T=486080 416760 1 0 $X=486080 $Y=411340
X856 1267 265 1048 2 1 ND2S $T=490420 447000 1 180 $X=488560 $Y=446620
X857 1267 1335 113 2 1 ND2S $T=492280 457080 1 0 $X=492280 $Y=451660
X858 1345 1350 1308 2 1 ND2S $T=496620 426840 1 180 $X=494760 $Y=426460
X859 1355 1360 1325 2 1 ND2S $T=500340 426840 1 180 $X=498480 $Y=426460
X860 255 1334 285 2 1 ND2S $T=501580 416760 1 0 $X=501580 $Y=411340
X861 1351 1362 1368 2 1 ND2S $T=504680 487320 1 0 $X=504680 $Y=481900
X862 1332 1376 1368 2 1 ND2S $T=509640 477240 0 0 $X=509640 $Y=476860
X863 288 340 277 2 1 ND2S $T=514600 497400 1 180 $X=512740 $Y=497020
X864 294 301 1078 2 1 ND2S $T=515840 467160 1 180 $X=513980 $Y=466780
X865 1418 1426 1407 2 1 ND2S $T=529480 477240 1 180 $X=527620 $Y=476860
X866 328 322 333 2 1 ND2S $T=530720 416760 1 0 $X=530720 $Y=411340
X867 1402 1429 1435 2 1 ND2S $T=533820 477240 1 0 $X=533820 $Y=471820
X868 1437 1424 338 2 1 ND2S $T=535680 416760 0 0 $X=535680 $Y=416380
X869 344 336 341 2 1 ND2S $T=536300 416760 1 0 $X=536300 $Y=411340
X870 1410 1446 290 2 1 ND2S $T=538160 497400 0 180 $X=536300 $Y=491980
X871 369 1473 1468 2 1 ND2S $T=548080 436920 0 0 $X=548080 $Y=436540
X872 1469 1474 269 2 1 ND2S $T=550560 447000 1 180 $X=548700 $Y=446620
X873 1476 1469 272 2 1 ND2S $T=554280 447000 1 0 $X=554280 $Y=441580
X874 272 1479 1450 2 1 ND2S $T=556140 457080 0 180 $X=554280 $Y=451660
X875 1489 1495 1472 2 1 ND2S $T=562960 457080 1 180 $X=561100 $Y=456700
X876 388 1505 375 2 1 ND2S $T=568540 447000 0 180 $X=566680 $Y=441580
X877 1507 1529 1499 2 1 ND2S $T=568540 467160 1 180 $X=566680 $Y=466780
X878 388 1511 1421 2 1 ND2S $T=573500 426840 1 180 $X=571640 $Y=426460
X879 1509 1524 1485 2 1 ND2S $T=577220 426840 0 180 $X=575360 $Y=421420
X880 388 1520 1459 2 1 ND2S $T=577220 426840 1 180 $X=575360 $Y=426460
X881 1516 1528 1518 2 1 ND2S $T=575360 467160 1 0 $X=575360 $Y=461740
X882 1513 1532 1504 2 1 ND2S $T=577840 416760 0 180 $X=575980 $Y=411340
X883 379 1519 359 2 1 ND2S $T=578460 497400 0 0 $X=578460 $Y=497020
X884 379 1540 404 2 1 ND2S $T=579080 487320 0 0 $X=579080 $Y=486940
X885 1528 1539 1541 2 1 ND2S $T=580940 467160 1 0 $X=580940 $Y=461740
X886 1508 1546 1518 2 1 ND2S $T=584040 447000 0 0 $X=584040 $Y=446620
X887 1490 1551 1584 2 1 ND2S $T=587140 457080 1 0 $X=587140 $Y=451660
X888 1538 1567 1536 2 1 ND2S $T=590240 457080 0 0 $X=590240 $Y=456700
X889 1561 1562 409 2 1 ND2S $T=593960 487320 0 180 $X=592100 $Y=481900
X890 383 1570 403 2 1 ND2S $T=593340 467160 0 0 $X=593340 $Y=466780
X891 1406 1578 1530 2 1 ND2S $T=600780 447000 0 180 $X=598920 $Y=441580
X892 419 1569 1583 2 1 ND2S $T=602020 426840 1 0 $X=602020 $Y=421420
X893 423 1568 1583 2 1 ND2S $T=602020 436920 1 0 $X=602020 $Y=431500
X894 1346 1579 1554 2 1 ND2S $T=603880 457080 1 180 $X=602020 $Y=456700
X895 423 425 1586 2 1 ND2S $T=602020 467160 0 0 $X=602020 $Y=466780
X896 419 1580 1586 2 1 ND2S $T=602020 477240 1 0 $X=602020 $Y=471820
X897 1529 1601 1587 2 1 ND2S $T=607600 467160 0 0 $X=607600 $Y=466780
X898 1320 1600 1586 2 1 ND2S $T=612560 457080 1 180 $X=610700 $Y=456700
X899 1495 1608 1587 2 1 ND2S $T=612560 467160 0 180 $X=610700 $Y=461740
X900 1564 1593 1599 2 1 ND2S $T=610700 487320 1 0 $X=610700 $Y=481900
X901 397 1595 1599 2 1 ND2S $T=610700 497400 1 0 $X=610700 $Y=491980
X902 1470 1598 1530 2 1 ND2S $T=614420 426840 1 180 $X=612560 $Y=426460
X903 435 437 439 2 1 ND2S $T=615660 416760 1 180 $X=613800 $Y=416380
X904 1470 1602 1586 2 1 ND2S $T=615660 467160 0 180 $X=613800 $Y=461740
X905 1543 442 1599 2 1 ND2S $T=619380 497400 0 180 $X=617520 $Y=491980
X906 1531 1621 1605 2 1 ND2S $T=621240 487320 0 180 $X=619380 $Y=481900
X907 445 448 1605 2 1 ND2S $T=621860 487320 1 180 $X=620000 $Y=486940
X908 1406 1611 1586 2 1 ND2S $T=622480 457080 1 180 $X=620620 $Y=456700
X909 1556 1615 452 2 1 ND2S $T=624960 447000 0 0 $X=624960 $Y=446620
X910 455 1618 447 2 1 ND2S $T=627440 436920 1 180 $X=625580 $Y=436540
X911 1619 1629 289 2 1 ND2S $T=630540 426840 1 180 $X=628680 $Y=426460
X912 455 1632 452 2 1 ND2S $T=631780 447000 0 0 $X=631780 $Y=446620
X913 467 1644 452 2 1 ND2S $T=637360 467160 0 0 $X=637360 $Y=466780
X914 1619 1686 438 2 1 ND2S $T=656580 426840 1 0 $X=656580 $Y=421420
X915 1710 1724 1707 2 1 ND2S $T=672080 477240 0 180 $X=670220 $Y=471820
X916 479 1730 1673 2 1 ND2S $T=675800 467160 0 180 $X=673940 $Y=461740
X917 1735 1745 1717 2 1 ND2S $T=680760 447000 0 180 $X=678900 $Y=441580
X918 414 1770 337 2 1 ND2S $T=696880 416760 1 0 $X=696880 $Y=411340
X919 1751 1780 1769 2 1 ND2S $T=696880 447000 1 0 $X=696880 $Y=441580
X920 1786 1796 1715 2 1 ND2S $T=706800 457080 0 0 $X=706800 $Y=456700
X921 514 1822 1521 2 1 ND2S $T=721680 426840 0 180 $X=719820 $Y=421420
X922 496 1843 525 2 1 ND2S $T=727260 447000 0 180 $X=725400 $Y=441580
X923 513 1840 1842 2 1 ND2S $T=726640 416760 0 0 $X=726640 $Y=416380
X924 1685 1841 526 2 1 ND2S $T=726640 426840 1 0 $X=726640 $Y=421420
X925 524 1831 525 2 1 ND2S $T=726640 457080 0 0 $X=726640 $Y=456700
X926 1685 1833 525 2 1 ND2S $T=726640 467160 0 0 $X=726640 $Y=466780
X927 524 1852 1842 2 1 ND2S $T=732220 447000 1 0 $X=732220 $Y=441580
X928 1849 531 529 2 1 ND2S $T=733460 497400 0 0 $X=733460 $Y=497020
X929 1685 1847 530 2 1 ND2S $T=734080 426840 0 0 $X=734080 $Y=426460
X930 1859 529 1828 2 1 ND2S $T=738420 497400 1 0 $X=738420 $Y=491980
X931 1819 536 533 2 1 ND2S $T=744000 497400 1 180 $X=742140 $Y=497020
X932 533 1869 529 2 1 ND2S $T=744000 487320 1 0 $X=744000 $Y=481900
X933 491 580 565 2 1 ND2S $T=783060 416760 0 180 $X=781200 $Y=411340
X934 602 1927 1521 2 1 ND2S $T=807860 426840 0 180 $X=806000 $Y=421420
X935 595 1932 1842 2 1 ND2S $T=810340 416760 0 180 $X=808480 $Y=411340
X936 594 608 1930 2 1 ND2S $T=809720 497400 1 0 $X=809720 $Y=491980
X937 610 1935 1842 2 1 ND2S $T=814060 436920 1 180 $X=812200 $Y=436540
X938 616 1943 1933 2 1 ND2S $T=823360 497400 0 180 $X=821500 $Y=491980
X939 1936 1945 1943 2 1 ND2S $T=821500 497400 0 0 $X=821500 $Y=497020
X940 1938 1940 625 2 1 ND2S $T=825220 447000 1 0 $X=825220 $Y=441580
X941 579 1950 530 2 1 ND2S $T=828320 426840 0 180 $X=826460 $Y=421420
X942 602 626 530 2 1 ND2S $T=828940 416760 0 180 $X=827080 $Y=411340
X943 628 1963 1948 2 1 ND2S $T=830180 477240 0 0 $X=830180 $Y=476860
X944 1955 639 1961 2 1 ND2S $T=833900 497400 1 0 $X=833900 $Y=491980
X945 637 1952 625 2 1 ND2S $T=835140 436920 0 0 $X=835140 $Y=436540
X946 1964 1959 1963 2 1 ND2S $T=837620 477240 1 180 $X=835760 $Y=476860
X947 634 1961 1967 2 1 ND2S $T=839480 487320 0 0 $X=839480 $Y=486940
X948 645 1983 1978 2 1 ND2S $T=849400 467160 0 0 $X=849400 $Y=466780
X949 1980 1985 1983 2 1 ND2S $T=852500 477240 1 0 $X=852500 $Y=471820
X950 579 2001 625 2 1 ND2S $T=856220 436920 1 180 $X=854360 $Y=436540
X951 1999 1998 1993 2 1 ND2S $T=858700 477240 1 180 $X=856840 $Y=476860
X952 657 1993 2002 2 1 ND2S $T=858700 467160 0 0 $X=858700 $Y=466780
X953 2012 2008 2010 2 1 ND2S $T=865520 487320 1 0 $X=865520 $Y=481900
X954 664 2010 2006 2 1 ND2S $T=866760 467160 0 0 $X=866760 $Y=466780
X955 2053 2041 2066 2 1 ND2S $T=900860 487320 1 0 $X=900860 $Y=481900
X956 695 2066 2071 2 1 ND2S $T=921320 487320 1 0 $X=921320 $Y=481900
X957 2083 2095 2092 2 1 ND2S $T=928140 457080 1 0 $X=928140 $Y=451660
X958 2101 2096 2092 2 1 ND2S $T=933720 457080 1 180 $X=931860 $Y=456700
X959 2095 2097 2104 2 1 ND2S $T=934340 447000 0 0 $X=934340 $Y=446620
X960 2099 2101 2104 2 1 ND2S $T=934340 457080 1 0 $X=934340 $Y=451660
X961 2092 2081 2104 2 1 ND2S $T=939920 457080 1 0 $X=939920 $Y=451660
X962 2122 2104 2120 2 1 ND2S $T=941160 447000 0 0 $X=941160 $Y=446620
X963 1298 1084 1 1316 260 2 OAI12H $T=482980 497400 1 0 $X=482980 $Y=491980
X964 1928 614 1 608 1939 2 OAI12H $T=812820 497400 0 0 $X=812820 $Y=497020
X965 1953 632 1 1961 1971 2 OAI12H $T=837620 497400 1 0 $X=837620 $Y=491980
X966 1936 1939 2 632 1947 1 AOI12H $T=825220 497400 1 0 $X=825220 $Y=491980
X967 1964 1971 2 1981 1968 1 AOI12H $T=840720 477240 0 0 $X=840720 $Y=476860
X968 138 148 1088 2 1 XOR2HS $T=396800 436920 0 180 $X=391220 $Y=431500
X969 1097 1099 1090 2 1 XOR2HS $T=393080 436920 0 0 $X=393080 $Y=436540
X970 1614 465 1654 2 1 XOR2HS $T=637980 487320 1 0 $X=637980 $Y=481900
X971 1652 1638 1658 2 1 XOR2HS $T=639840 467160 0 0 $X=639840 $Y=466780
X972 1985 1981 655 2 1 XOR2HS $T=850640 487320 0 0 $X=850640 $Y=486940
X973 1071 1074 1073 2 1 XNR2HS $T=377580 457080 1 0 $X=377580 $Y=451660
X974 1214 1209 1223 2 1 XNR2HS $T=446400 497400 1 0 $X=446400 $Y=491980
X975 1945 1939 627 2 1 XNR2HS $T=825220 497400 0 0 $X=825220 $Y=497020
X976 1959 1971 1969 2 1 XNR2HS $T=844440 487320 0 0 $X=844440 $Y=486940
X977 1998 1987 1988 2 1 XNR2HS $T=858080 487320 0 0 $X=858080 $Y=486940
X978 2008 2004 667 2 1 XNR2HS $T=864900 487320 0 0 $X=864900 $Y=486940
X979 1380 300 2 1 1371 1350 MUX2 $T=513360 447000 0 180 $X=509020 $Y=441580
X980 1403 300 2 1 1402 1360 MUX2 $T=527620 447000 1 180 $X=523280 $Y=446620
X981 1396 1510 2 1 1508 1283 MUX2 $T=573500 447000 1 180 $X=569160 $Y=446620
X982 1374 1510 2 1 1516 1309 MUX2 $T=577220 457080 1 180 $X=572880 $Y=456700
X983 419 417 2 1 1549 1524 MUX2 $T=594580 426840 1 180 $X=590240 $Y=426460
X984 423 417 2 1 1560 1532 MUX2 $T=599540 416760 0 180 $X=595200 $Y=411340
X985 1906 1 2 1909 DELB $T=775000 467160 0 0 $X=775000 $Y=466780
X986 1915 1 2 1913 DELB $T=793600 477240 0 0 $X=793600 $Y=476860
X987 1916 1 2 1912 DELB $T=794220 436920 0 0 $X=794220 $Y=436540
X988 1921 1 2 1918 DELB $T=796700 416760 0 0 $X=796700 $Y=416380
X989 1922 1 2 1925 DELB $T=798560 487320 0 0 $X=798560 $Y=486940
X990 1919 1 2 1923 DELB $T=801660 487320 1 0 $X=801660 $Y=481900
X991 1920 1 2 1924 DELB $T=802900 497400 0 0 $X=802900 $Y=497020
X992 1937 1 2 1946 DELB $T=819020 467160 0 0 $X=819020 $Y=466780
X993 1074 1071 1 2 1035 AN2 $T=376960 447000 1 180 $X=374480 $Y=446620
X994 147 1077 1 2 1108 AN2 $T=396180 426840 1 0 $X=396180 $Y=421420
X995 173 1126 1 2 1151 AN2 $T=414780 497400 1 0 $X=414780 $Y=491980
X996 1363 1408 1 2 1417 AN2 $T=527000 436920 1 0 $X=527000 $Y=431500
X997 1496 385 1 2 1506 AN2 $T=566060 477240 1 0 $X=566060 $Y=471820
X998 1523 1341 1 2 1535 AN2 $T=577220 457080 1 0 $X=577220 $Y=451660
X999 1603 1589 1 2 440 AN2 $T=616280 436920 1 0 $X=616280 $Y=431500
X1000 1400 1371 2 1167 1 1389 AOI12HS $T=523280 426840 0 180 $X=518940 $Y=421420
X1001 1077 147 1098 1 2 1103 OA12 $T=394320 416760 1 0 $X=394320 $Y=411340
X1002 254 267 1182 1 2 1344 OA12 $T=491040 487320 1 0 $X=491040 $Y=481900
X1003 1352 267 1333 1 2 1201 OA12 $T=499720 467160 1 180 $X=496000 $Y=466780
X1004 292 267 1358 1 2 1354 OA12 $T=505300 467160 0 180 $X=501580 $Y=461740
X1005 391 1552 1248 1 2 1573 OA12 $T=586520 416760 0 0 $X=586520 $Y=416380
X1006 1666 1664 1659 1 2 474 OA12 $T=649140 487320 1 180 $X=645420 $Y=486940
X1007 1719 1729 509 1 2 1781 OA12 $T=690060 416760 0 0 $X=690060 $Y=416380
X1008 1044 90 1047 2 1 1001 QDFFRBS $T=367660 436920 0 0 $X=367660 $Y=436540
X1009 1876 518 1870 2 1 1894 QDFFRBS $T=750200 457080 0 0 $X=750200 $Y=456700
X1010 555 518 553 2 1 571 QDFFRBS $T=774380 497400 1 0 $X=774380 $Y=491980
X1011 574 551 1885 2 1 1906 QDFFRBS $T=788640 447000 1 180 $X=776860 $Y=446620
X1012 1909 551 1910 2 1 581 QDFFRBS $T=779960 467160 0 0 $X=779960 $Y=466780
X1013 1988 551 649 2 1 662 QDFFRBS $T=853120 497400 0 0 $X=853120 $Y=497020
X1014 663 666 2013 2 1 2024 QDFFRBS $T=864900 416760 0 0 $X=864900 $Y=416380
X1015 2032 666 676 2 1 2019 QDFFRBS $T=889080 467160 1 180 $X=877300 $Y=466780
X1016 2116 666 2129 2 1 2124 QDFFRBS $T=944260 457080 1 0 $X=944260 $Y=451660
X1017 789 1 2 27 BUF1CK $T=233740 416760 0 0 $X=233740 $Y=416380
X1018 961 1 2 972 BUF1CK $T=318680 457080 1 0 $X=318680 $Y=451660
X1019 970 1 2 985 BUF1CK $T=324260 457080 0 0 $X=324260 $Y=456700
X1020 1070 1 2 1069 BUF1CK $T=373860 467160 0 0 $X=373860 $Y=466780
X1021 1093 1 2 1091 BUF1CK $T=389360 487320 0 0 $X=389360 $Y=486940
X1022 230 1 2 1214 BUF1CK $T=455700 497400 1 0 $X=455700 $Y=491980
X1023 1256 1 2 1301 BUF1CK $T=472440 426840 0 0 $X=472440 $Y=426460
X1024 242 1 2 1269 BUF1CK $T=472440 436920 1 0 $X=472440 $Y=431500
X1025 1767 1 2 1740 BUF1CK $T=690680 457080 0 0 $X=690680 $Y=456700
X1026 709 1 2 2107 BUF1CK $T=939300 497400 0 0 $X=939300 $Y=497020
X1027 2145 1 2 723 BUF1CK $T=967820 477240 0 0 $X=967820 $Y=476860
X1028 122 90 1 2 INV12CK $T=365180 487320 0 180 $X=355260 $Y=481900
X1029 399 354 1 2 INV12CK $T=577220 457080 0 180 $X=567300 $Y=451660
X1030 794 939 935 1 2 ND2 $T=305040 477240 1 0 $X=305040 $Y=471820
X1031 1122 1110 1101 1 2 ND2 $T=406100 497400 1 0 $X=406100 $Y=491980
X1032 1211 215 1203 1 2 ND2 $T=442680 487320 1 180 $X=440820 $Y=486940
X1033 1230 223 1222 1 2 ND2 $T=449500 477240 1 180 $X=447640 $Y=476860
X1034 1281 1251 1277 1 2 ND2 $T=468720 436920 1 0 $X=468720 $Y=431500
X1035 1287 1283 1279 1 2 ND2 $T=470580 447000 1 180 $X=468720 $Y=446620
X1036 1312 1264 1291 1 2 ND2 $T=478640 426840 0 180 $X=476780 $Y=421420
X1037 1304 1316 1313 1 2 ND2 $T=479260 497400 1 0 $X=479260 $Y=491980
X1038 1342 1271 1338 1 2 ND2 $T=493520 416760 1 180 $X=491660 $Y=416380
X1039 280 289 291 1 2 ND2 $T=509640 447000 1 180 $X=507780 $Y=446620
X1040 1404 319 1331 1 2 ND2 $T=523900 477240 1 180 $X=522040 $Y=476860
X1041 1413 1352 1416 1 2 ND2 $T=527620 447000 1 0 $X=527620 $Y=441580
X1042 1371 1423 1435 1 2 ND2 $T=530720 467160 0 0 $X=530720 $Y=466780
X1043 1437 1427 1432 1 2 ND2 $T=536920 426840 1 0 $X=536920 $Y=421420
X1044 1445 292 1436 1 2 ND2 $T=538780 457080 1 180 $X=536920 $Y=456700
X1045 1463 1410 1467 1 2 ND2 $T=548080 487320 0 0 $X=548080 $Y=486940
X1046 1526 1521 1367 1 2 ND2 $T=575360 447000 1 180 $X=573500 $Y=446620
X1047 1548 1556 410 1 2 ND2 $T=589000 497400 1 180 $X=587140 $Y=497020
X1048 1560 1557 1518 1 2 ND2 $T=594580 447000 1 180 $X=592720 $Y=446620
X1049 1594 1607 1575 1 2 ND2 $T=621240 447000 0 180 $X=619380 $Y=441580
X1050 1609 1613 1238 1 2 ND2 $T=621860 467160 0 0 $X=621860 $Y=466780
X1051 445 1617 411 1 2 ND2 $T=625580 477240 1 0 $X=625580 $Y=471820
X1052 125 120 1 1045 2 1052 OAI12HS $T=363940 497400 0 180 $X=360220 $Y=491980
X1053 143 144 1 140 2 1075 OAI12HS $T=387500 416760 1 0 $X=387500 $Y=411340
X1054 1972 1981 1 1983 2 1987 OAI12HS $T=848780 477240 0 0 $X=848780 $Y=476860
X1055 2061 2063 1 2066 2 2064 OAI12HS $T=912640 487320 0 0 $X=912640 $Y=486940
X1056 11 1 12 781 784 21 2 OAI22S $T=226300 487320 1 0 $X=226300 $Y=481900
X1057 774 1 12 775 785 21 2 OAI22S $T=226300 497400 1 0 $X=226300 $Y=491980
X1058 797 1 25 790 792 777 2 OAI22S $T=238700 447000 0 180 $X=234980 $Y=441580
X1059 801 1 25 795 787 777 2 OAI22S $T=241180 436920 0 180 $X=237460 $Y=431500
X1060 810 1 12 796 793 21 2 OAI22S $T=241180 467160 0 180 $X=237460 $Y=461740
X1061 799 1 25 788 791 21 2 OAI22S $T=243040 457080 1 180 $X=239320 $Y=456700
X1062 985 1 975 92 989 998 2 OAI22S $T=326740 457080 0 0 $X=326740 $Y=456700
X1063 1007 1 975 864 1002 998 2 OAI22S $T=337900 477240 0 180 $X=334180 $Y=471820
X1064 1006 1 1008 1006 988 999 2 OAI22S $T=338520 477240 1 180 $X=334800 $Y=476860
X1065 1054 1 105 1057 1055 998 2 OAI22S $T=363940 487320 0 0 $X=363940 $Y=486940
X1066 1065 1 105 129 1066 132 2 OAI22S $T=370140 487320 1 0 $X=370140 $Y=481900
X1067 142 1 140 1043 1087 137 2 OAI22S $T=387500 416760 1 180 $X=383780 $Y=416380
X1068 127 1 140 1072 1089 137 2 OAI22S $T=388740 426840 1 180 $X=385020 $Y=426460
X1069 181 1 161 1177 185 204 2 OAI22S $T=428420 497400 0 0 $X=428420 $Y=497020
X1070 210 1 198 207 1209 182 2 OAI22S $T=442680 497400 0 180 $X=438960 $Y=491980
X1071 197 1 1219 1220 1224 202 2 OAI22S $T=445780 487320 0 0 $X=445780 $Y=486940
X1072 1096 1 1233 1235 1236 1030 2 OAI22S $T=450120 457080 0 0 $X=450120 $Y=456700
X1073 1102 1 1233 1235 1239 1096 2 OAI22S $T=451360 447000 0 0 $X=451360 $Y=446620
X1074 202 1 1219 1220 1245 201 2 OAI22S $T=451980 487320 0 0 $X=451980 $Y=486940
X1075 1250 1 201 1244 1242 218 2 OAI22S $T=456940 477240 1 180 $X=453220 $Y=476860
X1076 1252 1 1064 1244 1247 1023 2 OAI22S $T=458180 467160 1 180 $X=454460 $Y=466780
X1077 1252 1 1030 1244 1249 1064 2 OAI22S $T=459420 457080 0 180 $X=455700 $Y=451660
X1078 218 1 1250 1244 1259 213 2 OAI22S $T=458800 487320 1 0 $X=458800 $Y=481900
X1079 213 1 1219 1220 1274 214 2 OAI22S $T=463760 487320 0 0 $X=463760 $Y=486940
X1080 1250 1 216 1244 1273 237 2 OAI22S $T=468720 487320 0 180 $X=465000 $Y=481900
X1081 214 1 1219 1220 1294 216 2 OAI22S $T=469960 487320 0 0 $X=469960 $Y=486940
X1082 237 1 1289 1244 1293 133 2 OAI22S $T=475540 487320 0 180 $X=471820 $Y=481900
X1083 1023 1 1292 1299 1302 1051 2 OAI22S $T=472440 457080 1 0 $X=472440 $Y=451660
X1084 237 1 1292 1299 1297 133 2 OAI22S $T=476780 467160 0 180 $X=473060 $Y=461740
X1085 235 1 1303 1235 1310 211 2 OAI22S $T=474920 436920 0 0 $X=474920 $Y=436540
X1086 216 1 1219 1220 1306 237 2 OAI22S $T=476160 467160 0 0 $X=476160 $Y=466780
X1087 211 1 1303 1235 1321 227 2 OAI22S $T=480500 436920 0 0 $X=480500 $Y=436540
X1088 1252 1 1048 1286 1318 1056 2 OAI22S $T=480500 457080 0 0 $X=480500 $Y=456700
X1089 1326 1 227 1319 1317 231 2 OAI22S $T=484840 436920 0 180 $X=481120 $Y=431500
X1090 1048 1 1303 1299 1328 1056 2 OAI22S $T=486080 457080 0 0 $X=486080 $Y=456700
X1091 1051 1 1303 1299 1330 1048 2 OAI22S $T=486700 457080 1 0 $X=486700 $Y=451660
X1092 1326 1 231 1319 1329 249 2 OAI22S $T=487320 436920 1 0 $X=487320 $Y=431500
X1093 249 1 1337 1235 1339 263 2 OAI22S $T=490420 436920 0 0 $X=490420 $Y=436540
X1094 1326 1 271 1319 1343 274 2 OAI22S $T=493520 436920 1 0 $X=493520 $Y=431500
X1095 263 1 1337 1235 1353 271 2 OAI22S $T=497240 436920 0 0 $X=497240 $Y=436540
X1096 1252 1 1056 1286 1347 113 2 OAI22S $T=497860 457080 1 0 $X=497860 $Y=451660
X1097 1056 1 1337 1299 1359 113 2 OAI22S $T=499720 457080 0 0 $X=499720 $Y=456700
X1098 1377 1 113 1286 1369 1060 2 OAI22S $T=510260 457080 0 180 $X=506540 $Y=451660
X1099 271 1 1337 1361 1373 274 2 OAI22S $T=507160 436920 0 0 $X=507160 $Y=436540
X1100 1383 1 274 1319 1366 285 2 OAI22S $T=512120 436920 0 180 $X=508400 $Y=431500
X1101 1377 1 1060 1286 1379 1078 2 OAI22S $T=510260 467160 1 0 $X=510260 $Y=461740
X1102 274 1 1337 1361 1393 285 2 OAI22S $T=515840 447000 1 0 $X=515840 $Y=441580
X1103 113 1 1387 1391 1394 1060 2 OAI22S $T=515840 457080 1 0 $X=515840 $Y=451660
X1104 1060 1 1387 1391 1395 1078 2 OAI22S $T=516460 467160 1 0 $X=516460 $Y=461740
X1105 1383 1 1382 1319 1399 318 2 OAI22S $T=518320 426840 0 0 $X=518320 $Y=426460
X1106 1377 1 1078 1286 1401 1116 2 OAI22S $T=525760 457080 1 180 $X=522040 $Y=456700
X1107 1078 1 1387 1391 1414 1116 2 OAI22S $T=525140 467160 1 0 $X=525140 $Y=461740
X1108 1442 1 1116 1444 1447 1161 2 OAI22S $T=536300 467160 0 0 $X=536300 $Y=466780
X1109 1442 1 355 1444 1457 347 2 OAI22S $T=546840 477240 1 180 $X=543120 $Y=476860
X1110 1442 1 1161 1444 1461 178 2 OAI22S $T=544360 467160 0 0 $X=544360 $Y=466780
X1111 240 1 1455 360 1464 1378 2 OAI22S $T=546220 416760 0 0 $X=546220 $Y=416380
X1112 1468 1 1455 1465 1462 1458 2 OAI22S $T=551180 447000 0 180 $X=547460 $Y=441580
X1113 1116 1 1466 1465 1477 1161 2 OAI22S $T=549940 467160 0 0 $X=549940 $Y=466780
X1114 1378 1 366 360 1480 293 2 OAI22S $T=552420 416760 0 0 $X=552420 $Y=416380
X1115 1442 1 178 1444 1482 1272 2 OAI22S $T=559860 467160 1 180 $X=556140 $Y=466780
X1116 1442 1 1475 1444 1471 355 2 OAI22S $T=559860 477240 1 180 $X=556140 $Y=476860
X1117 382 1 371 1486 376 374 2 OAI22S $T=561720 497400 1 180 $X=558000 $Y=497020
X1118 358 1 293 377 1493 372 2 OAI22S $T=558620 416760 1 0 $X=558620 $Y=411340
X1119 346 1 383 1465 1515 384 2 OAI22S $T=575360 477240 0 180 $X=571640 $Y=471820
X1120 346 1 359 1465 1534 404 2 OAI22S $T=577220 487320 1 0 $X=577220 $Y=481900
X1121 341 1 366 360 1537 395 2 OAI22S $T=579080 416760 0 0 $X=579080 $Y=416380
X1122 395 1 366 360 1544 398 2 OAI22S $T=580940 416760 1 0 $X=580940 $Y=411340
X1123 1683 1 1684 1683 486 1690 2 OAI22S $T=657200 457080 0 0 $X=657200 $Y=456700
X1124 1716 1 1709 1716 1713 1708 2 OAI22S $T=672700 497400 0 180 $X=668980 $Y=491980
X1125 1775 1 1765 1775 1779 1764 2 OAI22S $T=698740 436920 1 180 $X=695020 $Y=436540
X1126 1789 1 1760 1789 1790 1781 2 OAI22S $T=703700 416760 1 180 $X=699980 $Y=416380
X1127 583 1 580 583 1917 586 2 OAI22S $T=792360 416760 0 0 $X=792360 $Y=416380
X1128 1107 1025 1111 1105 1 1001 2 AOI22S $T=401760 447000 1 180 $X=398040 $Y=446620
X1129 1124 1105 1125 153 1 151 2 AOI22S $T=406100 416760 1 180 $X=402380 $Y=416380
X1130 1107 1105 1119 151 1 152 2 AOI22S $T=406100 426840 1 180 $X=402380 $Y=426460
X1131 156 1121 1127 1001 1 152 2 AOI22S $T=407340 436920 1 180 $X=403620 $Y=436540
X1132 1107 1105 1130 1074 1 1025 2 AOI22S $T=408580 447000 1 180 $X=404860 $Y=446620
X1133 163 1121 165 1025 1 159 2 AOI22S $T=411680 457080 0 180 $X=407960 $Y=451660
X1134 167 1121 164 1074 1 159 2 AOI22S $T=412300 457080 1 180 $X=408580 $Y=456700
X1135 1107 174 1152 1140 1 135 2 AOI22S $T=417260 416760 0 180 $X=413540 $Y=411340
X1136 1123 1155 1145 1160 1 1144 2 AOI22S $T=419120 467160 0 0 $X=419120 $Y=466780
X1137 1123 1163 1143 1160 1 1148 2 AOI22S $T=421600 457080 0 0 $X=421600 $Y=456700
X1138 1165 1140 1176 135 1 138 2 AOI22S $T=426560 416760 1 180 $X=422840 $Y=416380
X1139 1171 1172 1154 1160 1 1123 2 AOI22S $T=427180 457080 0 180 $X=423460 $Y=451660
X1140 1169 1174 1164 1160 1 180 2 AOI22S $T=425320 487320 1 0 $X=425320 $Y=481900
X1141 1168 1140 1173 183 1 194 2 AOI22S $T=425940 416760 1 0 $X=425940 $Y=411340
X1142 156 1121 1190 1148 1 1144 2 AOI22S $T=430280 447000 1 180 $X=426560 $Y=446620
X1143 1109 1179 1170 1160 1 1123 2 AOI22S $T=430900 436920 1 180 $X=427180 $Y=436540
X1144 179 172 1182 1141 1 1144 2 AOI22S $T=430900 477240 0 180 $X=427180 $Y=471820
X1145 1185 1181 1184 1102 1 1113 2 AOI22S $T=431520 467160 0 180 $X=427800 $Y=461740
X1146 1185 1181 1188 1141 1 1169 2 AOI22S $T=431520 467160 1 180 $X=427800 $Y=466780
X1147 156 187 191 1171 1 1169 2 AOI22S $T=434620 426840 0 180 $X=430900 $Y=421420
X1148 199 192 1205 1189 1 1109 2 AOI22S $T=435240 436920 0 180 $X=431520 $Y=431500
X1149 1158 1140 1195 194 1 190 2 AOI22S $T=435860 416760 0 180 $X=432140 $Y=411340
X1150 199 197 1202 180 1 1169 2 AOI22S $T=435860 487320 1 180 $X=432140 $Y=486940
X1151 156 1121 1200 1113 1 1141 2 AOI22S $T=436480 457080 1 180 $X=432760 $Y=456700
X1152 1185 1181 1210 1113 1 1171 2 AOI22S $T=438340 467160 0 180 $X=434620 $Y=461740
X1153 1185 1181 1192 197 1 1141 2 AOI22S $T=438340 477240 0 180 $X=434620 $Y=471820
X1154 1207 1196 1187 202 1 201 2 AOI22S $T=438960 487320 0 180 $X=435240 $Y=481900
X1155 1198 205 1208 1199 1 138 2 AOI22S $T=440200 426840 0 180 $X=436480 $Y=421420
X1156 1207 1196 1193 1096 1 1030 2 AOI22S $T=438960 457080 1 0 $X=438960 $Y=451660
X1157 1207 1196 1197 197 1 202 2 AOI22S $T=439580 467160 0 0 $X=439580 $Y=466780
X1158 1185 1181 1203 213 1 218 2 AOI22S $T=440820 477240 1 0 $X=440820 $Y=471820
X1159 1207 1196 1211 214 1 216 2 AOI22S $T=442060 477240 0 0 $X=442060 $Y=476860
X1160 1198 192 1226 1199 1 1109 2 AOI22S $T=448260 426840 0 180 $X=444540 $Y=421420
X1161 1228 1121 1221 1096 1 202 2 AOI22S $T=448260 457080 0 180 $X=444540 $Y=451660
X1162 1212 187 219 1102 1 197 2 AOI22S $T=448880 416760 0 180 $X=445160 $Y=411340
X1163 1207 1196 1215 1102 1 1096 2 AOI22S $T=445160 457080 0 0 $X=445160 $Y=456700
X1164 1228 1217 1234 1064 1 218 2 AOI22S $T=449500 447000 0 180 $X=445780 $Y=441580
X1165 1185 1181 1222 218 1 201 2 AOI22S $T=449500 467160 0 180 $X=445780 $Y=461740
X1166 1207 1196 1230 213 1 214 2 AOI22S $T=449500 477240 1 0 $X=449500 $Y=471820
X1167 1228 1217 234 1030 1 201 2 AOI22S $T=455700 447000 0 180 $X=451980 $Y=441580
X1168 159 195 229 227 1 226 2 AOI22S $T=456320 416760 0 180 $X=452600 $Y=411340
X1169 1198 232 1248 1225 1 222 2 AOI22S $T=455700 416760 0 0 $X=455700 $Y=416380
X1170 205 1251 1232 1160 1 1189 2 AOI22S $T=457560 436920 1 0 $X=457560 $Y=431500
X1171 1158 235 1257 1189 1 205 2 AOI22S $T=462520 426840 0 180 $X=458800 $Y=421420
X1172 1269 1256 1265 192 1 205 2 AOI22S $T=462520 436920 1 180 $X=458800 $Y=436540
X1173 222 1264 1180 1268 1 1266 2 AOI22S $T=462520 416760 0 0 $X=462520 $Y=416380
X1174 212 1271 1275 1268 1 1266 2 AOI22S $T=466860 426840 1 180 $X=463140 $Y=426460
X1175 1262 1256 1280 1064 1 1030 2 AOI22S $T=467480 457080 1 180 $X=463760 $Y=456700
X1176 1262 1256 1279 1023 1 1064 2 AOI22S $T=468100 447000 1 180 $X=464380 $Y=446620
X1177 1269 1256 1277 235 1 192 2 AOI22S $T=468720 436920 0 180 $X=465000 $Y=431500
X1178 1218 1229 1285 1023 1 1051 2 AOI22S $T=470580 467160 0 180 $X=466860 $Y=461740
X1179 1262 238 1284 127 1 142 2 AOI22S $T=470580 467160 1 180 $X=466860 $Y=466780
X1180 1212 187 243 1051 1 214 2 AOI22S $T=472440 416760 0 180 $X=468720 $Y=411340
X1181 242 1256 1291 232 1 212 2 AOI22S $T=472440 426840 1 180 $X=468720 $Y=426460
X1182 1282 1229 1278 235 1 211 2 AOI22S $T=468720 447000 1 0 $X=468720 $Y=441580
X1183 1296 240 1290 1266 1 212 2 AOI22S $T=473060 426840 0 180 $X=469340 $Y=421420
X1184 1282 1229 1287 1051 1 1048 2 AOI22S $T=473060 447000 0 0 $X=473060 $Y=446620
X1185 242 1301 1308 231 1 227 2 AOI22S $T=478640 426840 1 180 $X=474920 $Y=426460
X1186 1311 1305 1281 211 1 227 2 AOI22S $T=478640 436920 0 180 $X=474920 $Y=431500
X1187 223 247 253 1155 1 1261 2 AOI22S $T=482360 477240 1 180 $X=478640 $Y=476860
X1188 1212 187 251 1056 1 237 2 AOI22S $T=482980 416760 0 180 $X=479260 $Y=411340
X1189 1311 1305 1312 240 1 250 2 AOI22S $T=481120 426840 1 0 $X=481120 $Y=421420
X1190 242 1301 1325 249 1 231 2 AOI22S $T=486080 426840 1 180 $X=482360 $Y=426460
X1191 215 247 259 1174 1 1261 2 AOI22S $T=488560 477240 1 180 $X=484840 $Y=476860
X1192 1228 1267 266 1060 1 1112 2 AOI22S $T=489800 467160 1 180 $X=486080 $Y=466780
X1193 242 1301 1338 240 1 232 2 AOI22S $T=491040 416760 1 180 $X=487320 $Y=416380
X1194 1311 1305 1345 249 1 263 2 AOI22S $T=492280 426840 1 180 $X=488560 $Y=426460
X1195 1323 1332 1331 1261 1 1336 2 AOI22S $T=488560 477240 0 0 $X=488560 $Y=476860
X1196 1323 1332 1333 1349 1 1261 2 AOI22S $T=490420 477240 1 0 $X=490420 $Y=471820
X1197 1309 1336 1341 1163 1 1268 2 AOI22S $T=494760 457080 1 180 $X=491040 $Y=456700
X1198 1311 1305 1355 263 1 271 2 AOI22S $T=498480 416760 1 180 $X=494760 $Y=416380
X1199 246 255 278 274 1 273 2 AOI22S $T=499720 416760 0 180 $X=496000 $Y=411340
X1200 1350 1336 280 1179 1 1268 2 AOI22S $T=500340 447000 1 180 $X=496620 $Y=446620
X1201 1327 1351 1358 1349 1 1340 2 AOI22S $T=500340 477240 0 180 $X=496620 $Y=471820
X1202 1327 1351 275 1340 1 247 2 AOI22S $T=497240 487320 1 0 $X=497240 $Y=481900
X1203 236 248 1348 283 1 277 2 AOI22S $T=497240 487320 0 0 $X=497240 $Y=486940
X1204 1360 1336 1363 1251 1 1268 2 AOI22S $T=503440 436920 0 180 $X=499720 $Y=431500
X1205 1283 1336 1367 1172 1 1268 2 AOI22S $T=506540 447000 1 180 $X=502820 $Y=446620
X1206 283 286 1364 277 1 288 2 AOI22S $T=504680 497400 0 0 $X=504680 $Y=497020
X1207 1311 1305 1342 1378 1 293 2 AOI22S $T=505920 416760 0 0 $X=505920 $Y=416380
X1208 261 1267 1375 1116 1 1313 2 AOI22S $T=510260 477240 0 180 $X=506540 $Y=471820
X1209 1380 1381 291 1356 1 1349 2 AOI22S $T=515220 487320 0 180 $X=511500 $Y=481900
X1210 246 287 305 1382 1 299 2 AOI22S $T=516460 416760 1 180 $X=512740 $Y=416380
X1211 261 294 1392 1161 1 276 2 AOI22S $T=516460 477240 1 180 $X=512740 $Y=476860
X1212 1380 1381 303 277 1 1368 2 AOI22S $T=516460 487320 1 180 $X=512740 $Y=486940
X1213 261 294 1390 1272 1 314 2 AOI22S $T=517700 497400 1 0 $X=517700 $Y=491980
X1214 1418 1403 1408 1407 1 1356 2 AOI22S $T=527620 467160 1 180 $X=523900 $Y=466780
X1215 1356 1405 1404 1349 1 1410 2 AOI22S $T=524520 487320 1 0 $X=524520 $Y=481900
X1216 327 1381 1419 281 1 1356 2 AOI22S $T=528240 487320 1 180 $X=524520 $Y=486940
X1217 1420 1411 1416 297 1 1409 2 AOI22S $T=529480 457080 0 180 $X=525760 $Y=451660
X1218 1349 1405 1398 1428 1 1410 2 AOI22S $T=530100 487320 0 0 $X=530100 $Y=486940
X1219 1420 1411 1436 1430 1 297 2 AOI22S $T=536300 457080 0 180 $X=532580 $Y=451660
X1220 1421 1434 1413 1430 1 1440 2 AOI22S $T=533820 447000 1 0 $X=533820 $Y=441580
X1221 1418 1403 348 1368 1 290 2 AOI22S $T=540020 477240 1 180 $X=536300 $Y=476860
X1222 1421 308 1445 1440 1 1450 2 AOI22S $T=538160 457080 1 0 $X=538160 $Y=451660
X1223 347 349 1388 1456 1 357 2 AOI22S $T=541880 487320 1 0 $X=541880 $Y=481900
X1224 356 349 1431 359 1 357 2 AOI22S $T=546220 497400 0 0 $X=546220 $Y=497020
X1225 355 349 1397 363 1 357 2 AOI22S $T=548080 497400 1 0 $X=548080 $Y=491980
X1226 362 1411 1467 355 1 1475 2 AOI22S $T=549320 477240 0 0 $X=549320 $Y=476860
X1227 1458 349 1415 1478 1 357 2 AOI22S $T=551800 426840 0 0 $X=551800 $Y=426460
X1228 1420 1411 1472 178 1 1161 2 AOI22S $T=551800 467160 1 0 $X=551800 $Y=461740
X1229 1475 349 1386 367 1 357 2 AOI22S $T=551800 477240 1 0 $X=551800 $Y=471820
X1230 379 1481 1463 347 1 368 2 AOI22S $T=556760 487320 1 180 $X=553040 $Y=486940
X1231 1487 375 1485 372 1 293 2 AOI22S $T=560480 426840 0 180 $X=556760 $Y=421420
X1232 362 345 1492 1456 1 363 2 AOI22S $T=561100 497400 0 180 $X=557380 $Y=491980
X1233 362 345 1499 1272 1 178 2 AOI22S $T=561720 477240 0 180 $X=558000 $Y=471820
X1234 1487 375 1497 381 1 380 2 AOI22S $T=564200 436920 1 180 $X=560480 $Y=436540
X1235 353 1459 1502 1496 1 381 2 AOI22S $T=565440 447000 0 180 $X=561720 $Y=441580
X1236 379 1481 1489 1272 1 384 2 AOI22S $T=561720 467160 1 0 $X=561720 $Y=461740
X1237 379 1481 1507 384 1 383 2 AOI22S $T=566060 467160 1 180 $X=562340 $Y=466780
X1238 1487 375 1504 341 1 372 2 AOI22S $T=567920 416760 0 180 $X=564200 $Y=411340
X1239 1487 375 1501 380 1 387 2 AOI22S $T=565440 426840 1 0 $X=565440 $Y=421420
X1240 345 1481 1503 1456 1 363 2 AOI22S $T=565440 487320 0 0 $X=565440 $Y=486940
X1241 389 1459 1509 341 1 395 2 AOI22S $T=569160 416760 0 0 $X=569160 $Y=416380
X1242 389 1459 1513 395 1 398 2 AOI22S $T=570400 416760 1 0 $X=570400 $Y=411340
X1243 1374 1530 1523 1460 1 1536 2 AOI22S $T=577840 457080 0 0 $X=577840 $Y=456700
X1244 1396 1530 1526 1490 1 1536 2 AOI22S $T=580320 457080 1 0 $X=580320 $Y=451660
X1245 1538 1460 1541 1536 1 1542 2 AOI22S $T=580940 477240 1 0 $X=580940 $Y=471820
X1246 1396 1533 1548 1490 1 1437 2 AOI22S $T=584660 467160 0 0 $X=584660 $Y=466780
X1247 1374 1533 1547 1460 1 1437 2 AOI22S $T=585280 457080 0 0 $X=585280 $Y=456700
X1248 1524 1554 1558 1264 1 1533 2 AOI22S $T=590860 426840 0 180 $X=587140 $Y=421420
X1249 1559 415 1553 384 1 1466 2 AOI22S $T=592100 477240 0 180 $X=588380 $Y=471820
X1250 420 415 1565 408 1 1466 2 AOI22S $T=595820 487320 1 180 $X=592100 $Y=486940
X1251 1532 1554 1563 1271 1 1533 2 AOI22S $T=593960 426840 1 0 $X=593960 $Y=421420
X1252 1529 1533 1572 1470 1 1536 2 AOI22S $T=599540 467160 0 180 $X=595820 $Y=461740
X1253 1255 1495 1575 1530 1 1554 2 AOI22S $T=601400 447000 1 180 $X=597680 $Y=446620
X1254 1255 1320 1576 1584 1 1585 2 AOI22S $T=602640 447000 0 0 $X=602640 $Y=446620
X1255 1258 1529 1589 1530 1 1554 2 AOI22S $T=606980 447000 0 180 $X=603260 $Y=441580
X1256 1320 1406 1594 1584 1 1585 2 AOI22S $T=610700 447000 0 180 $X=606980 $Y=441580
X1257 1258 1346 1592 1583 1 1585 2 AOI22S $T=607600 436920 0 0 $X=607600 $Y=436540
X1258 1483 1564 1591 1583 1 1585 2 AOI22S $T=608220 426840 1 0 $X=608220 $Y=421420
X1259 411 1483 1596 1605 1 397 2 AOI22S $T=612560 487320 0 0 $X=612560 $Y=486940
X1260 1346 1470 1603 1583 1 1585 2 AOI22S $T=614420 436920 0 0 $X=614420 $Y=436540
X1261 1495 1585 1604 1406 1 1583 2 AOI22S $T=614420 457080 1 0 $X=614420 $Y=451660
X1262 1494 1531 462 1599 1 1605 2 AOI22S $T=621240 477240 1 180 $X=617520 $Y=476860
X1263 1494 1531 1609 409 1 1599 2 AOI22S $T=621860 467160 1 180 $X=618140 $Y=466780
X1264 1599 1543 1623 409 1 445 2 AOI22S $T=625580 487320 0 0 $X=625580 $Y=486940
X1265 409 1543 461 411 1 445 2 AOI22S $T=629300 497400 0 180 $X=625580 $Y=491980
X1266 1645 1616 468 464 1 1638 2 AOI22S $T=638600 467160 0 180 $X=634880 $Y=461740
X1267 473 471 475 1650 1 469 2 AOI22S $T=644180 497400 1 180 $X=640460 $Y=497020
X1268 473 471 1668 1654 1 1650 2 AOI22S $T=647900 497400 0 180 $X=644180 $Y=491980
X1269 1664 1666 478 1665 1 1659 2 AOI22S $T=650380 487320 0 180 $X=646660 $Y=481900
X1270 1664 1666 1677 1676 1 1665 2 AOI22S $T=654100 487320 1 0 $X=654100 $Y=481900
X1271 1673 1688 1687 1698 1 1654 2 AOI22S $T=659680 487320 0 0 $X=659680 $Y=486940
X1272 1701 1697 1699 466 1 1692 2 AOI22S $T=664020 416760 1 180 $X=660300 $Y=416380
X1273 1673 1688 1704 1658 1 1695 2 AOI22S $T=664020 467160 1 180 $X=660300 $Y=466780
X1274 1664 1666 1682 1696 1 1676 2 AOI22S $T=660300 487320 1 0 $X=660300 $Y=481900
X1275 490 1606 1698 1685 1 492 2 AOI22S $T=661540 426840 0 0 $X=661540 $Y=426460
X1276 1706 1726 1721 1723 1 1718 2 AOI22S $T=676420 457080 0 180 $X=672700 $Y=451660
X1277 1701 1697 1731 499 1 498 2 AOI22S $T=677660 416760 0 180 $X=673940 $Y=411340
X1278 1727 1666 1722 1750 1 1696 2 AOI22S $T=674560 487320 1 0 $X=674560 $Y=481900
X1279 1706 1726 1734 1748 1 1723 2 AOI22S $T=678280 457080 1 0 $X=678280 $Y=451660
X1280 1701 1697 1760 487 1 1737 2 AOI22S $T=683860 416760 1 180 $X=680140 $Y=416380
X1281 1727 1666 1747 1749 1 1750 2 AOI22S $T=682000 477240 1 0 $X=682000 $Y=471820
X1282 1706 1726 1758 1753 1 1748 2 AOI22S $T=688200 457080 0 180 $X=684480 $Y=451660
X1283 1717 1726 1764 1755 1 1744 2 AOI22S $T=688820 436920 1 180 $X=685100 $Y=436540
X1284 1706 1726 1761 1744 1 1753 2 AOI22S $T=688820 447000 1 180 $X=685100 $Y=446620
X1285 1727 1766 1768 1762 1 1749 2 AOI22S $T=692540 477240 0 180 $X=688820 $Y=471820
X1286 337 1697 1765 490 1 1771 2 AOI22S $T=690060 426840 0 0 $X=690060 $Y=426460
X1287 1727 1766 1772 1778 1 1762 2 AOI22S $T=693780 467160 0 0 $X=693780 $Y=466780
X1288 77 69 1 2 BUF2 $T=313720 436920 1 180 $X=310620 $Y=436540
X1289 81 935 1 2 BUF2 $T=318680 487320 0 180 $X=315580 $Y=481900
X1290 1165 199 1 2 BUF2 $T=425940 426840 0 0 $X=425940 $Y=426460
X1291 1225 1199 1 2 BUF2 $T=448260 416760 1 180 $X=445160 $Y=416380
X1292 1199 1135 1 2 BUF2 $T=445160 436920 1 0 $X=445160 $Y=431500
X1293 1296 1158 1 2 BUF2 $T=473060 426840 1 0 $X=473060 $Y=421420
X1294 308 1385 1 2 BUF2 $T=518320 447000 1 180 $X=515220 $Y=446620
X1295 1387 1337 1 2 BUF2 $T=518320 447000 0 0 $X=518320 $Y=446620
X1296 296 1241 1 2 BUF2 $T=528860 467160 1 0 $X=528860 $Y=461740
X1297 1383 358 1 2 BUF2 $T=543120 436920 1 0 $X=543120 $Y=431500
X1298 1421 389 1 2 BUF2 $T=572880 416760 0 0 $X=572880 $Y=416380
X1299 1448 1675 1 2 BUF2 $T=650380 487320 1 0 $X=650380 $Y=481900
X1300 88 87 1 2 INV2 $T=326740 487320 0 0 $X=326740 $Y=486940
X1301 172 158 1 2 INV2 $T=414780 477240 0 180 $X=412920 $Y=471820
X1302 1135 1157 1 2 INV2 $T=419120 477240 1 0 $X=419120 $Y=471820
X1303 1158 1131 1 2 INV2 $T=422220 416760 0 180 $X=420360 $Y=411340
X1304 1243 1185 1 2 INV2 $T=452600 457080 0 180 $X=450740 $Y=451660
X1305 1240 1233 1 2 INV2 $T=453840 457080 0 0 $X=453840 $Y=456700
X1306 1241 1256 1 2 INV2 $T=461900 457080 0 0 $X=461900 $Y=456700
X1307 1307 1229 1 2 INV2 $T=476780 447000 0 0 $X=476780 $Y=446620
X1308 1357 1252 1 2 INV2 $T=501580 457080 1 0 $X=501580 $Y=451660
X1309 1365 247 1 2 INV2 $T=506540 477240 1 180 $X=504680 $Y=476860
X1310 1370 302 1 2 INV2 $T=507160 497400 1 0 $X=507160 $Y=491980
X1311 1326 1357 1 2 INV2 $T=509640 447000 0 0 $X=509640 $Y=446620
X1312 1385 1326 1 2 INV2 $T=515220 447000 0 180 $X=513360 $Y=441580
X1313 1389 306 1 2 INV2 $T=517700 426840 0 180 $X=515840 $Y=421420
X1314 1385 1383 1 2 INV2 $T=517080 436920 1 0 $X=517080 $Y=431500
X1315 1314 307 1 2 INV2 $T=517080 487320 1 0 $X=517080 $Y=481900
X1316 296 320 1 2 INV2 $T=521420 467160 0 0 $X=521420 $Y=466780
X1317 1420 1387 1 2 INV2 $T=529480 457080 1 0 $X=529480 $Y=451660
X1318 1425 1422 1 2 INV2 $T=533820 436920 1 180 $X=531960 $Y=436540
X1319 331 1412 1 2 INV2 $T=533200 416760 0 0 $X=533200 $Y=416380
X1320 338 1432 1 2 INV2 $T=537540 416760 0 0 $X=537540 $Y=416380
X1321 1357 1442 1 2 INV2 $T=540020 467160 0 0 $X=540020 $Y=466780
X1322 1449 1433 1 2 INV2 $T=541260 436920 1 0 $X=541260 $Y=431500
X1323 1451 1420 1 2 INV2 $T=541880 457080 1 0 $X=541880 $Y=451660
X1324 1451 353 1 2 INV2 $T=543740 457080 1 0 $X=543740 $Y=451660
X1325 1453 1451 1 2 INV2 $T=564200 436920 0 0 $X=564200 $Y=436540
X1326 396 1435 1 2 INV2 $T=571640 477240 0 0 $X=571640 $Y=476860
X1327 1518 396 1 2 INV2 $T=575360 487320 0 180 $X=573500 $Y=481900
X1328 401 1527 1 2 INV2 $T=577220 477240 0 0 $X=577220 $Y=476860
X1329 403 1518 1 2 INV2 $T=579700 447000 1 180 $X=577840 $Y=446620
X1330 1527 409 1 2 INV2 $T=597680 487320 0 0 $X=597680 $Y=486940
X1331 1417 439 1 2 INV2 $T=619380 426840 0 180 $X=617520 $Y=421420
X1332 1624 458 1 2 INV2 $T=629300 467160 0 0 $X=629300 $Y=466780
X1333 1652 479 1 2 INV2 $T=646040 457080 0 0 $X=646040 $Y=456700
X1334 429 546 1 2 INV2 $T=765080 436920 1 0 $X=765080 $Y=431500
X1335 546 543 1 2 INV2 $T=766940 487320 0 180 $X=765080 $Y=481900
X1336 434 556 1 2 INV2 $T=773760 477240 1 0 $X=773760 $Y=471820
X1337 570 576 1 2 INV2 $T=785540 497400 0 0 $X=785540 $Y=497020
X1338 777 10 1 777 774 772 2 MOAI1S $T=227540 416760 1 180 $X=223820 $Y=416380
X1339 777 27 1 24 800 802 2 MOAI1S $T=239940 426840 1 0 $X=239940 $Y=421420
X1340 846 844 1 846 844 838 2 MOAI1S $T=266600 487320 0 180 $X=262880 $Y=481900
X1341 44 45 1 44 45 856 2 MOAI1S $T=263500 497400 1 0 $X=263500 $Y=491980
X1342 827 849 1 849 827 855 2 MOAI1S $T=265360 457080 0 0 $X=265360 $Y=456700
X1343 850 855 1 850 855 864 2 MOAI1S $T=268460 467160 1 0 $X=268460 $Y=461740
X1344 857 835 1 857 835 867 2 MOAI1S $T=269700 436920 0 0 $X=269700 $Y=436540
X1345 851 859 1 851 859 868 2 MOAI1S $T=272800 436920 1 0 $X=272800 $Y=431500
X1346 831 867 1 831 867 876 2 MOAI1S $T=275900 436920 0 0 $X=275900 $Y=436540
X1347 860 838 1 860 838 880 2 MOAI1S $T=276520 487320 1 0 $X=276520 $Y=481900
X1348 868 848 1 868 848 882 2 MOAI1S $T=277140 426840 0 0 $X=277140 $Y=426460
X1349 66 65 1 66 65 906 2 MOAI1S $T=296360 497400 0 180 $X=292640 $Y=491980
X1350 55 906 1 55 906 930 2 MOAI1S $T=300080 497400 0 0 $X=300080 $Y=497020
X1351 936 933 1 936 933 932 2 MOAI1S $T=309380 436920 1 180 $X=305660 $Y=436540
X1352 951 949 1 951 949 946 2 MOAI1S $T=313720 467160 1 180 $X=310000 $Y=466780
X1353 960 957 1 960 957 958 2 MOAI1S $T=318060 426840 1 180 $X=314340 $Y=426460
X1354 965 964 1 965 964 962 2 MOAI1S $T=319920 436920 1 180 $X=316200 $Y=436540
X1355 80 79 1 80 79 967 2 MOAI1S $T=321160 497400 0 180 $X=317440 $Y=491980
X1356 987 85 1 975 972 973 2 MOAI1S $T=324880 457080 0 180 $X=321160 $Y=451660
X1357 981 979 1 981 979 971 2 MOAI1S $T=326740 477240 0 180 $X=323020 $Y=471820
X1358 84 967 1 84 967 996 2 MOAI1S $T=324260 497400 1 0 $X=324260 $Y=491980
X1359 987 91 1 993 945 995 2 MOAI1S $T=327980 436920 1 0 $X=327980 $Y=431500
X1360 1001 974 1 1001 974 1000 2 MOAI1S $T=336040 447000 1 180 $X=332320 $Y=446620
X1361 987 1010 1 993 994 1003 2 MOAI1S $T=338520 426840 1 180 $X=334800 $Y=426460
X1362 1009 101 1 1009 101 1032 2 MOAI1S $T=337900 416760 1 0 $X=337900 $Y=411340
X1363 1011 1018 1 1011 1018 1010 2 MOAI1S $T=344720 436920 0 180 $X=341000 $Y=431500
X1364 1015 880 1 975 1024 1029 2 MOAI1S $T=341000 477240 0 0 $X=341000 $Y=476860
X1365 1015 856 1 975 1021 1031 2 MOAI1S $T=341620 487320 1 0 $X=341620 $Y=481900
X1366 1019 1020 1 1019 1020 1018 2 MOAI1S $T=342860 426840 1 0 $X=342860 $Y=421420
X1367 1025 959 1 1025 959 1022 2 MOAI1S $T=346580 447000 1 180 $X=342860 $Y=446620
X1368 1034 1030 1 998 882 1027 2 MOAI1S $T=349060 457080 1 180 $X=345340 $Y=456700
X1369 1015 996 1 105 106 1026 2 MOAI1S $T=345960 497400 1 0 $X=345960 $Y=491980
X1370 1012 1013 1 1012 1013 1037 2 MOAI1S $T=347200 436920 0 0 $X=347200 $Y=436540
X1371 1015 930 1 975 108 1038 2 MOAI1S $T=347200 477240 0 0 $X=347200 $Y=476860
X1372 987 1032 1 993 978 1039 2 MOAI1S $T=347820 426840 0 0 $X=347820 $Y=426460
X1373 987 1040 1 993 986 1044 2 MOAI1S $T=353400 436920 0 0 $X=353400 $Y=436540
X1374 987 1041 1 993 1017 1046 2 MOAI1S $T=353400 447000 0 0 $X=353400 $Y=446620
X1375 111 112 1 111 112 1043 2 MOAI1S $T=354020 416760 1 0 $X=354020 $Y=411340
X1376 1028 1037 1 1028 1037 1040 2 MOAI1S $T=360220 436920 0 0 $X=360220 $Y=436540
X1377 1049 121 1 1049 121 1062 2 MOAI1S $T=361460 416760 0 0 $X=361460 $Y=416380
X1378 1034 1008 1 998 876 1050 2 MOAI1S $T=365180 457080 1 180 $X=361460 $Y=456700
X1379 125 126 1 125 126 1057 2 MOAI1S $T=367660 497400 0 0 $X=367660 $Y=497020
X1380 124 1062 1 124 1062 1072 2 MOAI1S $T=370760 416760 0 0 $X=370760 $Y=416380
X1381 1067 1052 1 1067 1052 130 2 MOAI1S $T=375720 497400 1 180 $X=372000 $Y=497020
X1382 1074 1034 1 1073 998 1070 2 MOAI1S $T=379440 457080 1 180 $X=375720 $Y=456700
X1383 1075 135 1 137 1082 139 2 MOAI1S $T=378820 416760 1 0 $X=378820 $Y=411340
X1384 145 1076 1 1086 137 1080 2 MOAI1S $T=386880 457080 0 180 $X=383160 $Y=451660
X1385 145 138 1 1088 137 1063 2 MOAI1S $T=387500 436920 0 180 $X=383780 $Y=431500
X1386 145 1077 1 1090 137 1061 2 MOAI1S $T=389360 436920 1 180 $X=385640 $Y=436540
X1387 1034 1091 1 1083 132 1081 2 MOAI1S $T=389360 487320 1 180 $X=385640 $Y=486940
X1388 147 1098 1 147 1098 1097 2 MOAI1S $T=397420 426840 1 180 $X=393700 $Y=426460
X1389 1102 1123 1 1106 978 1115 2 MOAI1S $T=406720 436920 0 180 $X=403000 $Y=431500
X1390 1093 1117 1 1116 1117 1129 2 MOAI1S $T=405480 477240 1 0 $X=405480 $Y=471820
X1391 141 1129 1 161 1133 1114 2 MOAI1S $T=407960 477240 0 0 $X=407960 $Y=476860
X1392 171 1135 1 1132 162 1128 2 MOAI1S $T=412920 426840 1 180 $X=409200 $Y=426460
X1393 1105 960 1 158 945 1139 2 MOAI1S $T=409200 436920 0 0 $X=409200 $Y=436540
X1394 1122 1134 1 1122 1134 169 2 MOAI1S $T=409820 497400 1 0 $X=409820 $Y=491980
X1395 1124 166 1 1136 170 1142 2 MOAI1S $T=411060 416760 0 0 $X=411060 $Y=416380
X1396 1107 960 1 1136 945 1146 2 MOAI1S $T=416020 436920 1 0 $X=416020 $Y=431500
X1397 965 1135 1 1132 986 1150 2 MOAI1S $T=424700 436920 1 180 $X=420980 $Y=436540
X1398 212 1199 1 1132 188 1204 2 MOAI1S $T=442680 416760 1 180 $X=438960 $Y=416380
X1399 222 1158 1 1136 225 1237 2 MOAI1S $T=450120 416760 0 0 $X=450120 $Y=416380
X1400 1218 146 1 1120 1250 1253 2 MOAI1S $T=454460 477240 1 0 $X=454460 $Y=471820
X1401 238 142 1 1219 133 1260 2 MOAI1S $T=465620 477240 0 180 $X=461900 $Y=471820
X1402 1218 142 1 133 1250 1295 2 MOAI1S $T=468100 477240 1 0 $X=468100 $Y=471820
X1403 1218 127 1 1112 1252 1322 2 MOAI1S $T=479880 467160 0 0 $X=479880 $Y=466780
X1404 1313 1315 1 1313 1315 1324 2 MOAI1S $T=481740 497400 0 0 $X=481740 $Y=497020
X1405 272 1324 1 269 268 1263 2 MOAI1S $T=495380 497400 0 180 $X=491660 $Y=491980
X1406 1311 297 1 285 1383 1384 2 MOAI1S $T=512120 426840 1 0 $X=512120 $Y=421420
X1407 1411 1450 1 1455 1458 1452 2 MOAI1S $T=541880 447000 0 0 $X=541880 $Y=446620
X1408 1474 1475 1 1476 1479 1484 2 MOAI1S $T=552420 447000 0 0 $X=552420 $Y=446620
X1409 1474 1458 1 1469 1473 1488 2 MOAI1S $T=556760 436920 0 0 $X=556760 $Y=436540
X1410 367 1491 1 367 1491 1486 2 MOAI1S $T=559860 487320 1 0 $X=559860 $Y=481900
X1411 1542 1561 1 1525 1527 1566 2 MOAI1S $T=592720 477240 0 0 $X=592720 $Y=476860
X1412 1622 456 1 1622 456 1659 2 MOAI1S $T=629920 477240 1 0 $X=629920 $Y=471820
X1413 1448 450 1 1448 450 1641 2 MOAI1S $T=633020 487320 1 0 $X=633020 $Y=481900
X1414 1556 465 1 1556 465 469 2 MOAI1S $T=635500 497400 1 0 $X=635500 $Y=491980
X1415 1574 465 1 1574 1638 1650 2 MOAI1S $T=637360 487320 0 0 $X=637360 $Y=486940
X1416 456 1645 1 456 1645 1665 2 MOAI1S $T=650380 467160 1 0 $X=650380 $Y=461740
X1417 1556 1671 1 1556 1671 1676 2 MOAI1S $T=650380 477240 1 0 $X=650380 $Y=471820
X1418 317 1669 1 317 1663 1684 2 MOAI1S $T=651620 447000 0 0 $X=651620 $Y=446620
X1419 1574 1671 1 1574 1671 1696 2 MOAI1S $T=656580 477240 1 0 $X=656580 $Y=471820
X1420 1663 467 1 1663 467 1683 2 MOAI1S $T=661540 447000 0 180 $X=657820 $Y=441580
X1421 1685 487 1 1685 487 1695 2 MOAI1S $T=658440 436920 0 0 $X=658440 $Y=436540
X1422 1700 1694 1 1690 1683 1679 2 MOAI1S $T=662160 447000 1 180 $X=658440 $Y=446620
X1423 1693 453 1 1693 453 1692 2 MOAI1S $T=660920 426840 1 0 $X=660920 $Y=421420
X1424 1703 1645 1 1703 1645 1702 2 MOAI1S $T=668360 436920 1 180 $X=664640 $Y=436540
X1425 1697 1645 1 494 1641 1707 2 MOAI1S $T=666500 457080 0 0 $X=666500 $Y=456700
X1426 1697 488 1 494 1712 1715 2 MOAI1S $T=667120 436920 1 0 $X=667120 $Y=431500
X1427 1693 484 1 1693 484 1712 2 MOAI1S $T=668360 426840 0 0 $X=668360 $Y=426460
X1428 1700 1718 1 1690 1702 1708 2 MOAI1S $T=672080 447000 1 180 $X=668360 $Y=446620
X1429 1675 317 1 1675 317 1719 2 MOAI1S $T=670840 416760 0 0 $X=670840 $Y=416380
X1430 484 1703 1 484 1703 1718 2 MOAI1S $T=675180 436920 1 180 $X=671460 $Y=436540
X1431 1720 488 1 1720 488 1723 2 MOAI1S $T=673320 436920 1 0 $X=673320 $Y=431500
X1432 1710 1707 1 1710 1707 1741 2 MOAI1S $T=675180 477240 1 0 $X=675180 $Y=471820
X1433 1735 487 1 1735 487 1744 2 MOAI1S $T=677660 436920 0 0 $X=677660 $Y=436540
X1434 493 502 1 493 502 1737 2 MOAI1S $T=682620 416760 0 180 $X=678900 $Y=411340
X1435 1732 503 1 1732 503 1748 2 MOAI1S $T=678900 426840 1 0 $X=678900 $Y=421420
X1436 1606 1742 1 1606 1742 1753 2 MOAI1S $T=678900 447000 0 0 $X=678900 $Y=446620
X1437 1736 1740 1 1736 1740 1750 2 MOAI1S $T=681380 467160 0 0 $X=681380 $Y=466780
X1438 1720 1729 1 1720 1729 1755 2 MOAI1S $T=683860 426840 0 0 $X=683860 $Y=426460
X1439 1735 1726 1 1745 1751 1756 2 MOAI1S $T=683860 447000 1 0 $X=683860 $Y=441580
X1440 1606 1740 1 1606 1740 1749 2 MOAI1S $T=686960 467160 0 0 $X=686960 $Y=466780
X1441 1732 504 1 1732 504 1771 2 MOAI1S $T=690680 426840 1 0 $X=690680 $Y=421420
X1442 508 1742 1 508 1742 1769 2 MOAI1S $T=690680 447000 1 0 $X=690680 $Y=441580
X1443 414 1767 1 414 1767 1762 2 MOAI1S $T=690680 457080 1 0 $X=690680 $Y=451660
X1444 479 1767 1 1751 1767 1778 2 MOAI1S $T=693780 467160 1 0 $X=693780 $Y=461740
X1445 1786 1715 1 1786 1715 1784 2 MOAI1S $T=700600 457080 1 180 $X=696880 $Y=456700
X1446 1819 1869 1 1819 1869 1871 2 MOAI1S $T=743380 487320 0 0 $X=743380 $Y=486940
X1447 1849 1869 1 1849 1869 1880 2 MOAI1S $T=749580 497400 1 0 $X=749580 $Y=491980
X1448 637 685 1 637 685 686 2 MOAI1S $T=896520 416760 1 0 $X=896520 $Y=411340
X1449 2083 2081 1 2083 2081 2079 2 MOAI1S $T=926900 457080 1 180 $X=923180 $Y=456700
X1450 2099 2081 1 2099 2081 2102 2 MOAI1S $T=941780 457080 1 180 $X=938060 $Y=456700
X1451 1147 1 1119 176 2 1164 ND3 $T=419120 487320 1 0 $X=419120 $Y=481900
X1452 173 1 181 182 2 1166 ND3 $T=425940 497400 0 0 $X=425940 $Y=497020
X1453 1190 1 1186 193 2 189 ND3 $T=435240 447000 1 180 $X=432760 $Y=446620
X1454 1159 1 178 198 2 184 ND3 $T=432760 497400 1 0 $X=432760 $Y=491980
X1455 1208 1 1205 1194 2 1201 ND3 $T=440200 426840 1 180 $X=437720 $Y=426460
X1456 1200 1 1206 206 2 209 ND3 $T=438340 447000 0 0 $X=438340 $Y=446620
X1457 1221 1 1216 220 2 217 ND3 $T=448260 436920 1 180 $X=445780 $Y=436540
X1458 1234 1 1231 221 2 224 ND3 $T=449500 436920 0 0 $X=449500 $Y=436540
X1459 1270 1 1195 1276 2 1275 ND3 $T=464380 416760 1 0 $X=464380 $Y=411340
X1460 1362 1 284 1370 2 1364 ND3 $T=503440 497400 1 0 $X=503440 $Y=491980
X1461 1397 1 311 310 2 304 ND3 $T=520180 497400 1 180 $X=517700 $Y=497020
X1462 325 1 324 321 2 315 ND3 $T=526380 497400 1 180 $X=523900 $Y=497020
X1463 1415 1 1375 323 2 326 ND3 $T=527000 426840 1 180 $X=524520 $Y=426460
X1464 1426 1 334 1443 2 1429 ND3 $T=531340 477240 0 0 $X=531340 $Y=476860
X1465 1431 1 335 333 2 332 ND3 $T=533820 497400 0 180 $X=531340 $Y=491980
X1466 1458 1 1468 1476 2 369 ND3 $T=551180 436920 0 0 $X=551180 $Y=436540
X1467 1514 1 363 392 2 1456 ND3 $T=571640 487320 0 180 $X=569160 $Y=481900
X1468 1551 1 1553 412 2 1546 ND3 $T=587140 447000 1 0 $X=587140 $Y=441580
X1469 1551 1 1553 414 2 1546 ND3 $T=587140 447000 0 0 $X=587140 $Y=446620
X1470 1567 1 1571 1574 2 1547 ND3 $T=595820 457080 0 0 $X=595820 $Y=456700
X1471 1579 1 1571 1590 2 1572 ND3 $T=603880 467160 1 0 $X=603880 $Y=461740
X1472 1577 1 1562 1588 2 1580 ND3 $T=607600 487320 0 180 $X=605120 $Y=481900
X1473 1598 1 1592 432 2 1138 ND3 $T=610080 426840 1 180 $X=607600 $Y=426460
X1474 1570 1 1601 450 2 1602 ND3 $T=612560 477240 1 0 $X=612560 $Y=471820
X1475 1570 1 1608 1616 2 1611 ND3 $T=619380 467160 1 0 $X=619380 $Y=461740
X1476 1621 1 1577 457 2 1623 ND3 $T=625580 487320 1 0 $X=625580 $Y=481900
X1477 1729 1 497 509 2 1770 ND3 $T=690680 416760 1 0 $X=690680 $Y=411340
X1478 835 831 1 841 849 857 2 MOAI1 $T=260400 436920 0 0 $X=260400 $Y=436540
X1479 848 851 1 852 835 859 2 MOAI1 $T=265360 436920 1 0 $X=265360 $Y=431500
X1480 46 47 1 49 848 51 2 MOAI1 $T=267840 416760 1 0 $X=267840 $Y=411340
X1481 943 939 1 943 937 939 2 MOAI1 $T=313100 457080 0 180 $X=308760 $Y=451660
X1482 1166 173 1 1166 1175 173 2 MOAI1 $T=424080 487320 0 0 $X=424080 $Y=486940
X1483 184 1175 1 184 1177 1175 2 MOAI1 $T=430900 497400 0 180 $X=426560 $Y=491980
X1484 155 1214 1 204 1227 1223 2 MOAI1 $T=442060 497400 0 0 $X=442060 $Y=497020
X1485 1667 1691 1 1667 1673 1691 2 MOAI1 $T=662160 467160 1 0 $X=662160 $Y=461740
X1486 2142 2141 1 2142 2145 2141 2 MOAI1 $T=963480 477240 0 0 $X=963480 $Y=476860
X1487 2153 2152 1 2153 2141 2152 2 MOAI1 $T=977120 477240 0 180 $X=972780 $Y=471820
X1488 1709 1698 1673 2 1688 1695 1 AO22 $T=668360 477240 0 180 $X=663400 $Y=471820
X1489 1076 1059 1058 2 1 1086 XOR3 $T=383160 447000 0 0 $X=383160 $Y=446620
X1490 2014 2049 688 2 1 2067 XOR3 $T=907680 436920 0 0 $X=907680 $Y=436540
X1491 827 849 842 1 2 844 MAO222 $T=267840 477240 1 0 $X=267840 $Y=471820
X1492 860 844 846 1 2 52 MAO222 $T=269080 487320 1 0 $X=269080 $Y=481900
X1493 96 94 1009 1 2 93 MAO222 $T=333560 416760 0 180 $X=328600 $Y=411340
X1494 1013 1012 1028 1 2 1011 MAO222 $T=344720 436920 1 180 $X=339760 $Y=436540
X1495 1020 1019 1011 1 2 1009 MAO222 $T=347200 416760 1 180 $X=342240 $Y=416380
X1496 121 1049 124 1 2 1059 MAO222 $T=363940 426840 0 0 $X=363940 $Y=426460
X1497 1052 1067 136 1 2 1079 MAO222 $T=376340 497400 0 0 $X=376340 $Y=497020
X1498 2014 2049 688 1 2 2055 MAO222 $T=901480 436920 0 0 $X=901480 $Y=436540
X1499 1400 1516 1137 1 2 405 AO12 $T=574120 436920 0 0 $X=574120 $Y=436540
X1500 402 1508 1162 1 2 407 AO12 $T=580320 447000 1 0 $X=580320 $Y=441580
X1501 1400 1549 1183 1 2 413 AO12 $T=584040 426840 0 0 $X=584040 $Y=426460
X1502 1582 1587 1588 1 2 430 AO12 $T=604500 477240 0 0 $X=604500 $Y=476860
X1503 1999 1987 1996 1 2 1989 AO12 $T=858700 487320 0 180 $X=854980 $Y=481900
X1504 2012 2004 2016 1 2 2018 AO12 $T=872340 487320 0 0 $X=872340 $Y=486940
X1505 1077 1 1099 2 BUF4CK $T=394320 447000 1 0 $X=394320 $Y=441580
X1506 1123 1 180 2 BUF4CK $T=422220 477240 1 0 $X=422220 $Y=471820
X1507 1337 1 1303 2 BUF4CK $T=496000 467160 0 180 $X=491040 $Y=461740
X1508 1340 1 1261 2 BUF4CK $T=492280 477240 0 0 $X=492280 $Y=476860
X1509 296 1 339 2 BUF4CK $T=535060 467160 1 0 $X=535060 $Y=461740
X1510 290 1 2 1428 BUF1S $T=532580 487320 1 0 $X=532580 $Y=481900
X1511 417 2 1 1510 BUF3 $T=593340 436920 1 180 $X=589620 $Y=436540
X1512 1584 2 1 1583 BUF3 $T=610700 447000 1 0 $X=610700 $Y=441580
X1513 1084 1 1298 1304 2 ND2P $T=479260 497400 0 180 $X=475540 $Y=491980
X1514 1419 1 1423 337 2 ND2P $T=528860 487320 1 0 $X=528860 $Y=481900
X1515 462 1 461 527 2 ND2P $T=727260 487320 0 180 $X=723540 $Y=481900
X1516 1500 393 386 382 2 1 MXL2HS $T=572260 497400 1 180 $X=566680 $Y=497020
X1517 1729 1673 1714 476 2 1 MXL2HS $T=676420 467160 1 180 $X=670840 $Y=466780
X1518 1729 1769 1793 1788 2 1 MXL2HS $T=699980 447000 1 0 $X=699980 $Y=441580
X1519 1093 1110 1 1122 1126 1101 2 MOAI1H $T=401140 487320 1 0 $X=401140 $Y=481900
X1520 981 2 979 999 1 AN2B1S $T=328600 477240 1 0 $X=328600 $Y=471820
X1521 1617 2 1613 1624 1 AN2B1S $T=623720 467160 0 0 $X=623720 $Y=466780
X1522 1059 1076 1058 1084 1 2 MAO222P $T=376960 447000 0 0 $X=376960 $Y=446620
X1523 173 2 1126 1 1149 NR2P $T=417880 487320 1 180 $X=414160 $Y=486940
X1524 1133 2 1149 1 1159 NR2P $T=423460 487320 1 180 $X=419740 $Y=486940
X1525 188 2 158 1 1178 NR2P $T=430900 416760 0 0 $X=430900 $Y=416380
X1526 1239 2 1249 1 1255 NR2P $T=456940 447000 0 0 $X=456940 $Y=446620
X1527 1294 2 1293 1 248 NR2P $T=477400 487320 0 0 $X=477400 $Y=486940
X1528 338 2 331 1 1453 NR2P $T=542500 416760 0 0 $X=542500 $Y=416380
X1529 1450 2 1476 1 370 NR2P $T=557380 457080 1 180 $X=553660 $Y=456700
X1530 1496 2 385 1 1498 NR2P $T=566060 477240 1 180 $X=562340 $Y=476860
X1531 1498 2 388 1 1514 NR2P $T=571640 477240 1 180 $X=567920 $Y=476860
X1532 1506 2 1514 1 393 NR2P $T=569780 487320 0 0 $X=569780 $Y=486940
X1533 1550 2 1435 1 411 NR2P $T=591480 477240 1 180 $X=587760 $Y=476860
X1534 1765 2 1764 1 1775 NR2P $T=693780 436920 0 180 $X=690060 $Y=431500
X1535 464 456 1667 1671 476 1638 1 2 1688 OA222 $T=650380 467160 0 0 $X=650380 $Y=466780
X1536 496 513 508 503 1788 510 1 2 1766 OA222 $T=701840 436920 0 180 $X=696260 $Y=431500
X1537 1522 401 1 2 INV2CK $T=579700 477240 0 0 $X=579700 $Y=476860
X1538 457 505 1 2 INV2CK $T=688200 447000 1 0 $X=688200 $Y=441580
X1539 1518 1510 1522 1 2 OR2P $T=573500 477240 0 0 $X=573500 $Y=476860
X1540 158 162 1 1125 168 1145 2 OAI112HS $T=409820 467160 1 0 $X=409820 $Y=461740
X1541 1289 1313 1 1284 254 257 2 OAI112HS $T=482360 487320 0 0 $X=482360 $Y=486940
X1542 358 1478 1 1501 391 1511 2 OAI112HS $T=566060 426840 0 0 $X=566060 $Y=426460
X1543 377 394 1 1502 390 1505 2 OAI112HS $T=572880 436920 1 180 $X=568540 $Y=436540
X1544 377 1517 1 1497 1525 1520 2 OAI112HS $T=572260 436920 1 0 $X=572260 $Y=431500
X1545 400 1442 1 1519 397 1492 2 OAI112HS $T=577220 497400 1 180 $X=572880 $Y=497020
X1546 1466 388 1 1540 1543 1503 2 OAI112HS $T=586520 487320 1 180 $X=582180 $Y=486940
X1547 390 1527 1 1565 421 1557 2 OAI112HS $T=600780 487320 0 180 $X=596440 $Y=481900
X1548 1527 391 1 1593 431 1596 2 OAI112HS $T=605740 487320 0 0 $X=605740 $Y=486940
X1549 350 391 1 1595 451 444 2 OAI112HS $T=606980 497400 0 0 $X=606980 $Y=497020
X1550 2046 2044 2041 1 2 XNR2H $T=904580 497400 0 180 $X=895900 $Y=491980
X1551 186 1127 196 1191 2 1 203 OA112 $T=432140 447000 1 0 $X=432140 $Y=441580
X1552 1386 1392 309 1191 2 1 329 OA112 $T=516460 477240 1 0 $X=516460 $Y=471820
X1553 1388 1390 312 1191 2 1 316 OA112 $T=517080 477240 0 0 $X=517080 $Y=476860
X1554 342 1446 1438 350 2 1 1454 OA112 $T=539400 497400 1 0 $X=539400 $Y=491980
X1555 1558 1569 1525 1552 2 1 429 OA112 $T=595200 426840 0 0 $X=595200 $Y=426460
X1556 1194 1 2 200 INV3CK $T=437720 436920 0 0 $X=437720 $Y=436540
X1557 158 986 1 1130 1137 1143 2 OAI112H $T=409820 447000 0 0 $X=409820 $Y=446620
X1558 158 1095 1 1152 1167 1170 2 OAI112H $T=418500 426840 0 0 $X=418500 $Y=426460
X1559 262 1334 1335 2 264 1 270 AN4B1S $T=489180 416760 1 0 $X=489180 $Y=411340
X1560 1154 1162 1111 1156 1 2 ND3P $T=418500 457080 1 0 $X=418500 $Y=451660
X1561 1232 1246 1176 1213 1 2 ND3P $T=448880 426840 0 0 $X=448880 $Y=426460
X1562 1344 282 1348 1202 1 2 ND3P $T=498480 497400 1 0 $X=498480 $Y=491980
X1563 284 317 1398 1376 1 2 ND3P $T=517080 487320 0 0 $X=517080 $Y=486940
X1564 1573 433 1591 1290 1 2 ND3P $T=606360 416760 0 0 $X=606360 $Y=416380
X1565 1604 1606 1571 1600 1 2 ND3P $T=613800 457080 0 0 $X=613800 $Y=456700
X1566 1354 1257 1226 2 1 1372 AN3 $T=502820 426840 1 0 $X=502820 $Y=421420
X1567 1153 1576 1578 2 1 426 AN3 $T=600780 436920 0 0 $X=600780 $Y=436540
X1568 1400 1402 1246 1 2 313 AO12T $T=525140 436920 0 180 $X=520180 $Y=431500
X1569 1518 1549 1566 422 1 2 AO12P $T=592720 447000 1 0 $X=592720 $Y=441580
X1570 1560 402 1276 428 1 2 AO12P $T=601400 416760 0 0 $X=601400 $Y=416380
X1571 1563 1568 390 1552 434 1 2 OA112P $T=594580 436920 1 0 $X=594580 $Y=431500
X1572 402 403 1 2 BUF4 $T=584660 436920 0 0 $X=584660 $Y=436540
X1573 290 1550 1 403 2 NR2T $T=582180 487320 1 0 $X=582180 $Y=481900
X1574 402 2 1 1510 1437 NR2F $T=585900 436920 0 180 $X=579080 $Y=431500
X1575 1422 296 1 2 INV4 $T=531960 467160 1 0 $X=531960 $Y=461740
X1576 1178 1180 2 1183 1173 1 OR3B2 $T=427180 416760 0 0 $X=427180 $Y=416380
X1577 1189 1 2 1123 BUF3CK $T=429660 436920 0 180 $X=425320 $Y=431500
.ENDS
***************************************
.SUBCKT QDFFRBP D CK RB Q GND VCC
** N=7 EP=6 IP=0 FDC=0
.ENDS
***************************************
.SUBCKT INV1CK O I GND VCC
** N=5 EP=4 IP=0 FDC=0
.ENDS
***************************************
.SUBCKT ICV_8 1 2 3 4 5 6 7 8 9 10 11 12 13 14 15 16 17 18 19 20
+ 21 22 23 24 25 26 27 28 29 30 31 32 33 34 35 36 37 38 39 40
+ 41 42 43 44 45 46 47 48 49 50 51 52 53 54 55 56 57 58 59 60
+ 61 62 63 64 65 66 67 68 69 70 71 72 73 74 75 76 77 78 79 80
+ 81 82 83 84 85 86 87 88 89 90 91 92 93 94 95 96 97 98 99 100
+ 101 102 103 104 105 106 107 108 109 110 111 112 113 114 115 116 117 118 119 120
+ 121 122 123 124 125 126 127 128 129 130 131 132 133 134 135 136 137 138 139 140
+ 141 142 143 144 145 146 147 148 149 150 151 152 153 154 155 156 157 158 159 160
+ 161 162 163 164 165 166 167 168 169 170 171 172 173 174 175 176 177 178 179 180
+ 181 182 183 184 185 186 187 188 189 190 191 192 193 194 195 196 197 198 199 200
+ 201 202 203 204 205 206 207 208 209 210 211 212 213 214 215 216 217 218 219 220
+ 221 222 223 224 225 226 227 228 229 230 231 232 233 234 235 236 237 238 239 240
+ 241 242 243 244 245 246 247 248 249 250 251 252 253 254 255 256 257 258 259 260
+ 261 262 263 264 265 266 267 268 269 270 271 272 273 274 275 276 277 278 279 280
+ 281 282 283 284 285 286 287 288 289 290 291 292 293 294 295 296 297 298 299 300
+ 301 302 303 304 305 306 307 308 309 310 311 312 313 314 315 316 317 318 319 320
+ 321 322 323 324 325 326 327 328 329 330 331 332 333 334 335 336 337 338 339 340
+ 341 342 343 344 345 346 347 348 349 350 351 352 353 354 355 356 357 358 359 360
+ 361 362 363 364 365 366 367 368 369 370 371 372 373 374 375 376 377 378 379 380
+ 381 382 383 384 385 386 387 388 389 390 391 392 393 394 395 396 397 398 399 400
+ 401 402 403 404 405 406 407 408 409 410 411 412 413 414 415 416 417 418 419 420
+ 421 422 423 424 425 426 427 428 429 430 431 432 433 434 435 436 437 438 439 440
+ 441 442 443 444 445 446 447 448 449 450 451 452 453 454 455 456 457 458 459 460
+ 461 462 463 464 465 466 467 468 469 470 471 472 473 474 475 476 477 478 479 480
+ 481 482 483 484 485 486 487 488 489 490 491 492 493 494 495 496 497 498 499 500
+ 501 502 503 504 505 506 507 508 509 510 511 512 513 514 515 516 517 518 519 520
+ 521 522 523 524 525 526 527 528 529 530 531 532 533 534 535 536 537 538 539 540
+ 541 542 543 544 545 546 547 548 549 550 551 552 553 554 555 556 557 558 559 560
+ 561 562 563 564 565 566 567 568 569 570 571 572 573 574 575 576 577 578 579 580
+ 581 582 583 584 585 586 587 588 589 590 591 592 593 594 595 596 597 598 599 600
+ 601 602 603 604 605 606 607 608 609 610 611 612 613 614 615 616 617 618 619 620
+ 621 622 623 624 625 626 627 628 629 630 631 632 633 634 635 636 637 638 639 640
+ 641 642 643 644 645 691
** N=2142 EP=646 IP=10168 FDC=0
X0 643 638 638 638 644 642 645 YA2GSD $T=1199700 345460 0 90 $X=1060200 $Y=348310
X1 4 2 1 3 BUF1 $T=222580 386520 0 180 $X=220100 $Y=381100
X2 705 2 1 7 BUF1 $T=230020 346200 1 180 $X=227540 $Y=345820
X3 12 2 1 701 BUF1 $T=230640 396600 1 180 $X=228160 $Y=396220
X4 692 2 1 18 BUF1 $T=233740 396600 0 0 $X=233740 $Y=396220
X5 700 2 1 11 BUF1 $T=236220 336120 0 0 $X=236220 $Y=335740
X6 722 2 1 700 BUF1 $T=245520 366360 1 180 $X=243040 $Y=365980
X7 716 2 1 705 BUF1 $T=248000 346200 1 180 $X=245520 $Y=345820
X8 23 2 1 24 BUF1 $T=247380 366360 0 0 $X=247380 $Y=365980
X9 12 2 1 733 BUF1 $T=248000 396600 0 0 $X=248000 $Y=396220
X10 733 2 1 716 BUF1 $T=248620 376440 0 0 $X=248620 $Y=376060
X11 716 2 1 26 BUF1 $T=249240 346200 1 0 $X=249240 $Y=340780
X12 28 2 1 27 BUF1 $T=253580 406680 0 180 $X=251100 $Y=401260
X13 722 2 1 749 BUF1 $T=253580 366360 0 0 $X=253580 $Y=365980
X14 733 2 1 767 BUF1 $T=269080 376440 1 0 $X=269080 $Y=371020
X15 779 2 1 48 BUF1 $T=274040 336120 1 0 $X=274040 $Y=330700
X16 41 2 1 50 BUF1 $T=274660 326040 1 0 $X=274660 $Y=320620
X17 46 2 1 779 BUF1 $T=275900 366360 1 0 $X=275900 $Y=360940
X18 61 2 1 57 BUF1 $T=288920 406680 1 0 $X=288920 $Y=401260
X19 747 2 1 70 BUF1 $T=297600 336120 0 0 $X=297600 $Y=335740
X20 776 2 1 835 BUF1 $T=301940 356280 0 0 $X=301940 $Y=355900
X21 779 2 1 862 BUF1 $T=301940 366360 1 0 $X=301940 $Y=360940
X22 40 2 1 849 BUF1 $T=308760 376440 1 0 $X=308760 $Y=371020
X23 875 2 1 898 BUF1 $T=331080 366360 1 0 $X=331080 $Y=360940
X24 91 2 1 76 BUF1 $T=334180 356280 0 180 $X=331700 $Y=350860
X25 73 2 1 908 BUF1 $T=341000 336120 0 0 $X=341000 $Y=335740
X26 102 2 1 99 BUF1 $T=345960 336120 0 180 $X=343480 $Y=330700
X27 103 2 1 876 BUF1 $T=351540 326040 1 180 $X=349060 $Y=325660
X28 914 2 1 943 BUF1 $T=358360 376440 1 0 $X=358360 $Y=371020
X29 939 2 1 951 BUF1 $T=361460 346200 1 0 $X=361460 $Y=340780
X30 106 2 1 970 BUF1 $T=370140 406680 1 0 $X=370140 $Y=401260
X31 59 2 1 112 BUF1 $T=380680 346200 1 0 $X=380680 $Y=340780
X32 119 2 1 135 BUF1 $T=381920 396600 1 0 $X=381920 $Y=391180
X33 990 2 1 131 BUF1 $T=387500 396600 1 180 $X=385020 $Y=396220
X34 970 2 1 997 BUF1 $T=388740 386520 1 0 $X=388740 $Y=381100
X35 970 2 1 117 BUF1 $T=392460 376440 0 180 $X=389980 $Y=371020
X36 990 2 1 130 BUF1 $T=394320 366360 0 180 $X=391840 $Y=360940
X37 134 2 1 144 BUF1 $T=393700 346200 0 0 $X=393700 $Y=345820
X38 95 2 1 122 BUF1 $T=395560 326040 1 0 $X=395560 $Y=320620
X39 1014 2 1 140 BUF1 $T=399280 366360 1 180 $X=396800 $Y=365980
X40 110 2 1 148 BUF1 $T=396800 376440 1 0 $X=396800 $Y=371020
X41 1015 2 1 149 BUF1 $T=399280 376440 0 0 $X=399280 $Y=376060
X42 896 2 1 151 BUF1 $T=400520 326040 0 0 $X=400520 $Y=325660
X43 960 2 1 998 BUF1 $T=404240 356280 1 180 $X=401760 $Y=355900
X44 908 2 1 159 BUF1 $T=411680 326040 1 0 $X=411680 $Y=320620
X45 1031 2 1 163 BUF1 $T=417880 376440 0 0 $X=417880 $Y=376060
X46 165 2 1 1011 BUF1 $T=420360 386520 1 180 $X=417880 $Y=386140
X47 1060 2 1 990 BUF1 $T=422840 366360 1 180 $X=420360 $Y=365980
X48 997 2 1 1061 BUF1 $T=420980 376440 1 0 $X=420980 $Y=371020
X49 984 2 1 166 BUF1 $T=421600 406680 0 0 $X=421600 $Y=406300
X50 1070 2 1 182 BUF1 $T=438340 376440 1 0 $X=438340 $Y=371020
X51 1085 2 1 194 BUF1 $T=447640 366360 0 0 $X=447640 $Y=365980
X52 1113 2 1 191 BUF1 $T=451980 376440 1 0 $X=451980 $Y=371020
X53 90 2 1 199 BUF1 $T=458800 326040 1 0 $X=458800 $Y=320620
X54 1150 2 1 1014 BUF1 $T=465000 366360 0 180 $X=462520 $Y=360940
X55 204 2 1 179 BUF1 $T=468720 406680 0 180 $X=466240 $Y=401260
X56 208 2 1 1051 BUF1 $T=474300 406680 0 180 $X=471820 $Y=401260
X57 1168 2 1 1060 BUF1 $T=476160 366360 0 180 $X=473680 $Y=360940
X58 1164 2 1 211 BUF1 $T=474300 376440 1 0 $X=474300 $Y=371020
X59 1142 2 1 218 BUF1 $T=482360 376440 1 0 $X=482360 $Y=371020
X60 159 2 1 221 BUF1 $T=485460 326040 1 0 $X=485460 $Y=320620
X61 1220 2 1 1072 BUF1 $T=496620 386520 1 180 $X=494140 $Y=386140
X62 1239 2 1 1077 BUF1 $T=502200 396600 0 180 $X=499720 $Y=391180
X63 1208 2 1 229 BUF1 $T=502820 366360 1 180 $X=500340 $Y=365980
X64 235 2 1 228 BUF1 $T=503440 326040 1 0 $X=503440 $Y=320620
X65 1246 2 1 231 BUF1 $T=512120 376440 0 180 $X=509640 $Y=371020
X66 1095 2 1 1241 BUF1 $T=513980 396600 0 0 $X=513980 $Y=396220
X67 1128 2 1 244 BUF1 $T=515220 326040 1 0 $X=515220 $Y=320620
X68 1254 2 1 248 BUF1 $T=517700 366360 1 0 $X=517700 $Y=360940
X69 254 2 1 1150 BUF1 $T=527000 366360 1 180 $X=524520 $Y=365980
X70 259 2 1 1239 BUF1 $T=531960 406680 0 180 $X=529480 $Y=401260
X71 274 2 1 233 BUF1 $T=549320 336120 0 0 $X=549320 $Y=335740
X72 1327 2 1 1336 BUF1 $T=549320 376440 0 0 $X=549320 $Y=376060
X73 278 2 1 254 BUF1 $T=556140 336120 0 180 $X=553660 $Y=330700
X74 1340 2 1 280 BUF1 $T=560480 396600 0 180 $X=558000 $Y=391180
X75 288 2 1 214 BUF1 $T=562340 336120 1 180 $X=559860 $Y=335740
X76 296 2 1 282 BUF1 $T=565440 326040 1 180 $X=562960 $Y=325660
X77 279 2 1 1367 BUF1 $T=566680 366360 1 0 $X=566680 $Y=360940
X78 279 2 1 1331 BUF1 $T=567300 386520 0 0 $X=567300 $Y=386140
X79 1367 2 1 1249 BUF1 $T=573500 366360 0 180 $X=571020 $Y=360940
X80 1367 2 1 306 BUF1 $T=580940 326040 0 0 $X=580940 $Y=325660
X81 1367 2 1 1390 BUF1 $T=580940 346200 1 0 $X=580940 $Y=340780
X82 322 2 1 1424 BUF1 $T=602640 406680 0 0 $X=602640 $Y=406300
X83 324 2 1 1432 BUF1 $T=606360 406680 0 0 $X=606360 $Y=406300
X84 349 2 1 339 BUF1 $T=626820 346200 0 180 $X=624340 $Y=340780
X85 356 2 1 351 BUF1 $T=634880 336120 1 180 $X=632400 $Y=335740
X86 354 2 1 1495 BUF1 $T=637360 386520 1 0 $X=637360 $Y=381100
X87 373 2 1 371 BUF1 $T=647900 386520 0 180 $X=645420 $Y=381100
X88 377 2 1 359 BUF1 $T=648520 376440 1 180 $X=646040 $Y=376060
X89 333 2 1 380 BUF1 $T=646660 376440 1 0 $X=646660 $Y=371020
X90 1424 2 1 345 BUF1 $T=649140 396600 0 0 $X=649140 $Y=396220
X91 379 2 1 1466 BUF1 $T=654100 386520 0 180 $X=651620 $Y=381100
X92 375 2 1 384 BUF1 $T=654720 386520 1 0 $X=654720 $Y=381100
X93 347 2 1 387 BUF1 $T=656580 356280 0 0 $X=656580 $Y=355900
X94 386 2 1 1533 BUF1 $T=657820 376440 1 0 $X=657820 $Y=371020
X95 368 2 1 364 BUF1 $T=661540 346200 0 180 $X=659060 $Y=340780
X96 388 2 1 1530 BUF1 $T=660300 386520 0 0 $X=660300 $Y=386140
X97 1432 2 1 341 BUF1 $T=660920 406680 1 0 $X=660920 $Y=401260
X98 366 2 1 392 BUF1 $T=664020 406680 0 0 $X=664020 $Y=406300
X99 1552 2 1 393 BUF1 $T=668980 346200 0 0 $X=668980 $Y=345820
X100 398 2 1 1438 BUF1 $T=673940 346200 0 180 $X=671460 $Y=340780
X101 343 2 1 1569 BUF1 $T=673940 346200 1 0 $X=673940 $Y=340780
X102 380 2 1 1574 BUF1 $T=675800 376440 1 0 $X=675800 $Y=371020
X103 1583 2 1 400 BUF1 $T=684480 356280 1 180 $X=682000 $Y=355900
X104 1587 2 1 404 BUF1 $T=685720 346200 1 180 $X=683240 $Y=345820
X105 388 2 1 1610 BUF1 $T=690680 386520 0 0 $X=690680 $Y=386140
X106 382 2 1 412 BUF1 $T=693780 396600 0 0 $X=693780 $Y=396220
X107 414 2 1 1625 BUF1 $T=699980 396600 1 0 $X=699980 $Y=391180
X108 1583 2 1 1627 BUF1 $T=700600 356280 0 0 $X=700600 $Y=355900
X109 1612 2 1 1623 BUF1 $T=702460 386520 1 0 $X=702460 $Y=381100
X110 423 2 1 428 BUF1 $T=702460 406680 0 0 $X=702460 $Y=406300
X111 427 2 1 408 BUF1 $T=705560 396600 0 180 $X=703080 $Y=391180
X112 432 2 1 1552 BUF1 $T=708040 366360 1 0 $X=708040 $Y=360940
X113 436 2 1 1560 BUF1 $T=711140 326040 1 180 $X=708660 $Y=325660
X114 436 2 1 1551 BUF1 $T=711140 376440 0 180 $X=708660 $Y=371020
X115 434 2 1 1587 BUF1 $T=708660 396600 1 0 $X=708660 $Y=391180
X116 1636 2 1 1641 BUF1 $T=713620 396600 0 0 $X=713620 $Y=396220
X117 415 2 1 1653 BUF1 $T=719200 356280 1 180 $X=716720 $Y=355900
X118 1679 2 1 451 BUF1 $T=729740 396600 0 180 $X=727260 $Y=391180
X119 463 2 1 467 BUF1 $T=743380 406680 0 0 $X=743380 $Y=406300
X120 441 2 1 479 BUF1 $T=764460 336120 0 0 $X=764460 $Y=335740
X121 478 2 1 482 BUF1 $T=765080 366360 0 0 $X=765080 $Y=365980
X122 1730 2 1 488 BUF1 $T=768800 326040 0 0 $X=768800 $Y=325660
X123 412 2 1 1758 BUF1 $T=770040 366360 0 0 $X=770040 $Y=365980
X124 487 2 1 1730 BUF1 $T=772520 386520 1 180 $X=770040 $Y=386140
X125 492 2 1 1762 BUF1 $T=776240 376440 1 0 $X=776240 $Y=371020
X126 1800 2 1 507 BUF1 $T=796700 336120 0 180 $X=794220 $Y=330700
X127 436 2 1 1781 BUF1 $T=794840 366360 1 0 $X=794840 $Y=360940
X128 352 2 1 515 BUF1 $T=794840 366360 0 0 $X=794840 $Y=365980
X129 1794 2 1 512 BUF1 $T=797940 336120 1 180 $X=795460 $Y=335740
X130 1800 2 1 1808 BUF1 $T=797940 346200 0 0 $X=797940 $Y=345820
X131 432 2 1 1794 BUF1 $T=799800 366360 1 0 $X=799800 $Y=360940
X132 1679 2 1 528 BUF1 $T=808480 396600 1 0 $X=808480 $Y=391180
X133 531 2 1 1848 BUF1 $T=815300 386520 1 0 $X=815300 $Y=381100
X134 535 2 1 532 BUF1 $T=820880 376440 1 180 $X=818400 $Y=376060
X135 1896 2 1 1836 BUF1 $T=840100 346200 1 0 $X=840100 $Y=340780
X136 1916 2 1 1888 BUF1 $T=843200 386520 1 0 $X=843200 $Y=381100
X137 1914 2 1 1882 BUF1 $T=845680 346200 0 0 $X=845680 $Y=345820
X138 467 2 1 558 BUF1 $T=850640 326040 1 0 $X=850640 $Y=320620
X139 529 2 1 1954 BUF1 $T=868000 356280 0 0 $X=868000 $Y=355900
X140 530 2 1 572 BUF1 $T=874820 406680 0 0 $X=874820 $Y=406300
X141 1963 2 1 1965 BUF1 $T=877300 386520 0 0 $X=877300 $Y=386140
X142 1916 2 1 1973 BUF1 $T=881020 366360 0 0 $X=881020 $Y=365980
X143 572 2 1 548 BUF1 $T=884120 396600 0 0 $X=884120 $Y=396220
X144 538 2 1 524 BUF1 $T=885980 386520 1 0 $X=885980 $Y=381100
X145 1809 2 1 1997 BUF1 $T=890940 346200 1 0 $X=890940 $Y=340780
X146 534 2 1 2000 BUF1 $T=890940 396600 0 0 $X=890940 $Y=396220
X147 1965 2 1 1990 BUF1 $T=891560 406680 1 0 $X=891560 $Y=401260
X148 1965 2 1 582 BUF1 $T=894040 336120 1 0 $X=894040 $Y=330700
X149 1896 2 1 2004 BUF1 $T=895280 346200 1 0 $X=895280 $Y=340780
X150 1954 2 1 2012 BUF1 $T=896520 366360 1 0 $X=896520 $Y=360940
X151 572 2 1 2005 BUF1 $T=899620 396600 0 0 $X=899620 $Y=396220
X152 1974 2 1 2011 BUF1 $T=900240 346200 1 0 $X=900240 $Y=340780
X153 1762 2 1 585 BUF1 $T=903340 336120 0 180 $X=900860 $Y=330700
X154 477 2 1 588 BUF1 $T=901480 326040 1 0 $X=901480 $Y=320620
X155 2005 2 1 2029 BUF1 $T=913260 396600 1 0 $X=913260 $Y=391180
X156 1997 2 1 2040 BUF1 $T=915740 346200 0 0 $X=915740 $Y=345820
X157 1971 2 1 2049 BUF1 $T=917600 396600 0 0 $X=917600 $Y=396220
X158 1973 2 1 2043 BUF1 $T=921320 366360 0 0 $X=921320 $Y=365980
X159 1975 2 1 2067 BUF1 $T=921320 396600 0 0 $X=921320 $Y=396220
X160 2009 2 1 2068 BUF1 $T=925040 376440 0 0 $X=925040 $Y=376060
X161 2064 2 1 2003 BUF1 $T=930000 366360 0 180 $X=927520 $Y=360940
X162 2065 2 1 1993 BUF1 $T=930000 366360 1 180 $X=927520 $Y=365980
X163 2063 2 1 2052 BUF1 $T=930620 346200 1 180 $X=928140 $Y=345820
X164 2063 2 1 618 BUF1 $T=933720 336120 0 0 $X=933720 $Y=335740
X165 2029 2 1 2082 BUF1 $T=939300 386520 0 0 $X=939300 $Y=386140
X166 610 2 1 2098 BUF1 $T=939920 336120 0 0 $X=939920 $Y=335740
X167 2090 2 1 610 BUF1 $T=942400 346200 0 180 $X=939920 $Y=340780
X168 1954 2 1 2047 BUF1 $T=946120 356280 0 0 $X=946120 $Y=355900
X169 586 2 1 2107 BUF1 $T=948600 386520 1 0 $X=948600 $Y=381100
X170 2068 2 1 2117 BUF1 $T=953560 376440 1 0 $X=953560 $Y=371020
X171 2014 2 1 2132 BUF1 $T=964100 386520 1 0 $X=964100 $Y=381100
X172 638 2 1 642 BUF1 $T=974640 366360 0 0 $X=974640 $Y=365980
X173 707 6 7 2 1 693 QDFFRBN $T=232500 346200 0 180 $X=220720 $Y=340780
X174 695 6 7 2 1 712 QDFFRBN $T=221340 326040 1 0 $X=221340 $Y=320620
X175 697 6 705 2 1 713 QDFFRBN $T=221340 366360 1 0 $X=221340 $Y=360940
X176 702 6 701 2 1 694 QDFFRBN $T=233120 396600 0 180 $X=221340 $Y=391180
X177 5 6 12 2 1 14 QDFFRBN $T=221340 406680 1 0 $X=221340 $Y=401260
X178 699 6 701 2 1 714 QDFFRBN $T=221960 376440 0 0 $X=221960 $Y=376060
X179 708 6 7 2 1 723 QDFFRBN $T=229400 326040 0 0 $X=229400 $Y=325660
X180 724 6 716 2 1 706 QDFFRBN $T=242420 366360 1 180 $X=230640 $Y=365980
X181 710 6 705 2 1 728 QDFFRBN $T=231880 346200 0 0 $X=231880 $Y=345820
X182 729 6 701 2 1 715 QDFFRBN $T=246760 386520 1 180 $X=234980 $Y=386140
X183 734 6 705 2 1 719 QDFFRBN $T=250480 356280 0 180 $X=238700 $Y=350860
X184 725 6 733 2 1 739 QDFFRBN $T=240560 386520 1 0 $X=240560 $Y=381100
X185 727 6 26 2 1 30 QDFFRBN $T=243040 326040 0 0 $X=243040 $Y=325660
X186 726 6 26 2 1 744 QDFFRBN $T=243040 336120 1 0 $X=243040 $Y=330700
X187 753 6 716 2 1 731 QDFFRBN $T=258540 356280 1 180 $X=246760 $Y=355900
X188 736 6 716 2 1 758 QDFFRBN $T=250480 346200 0 0 $X=250480 $Y=345820
X189 761 6 716 2 1 738 QDFFRBN $T=265360 376440 0 180 $X=253580 $Y=371020
X190 742 6 733 2 1 763 QDFFRBN $T=253580 386520 1 0 $X=253580 $Y=381100
X191 748 6 26 2 1 39 QDFFRBN $T=257300 336120 1 0 $X=257300 $Y=330700
X192 755 6 767 2 1 773 QDFFRBN $T=260400 356280 1 0 $X=260400 $Y=350860
X193 774 6 26 2 1 754 QDFFRBN $T=273420 346200 0 180 $X=261640 $Y=340780
X194 782 6 733 2 1 762 QDFFRBN $T=277760 376440 1 180 $X=265980 $Y=376060
X195 790 6 733 2 1 769 QDFFRBN $T=281480 386520 1 180 $X=269700 $Y=386140
X196 775 6 767 2 1 53 QDFFRBN $T=272800 376440 1 0 $X=272800 $Y=371020
X197 787 6 767 2 1 811 QDFFRBN $T=279620 376440 0 0 $X=279620 $Y=376060
X198 867 82 767 2 1 93 QDFFRBN $T=320540 366360 0 0 $X=320540 $Y=365980
X199 100 82 104 2 1 102 QDFFRBN $T=342860 326040 1 0 $X=342860 $Y=320620
X200 910 82 106 2 1 107 QDFFRBN $T=344100 396600 0 0 $X=344100 $Y=396220
X201 942 82 104 2 1 120 QDFFRBN $T=361460 326040 1 0 $X=361460 $Y=320620
X202 958 82 106 2 1 124 QDFFRBN $T=367040 406680 0 0 $X=367040 $Y=406300
X203 125 82 117 2 1 110 QDFFRBN $T=380060 326040 1 180 $X=368280 $Y=325660
X204 973 82 970 2 1 133 QDFFRBN $T=373860 406680 1 0 $X=373860 $Y=401260
X205 976 82 117 2 1 984 QDFFRBN $T=376340 336120 1 0 $X=376340 $Y=330700
X206 978 82 970 2 1 137 QDFFRBN $T=376340 386520 0 0 $X=376340 $Y=386140
X207 992 82 970 2 1 123 QDFFRBN $T=389980 376440 0 180 $X=378200 $Y=371020
X208 128 82 970 2 1 139 QDFFRBN $T=380680 406680 0 0 $X=380680 $Y=406300
X209 987 82 117 2 1 1015 QDFFRBN $T=383160 366360 0 0 $X=383160 $Y=365980
X210 1022 82 997 2 1 141 QDFFRBN $T=401140 396600 1 0 $X=401140 $Y=391180
X211 1046 82 997 2 1 1031 QDFFRBN $T=417880 376440 0 180 $X=406100 $Y=371020
X212 1021 82 997 2 1 165 QDFFRBN $T=411680 386520 1 0 $X=411680 $Y=381100
X213 993 82 997 2 1 164 QDFFRBN $T=414160 396600 1 0 $X=414160 $Y=391180
X214 1062 82 1061 2 1 1070 QDFFRBN $T=424700 376440 1 0 $X=424700 $Y=371020
X215 1102 184 1061 2 1 1085 QDFFRBN $T=446400 366360 1 180 $X=434620 $Y=365980
X216 1120 184 1061 2 1 1113 QDFFRBN $T=450740 366360 1 0 $X=450740 $Y=360940
X217 1159 184 1061 2 1 1142 QDFFRBN $T=471820 376440 0 180 $X=460040 $Y=371020
X218 1187 184 1061 2 1 1164 QDFFRBN $T=484840 366360 1 180 $X=473060 $Y=365980
X219 1203 184 1061 2 1 1208 QDFFRBN $T=487320 366360 0 0 $X=487320 $Y=365980
X220 1236 184 1249 2 1 1246 QDFFRBN $T=502200 366360 1 0 $X=502200 $Y=360940
X221 1274 184 1249 2 1 1254 QDFFRBN $T=524520 366360 1 180 $X=512740 $Y=365980
X222 1306 184 1249 2 1 1289 QDFFRBN $T=547460 356280 0 180 $X=535680 $Y=350860
X223 1330 184 1249 2 1 1338 QDFFRBN $T=546840 356280 0 0 $X=546840 $Y=355900
X224 1355 184 279 2 1 1340 QDFFRBN $T=564200 386520 1 180 $X=552420 $Y=386140
X225 1354 184 1249 2 1 1357 QDFFRBN $T=562960 356280 0 0 $X=562960 $Y=355900
X226 1353 184 1367 2 1 1371 QDFFRBN $T=564200 336120 0 0 $X=564200 $Y=335740
X227 298 184 1367 2 1 1372 QDFFRBN $T=567920 326040 0 0 $X=567920 $Y=325660
X228 1363 184 1367 2 1 1360 QDFFRBN $T=568540 346200 1 0 $X=568540 $Y=340780
X229 1381 184 279 2 1 1364 QDFFRBN $T=580940 366360 1 180 $X=569160 $Y=365980
X230 1373 184 1390 2 1 1387 QDFFRBN $T=576600 346200 0 0 $X=576600 $Y=345820
X231 1408 184 1390 2 1 1419 QDFFRBN $T=590240 346200 1 0 $X=590240 $Y=340780
X232 1405 184 1331 2 1 319 QDFFRBN $T=590240 396600 0 0 $X=590240 $Y=396220
X233 1423 184 1390 2 1 1416 QDFFRBN $T=607600 366360 0 180 $X=595820 $Y=360940
X234 1412 184 1390 2 1 1392 QDFFRBN $T=609460 356280 1 180 $X=597680 $Y=355900
X235 1437 184 1390 2 1 1422 QDFFRBN $T=613800 346200 1 180 $X=602020 $Y=345820
X236 1707 459 466 2 1 1728 QDFFRBN $T=737800 326040 0 0 $X=737800 $Y=325660
X237 464 459 1730 2 1 1740 QDFFRBN $T=744000 326040 1 0 $X=744000 $Y=320620
X238 1733 459 1730 2 1 1746 QDFFRBN $T=752680 366360 1 0 $X=752680 $Y=360940
X239 1750 459 1730 2 1 1743 QDFFRBN $T=770040 346200 0 180 $X=758260 $Y=340780
X240 1720 459 1730 2 1 1754 QDFFRBN $T=761360 376440 1 0 $X=761360 $Y=371020
X241 1759 459 1730 2 1 1747 QDFFRBN $T=776860 396600 0 180 $X=765080 $Y=391180
X242 1749 459 487 2 1 495 QDFFRBN $T=766940 406680 1 0 $X=766940 $Y=401260
X243 1814 459 488 2 1 1847 QDFFRBN $T=804760 326040 1 0 $X=804760 $Y=320620
X244 1952 459 569 2 1 1966 QDFFRBN $T=868620 366360 0 0 $X=868620 $Y=365980
X245 1953 459 569 2 1 1972 QDFFRBN $T=871100 346200 0 0 $X=871100 $Y=345820
X246 1964 459 569 2 1 1955 QDFFRBN $T=883500 336120 1 180 $X=871720 $Y=335740
X247 1981 459 569 2 1 1950 QDFFRBN $T=885360 326040 0 180 $X=873580 $Y=320620
X248 1995 459 569 2 1 1960 QDFFRBN $T=894040 326040 1 180 $X=882260 $Y=325660
X249 735 2 692 1 INV1S $T=247380 396600 0 180 $X=246140 $Y=391180
X250 722 2 735 1 INV1S $T=248620 376440 1 0 $X=248620 $Y=371020
X251 23 2 722 1 INV1S $T=249860 366360 0 0 $X=249860 $Y=365980
X252 735 2 741 1 INV1S $T=251720 376440 1 0 $X=251720 $Y=371020
X253 30 2 25 1 INV1S $T=261020 326040 1 0 $X=261020 $Y=320620
X254 735 2 770 1 INV1S $T=261020 356280 0 0 $X=261020 $Y=355900
X255 43 2 41 1 INV1S $T=271560 326040 0 180 $X=270320 $Y=320620
X256 39 2 747 1 INV1S $T=270320 336120 1 0 $X=270320 $Y=330700
X257 777 2 785 1 INV1S $T=276520 336120 1 0 $X=276520 $Y=330700
X258 53 2 776 1 INV1S $T=279620 366360 0 180 $X=278380 $Y=360940
X259 797 2 781 1 INV1S $T=283340 346200 1 180 $X=282100 $Y=345820
X260 792 2 817 1 INV1S $T=293880 376440 0 0 $X=293880 $Y=376060
X261 833 2 823 1 INV1S $T=301320 336120 1 180 $X=300080 $Y=335740
X262 93 2 875 1 INV1S $T=331080 356280 1 180 $X=329840 $Y=355900
X263 90 2 819 1 INV1S $T=332320 336120 1 180 $X=331080 $Y=335740
X264 905 2 892 1 INV1S $T=336040 376440 1 180 $X=334800 $Y=376060
X265 95 2 79 1 INV1S $T=337900 336120 1 180 $X=336660 $Y=335740
X266 99 2 98 1 INV1S $T=342240 336120 0 180 $X=341000 $Y=330700
X267 59 2 919 1 INV1S $T=345960 376440 1 0 $X=345960 $Y=371020
X268 927 2 917 1 INV1S $T=349060 386520 0 180 $X=347820 $Y=381100
X269 932 2 931 1 INV1S $T=353400 366360 0 180 $X=352160 $Y=360940
X270 933 2 930 1 INV1S $T=353400 386520 0 180 $X=352160 $Y=381100
X271 107 2 914 1 INV1S $T=354640 386520 1 180 $X=353400 $Y=386140
X272 935 2 929 1 INV1S $T=355880 376440 1 0 $X=355880 $Y=371020
X273 939 2 934 1 INV1S $T=358980 346200 0 180 $X=357740 $Y=340780
X274 953 2 912 1 INV1S $T=360220 346200 0 180 $X=358980 $Y=340780
X275 862 2 115 1 INV1S $T=358980 356280 1 0 $X=358980 $Y=350860
X276 946 2 924 1 INV1S $T=360220 356280 1 180 $X=358980 $Y=355900
X277 59 2 963 1 INV1S $T=372000 376440 0 180 $X=370760 $Y=371020
X278 62 2 109 1 INV1S $T=373240 326040 1 0 $X=373240 $Y=320620
X279 123 2 989 1 INV1S $T=379440 376440 0 0 $X=379440 $Y=376060
X280 984 2 982 1 INV1S $T=388740 336120 0 0 $X=388740 $Y=335740
X281 137 2 962 1 INV1S $T=391840 386520 1 180 $X=390600 $Y=386140
X282 95 2 996 1 INV1S $T=393700 376440 0 180 $X=392460 $Y=371020
X283 129 2 1003 1 INV1S $T=393080 386520 1 0 $X=393080 $Y=381100
X284 129 2 1008 1 INV1S $T=394940 406680 0 0 $X=394940 $Y=406300
X285 1009 2 1010 1 INV1S $T=396800 356280 0 0 $X=396800 $Y=355900
X286 129 2 146 1 INV1S $T=398660 346200 0 0 $X=398660 $Y=345820
X287 141 2 1018 1 INV1S $T=404240 406680 0 180 $X=403000 $Y=401260
X288 1009 2 1025 1 INV1S $T=405480 346200 1 180 $X=404240 $Y=345820
X289 151 2 1007 1 INV1S $T=406720 326040 0 0 $X=406720 $Y=325660
X290 133 2 974 1 INV1S $T=408580 406680 1 0 $X=408580 $Y=401260
X291 908 2 118 1 INV1S $T=410440 326040 0 180 $X=409200 $Y=320620
X292 1009 2 1035 1 INV1S $T=409200 346200 1 0 $X=409200 $Y=340780
X293 1036 2 961 1 INV1S $T=410440 386520 0 180 $X=409200 $Y=381100
X294 1056 2 1048 1 INV1S $T=420360 336120 0 180 $X=419120 $Y=330700
X295 164 2 999 1 INV1S $T=423460 396600 1 180 $X=422220 $Y=396220
X296 168 2 172 1 INV1S $T=426560 406680 0 0 $X=426560 $Y=406300
X297 1060 2 171 1 INV1S $T=427800 346200 1 0 $X=427800 $Y=340780
X298 1126 2 1054 1 INV1S $T=451980 406680 1 180 $X=450740 $Y=406300
X299 171 2 1036 1 INV1S $T=453220 346200 0 0 $X=453220 $Y=345820
X300 1126 2 193 1 INV1S $T=456320 406680 1 180 $X=455080 $Y=406300
X301 198 2 1126 1 INV1S $T=459420 406680 1 180 $X=458180 $Y=406300
X302 233 2 1144 1 INV1S $T=500340 406680 1 180 $X=499100 $Y=406300
X303 1239 2 1220 1 INV1S $T=503440 386520 0 0 $X=503440 $Y=386140
X304 1242 2 1253 1 INV1S $T=507160 336120 0 0 $X=507160 $Y=335740
X305 235 2 237 1 INV1S $T=507780 326040 1 0 $X=507780 $Y=320620
X306 1241 2 208 1 INV1S $T=510260 406680 1 0 $X=510260 $Y=401260
X307 1256 2 1258 1 INV1S $T=515840 336120 0 0 $X=515840 $Y=335740
X308 1286 2 1297 1 INV1S $T=531960 376440 1 0 $X=531960 $Y=371020
X309 1289 2 257 1 INV1S $T=538160 356280 1 180 $X=536920 $Y=355900
X310 1326 2 1168 1 INV1S $T=543740 366360 0 180 $X=542500 $Y=360940
X311 1329 2 245 1 INV1S $T=544980 346200 1 180 $X=543740 $Y=345820
X312 1326 2 270 1 INV1S $T=549320 366360 0 180 $X=548080 $Y=360940
X313 280 2 1346 1 INV1S $T=556760 396600 1 0 $X=556760 $Y=391180
X314 273 2 1326 1 INV1S $T=559240 356280 0 180 $X=558000 $Y=350860
X315 1036 2 281 1 INV1S $T=558000 376440 0 0 $X=558000 $Y=376060
X316 1036 2 291 1 INV1S $T=560480 326040 0 0 $X=560480 $Y=325660
X317 1338 2 294 1 INV1S $T=561100 376440 1 0 $X=561100 $Y=371020
X318 1340 2 289 1 INV1S $T=561100 396600 1 0 $X=561100 $Y=391180
X319 1357 2 247 1 INV1S $T=566060 366360 0 180 $X=564820 $Y=360940
X320 1360 2 1252 1 INV1S $T=568540 346200 0 0 $X=568540 $Y=345820
X321 1371 2 251 1 INV1S $T=573500 346200 1 180 $X=572260 $Y=345820
X322 1372 2 238 1 INV1S $T=574740 366360 0 180 $X=573500 $Y=360940
X323 299 2 224 1 INV1S $T=579700 336120 1 180 $X=578460 $Y=335740
X324 1389 2 1380 1 INV1S $T=580940 386520 1 180 $X=579700 $Y=386140
X325 1387 2 1383 1 INV1S $T=583420 366360 0 180 $X=582180 $Y=360940
X326 1397 2 1379 1 INV1S $T=589000 356280 0 180 $X=587760 $Y=350860
X327 1312 2 1411 1 INV1S $T=589620 376440 1 0 $X=589620 $Y=371020
X328 1410 2 1407 1 INV1S $T=593960 326040 1 180 $X=592720 $Y=325660
X329 1392 2 1406 1 INV1S $T=593960 366360 0 180 $X=592720 $Y=360940
X330 1321 2 1414 1 INV1S $T=592720 376440 0 0 $X=592720 $Y=376060
X331 1402 2 1382 1 INV1S $T=593340 356280 1 0 $X=593340 $Y=350860
X332 1419 2 1403 1 INV1S $T=597680 356280 0 180 $X=596440 $Y=350860
X333 326 2 316 1 INV1S $T=598300 326040 0 180 $X=597060 $Y=320620
X334 1375 2 1418 1 INV1S $T=597680 386520 1 0 $X=597680 $Y=381100
X335 1420 2 1399 1 INV1S $T=602020 376440 0 0 $X=602020 $Y=376060
X336 1436 2 1429 1 INV1S $T=610080 386520 0 180 $X=608840 $Y=381100
X337 1430 2 1434 1 INV1S $T=611940 396600 1 180 $X=610700 $Y=396220
X338 334 2 1456 1 INV1S $T=613800 396600 0 0 $X=613800 $Y=396220
X339 1425 2 1433 1 INV1S $T=614420 336120 0 0 $X=614420 $Y=335740
X340 1439 2 1441 1 INV1S $T=614420 356280 0 0 $X=614420 $Y=355900
X341 1447 2 1449 1 INV1S $T=616900 386520 1 0 $X=616900 $Y=381100
X342 333 2 1463 1 INV1S $T=622480 376440 0 0 $X=622480 $Y=376060
X343 1462 2 1471 1 INV1S $T=628680 336120 0 0 $X=628680 $Y=335740
X344 1466 2 361 1 INV1S $T=645420 386520 0 180 $X=644180 $Y=381100
X345 329 2 358 1 INV1S $T=652240 376440 0 0 $X=652240 $Y=376060
X346 346 2 347 1 INV1S $T=654720 376440 0 0 $X=654720 $Y=376060
X347 377 2 381 1 INV1S $T=655960 376440 0 0 $X=655960 $Y=376060
X348 1495 2 365 1 INV1S $T=658440 366360 0 180 $X=657200 $Y=360940
X349 1540 2 1528 1 INV1S $T=665880 346200 1 180 $X=664640 $Y=345820
X350 1540 2 1535 1 INV1S $T=665880 386520 0 180 $X=664640 $Y=381100
X351 341 2 398 1 INV1S $T=672080 336120 1 0 $X=672080 $Y=330700
X352 1540 2 1566 1 INV1S $T=672700 406680 0 0 $X=672700 $Y=406300
X353 1550 2 1597 1 INV1S $T=677040 376440 0 0 $X=677040 $Y=376060
X354 1568 2 1585 1 INV1S $T=681380 386520 1 0 $X=681380 $Y=381100
X355 1612 2 1617 1 INV1S $T=693780 386520 0 0 $X=693780 $Y=386140
X356 1617 2 410 1 INV1S $T=695640 406680 0 0 $X=695640 $Y=406300
X357 412 2 1583 1 INV1S $T=697500 356280 0 0 $X=697500 $Y=355900
X358 1610 2 1605 1 INV1S $T=697500 376440 0 0 $X=697500 $Y=376060
X359 397 2 1612 1 INV1S $T=697500 386520 0 0 $X=697500 $Y=386140
X360 415 2 414 1 INV1S $T=698740 396600 0 180 $X=697500 $Y=391180
X361 425 2 1636 1 INV1S $T=703080 396600 0 0 $X=703080 $Y=396220
X362 1540 2 444 1 INV1S $T=714240 376440 1 0 $X=714240 $Y=371020
X363 444 2 1595 1 INV1S $T=715480 376440 1 180 $X=714240 $Y=376060
X364 1658 2 1656 1 INV1S $T=719200 326040 1 180 $X=717960 $Y=325660
X365 1636 2 1690 1 INV1S $T=722300 336120 0 0 $X=722300 $Y=335740
X366 1692 2 1703 1 INV1S $T=733460 326040 0 0 $X=733460 $Y=325660
X367 1689 2 1711 1 INV1S $T=738420 386520 1 0 $X=738420 $Y=381100
X368 1706 2 1715 1 INV1S $T=739660 376440 1 0 $X=739660 $Y=371020
X369 1717 2 465 1 INV1S $T=744620 406680 1 0 $X=744620 $Y=401260
X370 428 2 1679 1 INV1S $T=747100 406680 1 0 $X=747100 $Y=401260
X371 1723 2 1727 1 INV1S $T=747720 406680 0 0 $X=747720 $Y=406300
X372 379 2 1767 1 INV1S $T=779340 376440 1 0 $X=779340 $Y=371020
X373 1769 2 1783 1 INV1S $T=783060 376440 1 0 $X=783060 $Y=371020
X374 498 2 508 1 INV1S $T=791740 366360 1 0 $X=791740 $Y=360940
X375 1793 2 1795 1 INV1S $T=791740 386520 1 0 $X=791740 $Y=381100
X376 1758 2 1800 1 INV1S $T=796700 346200 0 180 $X=795460 $Y=340780
X377 436 2 1802 1 INV1S $T=796700 346200 0 0 $X=796700 $Y=345820
X378 494 2 520 1 INV1S $T=797940 366360 0 0 $X=797940 $Y=365980
X379 1796 2 1812 1 INV1S $T=802900 406680 1 0 $X=802900 $Y=401260
X380 1810 2 1796 1 INV1S $T=804760 386520 0 180 $X=803520 $Y=381100
X381 1816 2 1813 1 INV1S $T=805380 376440 0 180 $X=804140 $Y=371020
X382 1810 2 1821 1 INV1S $T=806000 386520 1 0 $X=806000 $Y=381100
X383 1820 2 1819 1 INV1S $T=807860 356280 0 180 $X=806620 $Y=350860
X384 527 2 1828 1 INV1S $T=810960 386520 0 180 $X=809720 $Y=381100
X385 527 2 1815 1 INV1S $T=814060 356280 0 180 $X=812820 $Y=350860
X386 530 2 1830 1 INV1S $T=815300 386520 0 180 $X=814060 $Y=381100
X387 1840 2 1852 1 INV1S $T=819640 396600 0 0 $X=819640 $Y=396220
X388 536 2 1858 1 INV1S $T=822120 406680 0 0 $X=822120 $Y=406300
X389 1873 2 1874 1 INV1S $T=827700 386520 1 0 $X=827700 $Y=381100
X390 527 2 1881 1 INV1S $T=829560 386520 0 0 $X=829560 $Y=386140
X391 531 2 1860 1 INV1S $T=833900 346200 0 0 $X=833900 $Y=345820
X392 1872 2 1897 1 INV1S $T=838860 326040 0 0 $X=838860 $Y=325660
X393 1855 2 1928 1 INV1S $T=848160 336120 1 0 $X=848160 $Y=330700
X394 1936 2 1934 1 INV1S $T=858080 406680 1 0 $X=858080 $Y=401260
X395 1809 2 1896 1 INV1S $T=860560 346200 1 0 $X=860560 $Y=340780
X396 529 2 1916 1 INV1S $T=869240 386520 0 0 $X=869240 $Y=386140
X397 530 2 1961 1 INV1S $T=874820 386520 0 0 $X=874820 $Y=386140
X398 527 2 1974 1 INV1S $T=881020 356280 1 0 $X=881020 $Y=350860
X399 538 2 550 1 INV1S $T=881020 406680 1 0 $X=881020 $Y=401260
X400 1456 2 1970 1 INV1S $T=888460 346200 0 180 $X=887220 $Y=340780
X401 1456 2 1983 1 INV1S $T=887220 356280 1 0 $X=887220 $Y=350860
X402 377 2 1963 1 INV1S $T=889080 386520 1 0 $X=889080 $Y=381100
X403 2001 2 1989 1 INV1S $T=892180 386520 0 180 $X=890940 $Y=381100
X404 534 2 2009 1 INV1S $T=893420 406680 0 0 $X=893420 $Y=406300
X405 2002 2 578 1 INV1S $T=895280 386520 0 0 $X=895280 $Y=386140
X406 1974 2 1914 1 INV1S $T=898380 346200 0 0 $X=898380 $Y=345820
X407 1963 2 2016 1 INV1S $T=899620 386520 0 0 $X=899620 $Y=386140
X408 2016 2 2002 1 INV1S $T=900860 386520 0 0 $X=900860 $Y=386140
X409 585 2 584 1 INV1S $T=901480 326040 0 0 $X=901480 $Y=325660
X410 583 2 539 1 INV1S $T=902720 406680 1 180 $X=901480 $Y=406300
X411 2002 2 2024 1 INV1S $T=903340 386520 0 0 $X=903340 $Y=386140
X412 2025 2 587 1 INV1S $T=906440 406680 1 180 $X=905200 $Y=406300
X413 590 2 597 1 INV1S $T=907680 326040 0 0 $X=907680 $Y=325660
X414 579 2 2026 1 INV1S $T=910160 356280 1 0 $X=910160 $Y=350860
X415 366 2 2036 1 INV1S $T=910160 376440 0 0 $X=910160 $Y=376060
X416 1767 2 594 1 INV1S $T=912020 336120 0 180 $X=910780 $Y=330700
X417 602 2 589 1 INV1S $T=912020 356280 1 180 $X=910780 $Y=355900
X418 366 2 599 1 INV1S $T=912640 326040 0 0 $X=912640 $Y=325660
X419 594 2 607 1 INV1S $T=916980 326040 0 0 $X=916980 $Y=325660
X420 1767 2 2037 1 INV1S $T=920080 346200 1 180 $X=918840 $Y=345820
X421 610 2 2071 1 INV1S $T=931240 326040 0 180 $X=930000 $Y=320620
X422 602 2 2075 1 INV1S $T=930620 376440 0 0 $X=930620 $Y=376060
X423 602 2 2072 1 INV1S $T=930620 396600 0 0 $X=930620 $Y=396220
X424 515 2 2063 1 INV1S $T=935580 346200 0 180 $X=934340 $Y=340780
X425 2079 2 2100 1 INV1S $T=934960 326040 0 0 $X=934960 $Y=325660
X426 1767 2 2074 1 INV1S $T=936820 366360 1 180 $X=935580 $Y=365980
X427 620 2 2090 1 INV1S $T=939920 356280 1 0 $X=939920 $Y=350860
X428 1998 2 2064 1 INV1S $T=939920 356280 0 0 $X=939920 $Y=355900
X429 1767 2 2089 1 INV1S $T=939920 366360 0 0 $X=939920 $Y=365980
X430 2090 2 615 1 INV1S $T=940540 346200 0 0 $X=940540 $Y=345820
X431 2080 2 2106 1 INV1S $T=944880 366360 1 0 $X=944880 $Y=360940
X432 2113 2 2108 1 INV1S $T=956040 396600 0 180 $X=954800 $Y=391180
X433 2104 2 628 1 INV1S $T=958520 406680 1 0 $X=958520 $Y=401260
X434 2097 2 2121 1 INV1S $T=962240 396600 0 180 $X=961000 $Y=391180
X435 2128 2 629 1 INV1S $T=963480 406680 1 180 $X=962240 $Y=406300
X436 2135 2 635 1 INV1S $T=967820 406680 1 0 $X=967820 $Y=401260
X437 2118 2 2139 1 INV1S $T=970300 346200 0 0 $X=970300 $Y=345820
X438 2136 2 2123 1 INV1S $T=973400 356280 1 0 $X=973400 $Y=350860
X439 2140 2 637 1 INV1S $T=973400 396600 0 0 $X=973400 $Y=396220
X440 2141 2 636 1 INV1S $T=977120 406680 0 180 $X=975880 $Y=401260
X441 771 751 2 750 765 1 743 FA1 $T=269700 396600 0 180 $X=254200 $Y=391180
X442 777 759 2 756 772 1 746 FA1 $T=272800 326040 1 180 $X=257300 $Y=325660
X443 35 38 2 766 743 1 42 FA1 $T=257300 406680 1 0 $X=257300 $Y=401260
X444 797 818 2 815 64 1 821 FA1 $T=285200 346200 1 0 $X=285200 $Y=340780
X445 833 826 2 827 845 1 772 FA1 $T=310620 336120 0 180 $X=295120 $Y=330700
X446 839 74 2 841 859 1 765 FA1 $T=318060 406680 0 180 $X=302560 $Y=401260
X447 877 907 2 901 912 1 921 FA1 $T=332940 346200 0 0 $X=332940 $Y=345820
X448 953 945 2 975 972 1 979 FA1 $T=364560 346200 1 0 $X=364560 $Y=340780
X449 1073 1091 2 1090 1066 1 1103 FA1 $T=429040 346200 1 0 $X=429040 $Y=340780
X450 1135 1154 2 1156 1117 1 1170 FA1 $T=458800 346200 1 0 $X=458800 $Y=340780
X451 1171 1146 2 1197 1170 1 1213 FA1 $T=474920 346200 1 0 $X=474920 $Y=340780
X452 1195 1179 2 1223 1213 1 1231 FA1 $T=484840 346200 0 0 $X=484840 $Y=345820
X453 1238 1221 2 1258 1231 1 1267 FA1 $T=503440 346200 1 0 $X=503440 $Y=340780
X454 1332 1338 2 1347 1303 1 1345 FA1 $T=548700 346200 0 0 $X=548700 $Y=345820
X455 1490 1508 2 1502 363 1 1509 FA1 $T=635500 336120 0 0 $X=635500 $Y=335740
X456 1522 1494 2 1499 1509 1 1496 FA1 $T=655960 366360 1 180 $X=640460 $Y=365980
X457 369 378 2 1484 1506 1 385 FA1 $T=641700 406680 0 0 $X=641700 $Y=406300
X458 1525 1501 2 1478 1496 1 1506 FA1 $T=659680 386520 1 180 $X=644180 $Y=386140
X459 402 1600 2 1597 1584 1 1613 FA1 $T=678900 376440 1 0 $X=678900 $Y=371020
X460 407 1580 2 1586 1590 1 1614 FA1 $T=682000 396600 1 0 $X=682000 $Y=391180
X461 413 1585 2 1592 1614 1 1584 FA1 $T=698120 386520 0 180 $X=682620 $Y=381100
X462 418 1599 2 1602 1613 1 1589 FA1 $T=699360 366360 0 180 $X=683860 $Y=360940
X463 421 1608 2 1601 1589 1 1594 FA1 $T=701840 346200 1 180 $X=686340 $Y=345820
X464 1606 419 2 1611 1594 1 430 FA1 $T=690680 326040 1 0 $X=690680 $Y=320620
X465 450 1699 2 1703 456 1 1718 FA1 $T=724780 326040 1 0 $X=724780 $Y=320620
X466 461 1732 2 1680 1718 1 1737 FA1 $T=742760 346200 1 0 $X=742760 $Y=340780
X467 1742 1722 2 1724 1737 1 1716 FA1 $T=758260 346200 1 180 $X=742760 $Y=345820
X468 1713 1735 2 1739 1716 1 1744 FA1 $T=744000 376440 1 0 $X=744000 $Y=371020
X469 1707 1742 2 1490 470 1 1750 FA1 $T=748340 336120 0 0 $X=748340 $Y=335740
X470 1748 1738 2 1734 1744 1 471 FA1 $T=765700 406680 0 180 $X=750200 $Y=401260
X471 480 1740 2 1728 473 1 1726 FA1 $T=767560 326040 1 180 $X=752060 $Y=325660
X472 489 1743 2 1746 1726 1 1741 FA1 $T=773140 356280 0 180 $X=757640 $Y=350860
X473 474 1754 2 1747 1741 1 490 FA1 $T=760740 376440 0 0 $X=760740 $Y=376060
X474 491 501 2 1786 1761 1 505 FA1 $T=776860 336120 1 0 $X=776860 $Y=330700
X475 506 1773 2 1768 1791 1 1761 FA1 $T=792980 356280 1 180 $X=777480 $Y=355900
X476 496 1790 2 1783 1771 1 1791 FA1 $T=779340 366360 0 0 $X=779340 $Y=365980
X477 521 1795 2 1792 1789 1 1771 FA1 $T=802900 376440 0 180 $X=787400 $Y=371020
X478 523 1774 2 1798 1799 1 1789 FA1 $T=804140 396600 1 180 $X=788640 $Y=396220
X479 516 1822 2 1817 1841 1 1843 FA1 $T=799180 326040 0 0 $X=799180 $Y=325660
X480 546 1897 2 1908 1854 1 1917 FA1 $T=833280 326040 1 0 $X=833280 $Y=320620
X481 554 1929 2 1928 1917 1 1945 FA1 $T=847540 326040 0 0 $X=847540 $Y=325660
X482 1951 1930 2 1933 1946 1 1923 FA1 $T=867380 366360 1 180 $X=851880 $Y=365980
X483 566 1937 2 1919 1945 1 1924 FA1 $T=868620 336120 1 180 $X=853120 $Y=335740
X484 556 1943 2 1941 1924 1 1946 FA1 $T=853120 346200 0 0 $X=853120 $Y=345820
X485 559 564 2 1950 562 1 1956 FA1 $T=855600 326040 1 0 $X=855600 $Y=320620
X486 1962 1948 2 1949 1959 1 560 FA1 $T=876680 396600 1 180 $X=861180 $Y=396220
X487 565 1960 2 1955 1956 1 1967 FA1 $T=865520 326040 0 0 $X=865520 $Y=325660
X488 1947 1957 2 1931 1923 1 1959 FA1 $T=865520 376440 0 0 $X=865520 $Y=376060
X489 567 1972 2 1966 1967 1 576 FA1 $T=872960 356280 0 0 $X=872960 $Y=355900
X490 574 1987 2 1989 1969 1 580 FA1 $T=879780 386520 0 0 $X=879780 $Y=386140
X491 1984 1977 2 1976 1999 1 1969 FA1 $T=896520 376440 1 180 $X=881020 $Y=376060
X492 626 2111 2 2123 2138 1 2129 FA1 $T=949840 356280 1 0 $X=949840 $Y=350860
X493 623 2125 2 2130 2124 1 2138 FA1 $T=953560 336120 0 0 $X=953560 $Y=335740
X494 1992 2137 2 633 640 1 2124 FA1 $T=978980 336120 0 180 $X=963480 $Y=330700
X495 631 2095 2 2139 2129 1 641 FA1 $T=963480 366360 1 0 $X=963480 $Y=360940
X496 784 2 780 793 794 1 795 FA1S $T=272180 356280 0 0 $X=272180 $Y=355900
X497 792 2 781 785 813 1 789 FA1S $T=276520 336120 0 0 $X=276520 $Y=335740
X498 58 2 803 65 60 1 788 FA1S $T=290780 406680 1 180 $X=279000 $Y=406300
X499 802 2 795 810 746 1 814 FA1S $T=281480 366360 0 0 $X=281480 $Y=365980
X500 813 2 823 829 67 1 55 FA1S $T=298840 326040 0 180 $X=287060 $Y=320620
X501 812 2 805 801 784 1 830 FA1S $T=287680 356280 0 0 $X=287680 $Y=355900
X502 828 2 837 814 821 1 807 FA1S $T=305660 366360 1 180 $X=293880 $Y=365980
X503 822 2 830 836 802 1 840 FA1S $T=294500 376440 1 0 $X=294500 $Y=371020
X504 832 2 820 842 846 1 815 FA1S $T=298220 346200 0 0 $X=298220 $Y=345820
X505 845 2 78 850 77 1 71 FA1S $T=314340 326040 0 180 $X=302560 $Y=320620
X506 846 2 852 858 848 1 826 FA1S $T=314340 346200 0 180 $X=302560 $Y=340780
X507 851 2 847 856 832 1 837 FA1S $T=317440 356280 1 180 $X=305660 $Y=355900
X508 853 2 864 844 851 1 836 FA1S $T=318680 366360 1 180 $X=306900 $Y=365980
X509 848 2 860 880 870 1 850 FA1S $T=324880 326040 1 180 $X=313100 $Y=325660
X510 865 2 881 884 853 1 854 FA1S $T=325500 376440 0 180 $X=313720 $Y=371020
X511 794 2 861 877 878 1 842 FA1S $T=316200 346200 0 0 $X=316200 $Y=345820
X512 870 2 86 87 868 1 80 FA1S $T=329840 326040 0 180 $X=318060 $Y=320620
X513 872 2 863 866 812 1 884 FA1S $T=318680 366360 1 0 $X=318680 $Y=360940
X514 878 2 883 894 882 1 858 FA1S $T=331080 346200 0 180 $X=319300 $Y=340780
X515 859 2 84 81 92 1 89 FA1S $T=320540 406680 0 0 $X=320540 $Y=406300
X516 882 2 915 900 895 1 880 FA1S $T=338520 326040 1 180 $X=326740 $Y=325660
X517 899 2 897 891 903 1 889 FA1S $T=343480 376440 0 180 $X=331700 $Y=371020
X518 888 2 892 889 872 1 871 FA1S $T=332320 386520 1 0 $X=332320 $Y=381100
X519 101 2 917 930 899 1 893 FA1S $T=348440 386520 1 180 $X=336660 $Y=386140
X520 903 2 926 929 913 1 881 FA1S $T=349060 366360 1 180 $X=337280 $Y=365980
X521 913 2 923 931 920 1 864 FA1S $T=350920 366360 0 180 $X=339140 $Y=360940
X522 907 2 928 925 922 1 894 FA1S $T=352160 346200 0 180 $X=340380 $Y=340780
X523 920 2 904 924 921 1 856 FA1S $T=352160 356280 1 180 $X=340380 $Y=355900
X524 940 2 950 949 948 1 935 FA1S $T=365180 366360 0 180 $X=353400 $Y=360940
X525 108 2 909 114 936 1 955 FA1S $T=353400 406680 0 0 $X=353400 $Y=406300
X526 947 2 954 937 938 1 933 FA1S $T=367040 386520 0 180 $X=355260 $Y=381100
X527 113 2 947 955 952 1 911 FA1S $T=367660 396600 1 180 $X=355880 $Y=396220
X528 927 2 959 957 940 1 905 FA1S $T=368900 376440 1 180 $X=357120 $Y=376060
X529 952 2 941 116 956 1 938 FA1S $T=369520 396600 0 180 $X=357740 $Y=391180
X530 948 2 964 969 966 1 932 FA1S $T=374480 356280 1 180 $X=362700 $Y=355900
X531 968 2 977 974 971 1 949 FA1S $T=376960 366360 1 180 $X=365180 $Y=365980
X532 956 2 965 962 968 1 957 FA1S $T=379440 386520 0 180 $X=367660 $Y=381100
X533 966 2 967 980 979 1 946 FA1S $T=380060 356280 0 180 $X=368280 $Y=350860
X534 971 2 981 989 988 1 969 FA1S $T=388120 366360 0 180 $X=376340 $Y=360940
X535 988 2 994 999 986 1 980 FA1S $T=390600 356280 1 180 $X=378820 $Y=355900
X536 1020 2 1000 1027 1017 1 1023 FA1S $T=395560 346200 1 0 $X=395560 $Y=340780
X537 1040 2 1053 1049 1020 1 1032 FA1S $T=419120 346200 1 180 $X=407340 $Y=345820
X538 1066 2 1075 1083 1040 1 1057 FA1S $T=432140 346200 1 180 $X=420360 $Y=345820
X539 1069 2 1052 1059 1076 1 1083 FA1S $T=423460 336120 1 0 $X=423460 $Y=330700
X540 1089 2 1096 1078 1069 1 1091 FA1S $T=432760 326040 0 0 $X=432760 $Y=325660
X541 1114 2 1138 1119 1089 1 1097 FA1S $T=453220 336120 0 180 $X=441440 $Y=330700
X542 1117 2 1107 1097 1103 1 1133 FA1S $T=445780 346200 1 0 $X=445780 $Y=340780
X543 1146 2 1132 196 1114 1 1156 FA1S $T=458180 336120 0 0 $X=458180 $Y=335740
X544 1157 2 1166 1148 1129 1 1154 FA1S $T=465000 326040 0 0 $X=465000 $Y=325660
X545 1179 2 1157 1192 1176 1 1197 FA1S $T=474300 336120 1 0 $X=474300 $Y=330700
X546 1198 2 219 1189 1175 1 1192 FA1S $T=481120 326040 0 0 $X=481120 $Y=325660
X547 1221 2 1198 1205 1211 1 1223 FA1S $T=491660 336120 0 0 $X=491660 $Y=335740
X548 1242 2 1250 1230 1215 1 1256 FA1S $T=501580 336120 1 0 $X=501580 $Y=330700
X549 1268 2 1284 1253 1267 1 1264 FA1S $T=518940 346200 1 0 $X=518940 $Y=340780
X550 1295 2 1294 251 263 1 1309 FA1S $T=530720 336120 0 0 $X=530720 $Y=335740
X551 1303 2 261 247 1295 1 1323 FA1S $T=532580 346200 1 0 $X=532580 $Y=340780
X552 1311 2 1301 1252 265 1 271 FA1S $T=536920 326040 1 0 $X=536920 $Y=320620
X553 1314 2 266 1309 1311 1 1335 FA1S $T=537540 326040 0 0 $X=537540 $Y=325660
X554 1436 2 1431 1428 1454 1 1447 FA1S $T=606980 376440 0 0 $X=606980 $Y=376060
X555 331 2 1429 1434 1450 1 1455 FA1S $T=606980 386520 0 0 $X=606980 $Y=386140
X556 335 2 338 1435 1443 1 1430 FA1S $T=619380 406680 0 180 $X=607600 $Y=401260
X557 1439 2 1440 1459 1453 1 1462 FA1S $T=613800 346200 0 0 $X=613800 $Y=345820
X558 1450 2 1441 1446 1467 1 1464 FA1S $T=614420 366360 1 0 $X=614420 $Y=360940
X559 350 2 1480 1476 1469 1 340 FA1S $T=630540 406680 1 180 $X=618760 $Y=406300
X560 348 2 1474 1442 1473 1 1477 FA1S $T=620000 406680 1 0 $X=620000 $Y=401260
X561 1465 2 1451 344 355 1 1486 FA1S $T=621860 326040 1 0 $X=621860 $Y=320620
X562 1473 2 1485 1487 1461 1 1458 FA1S $T=634260 386520 1 180 $X=622480 $Y=386140
X563 1468 2 1444 1481 1489 1 1498 FA1S $T=623100 326040 0 0 $X=623100 $Y=325660
X564 1467 2 1479 1505 1470 1 1460 FA1S $T=634880 356280 1 180 $X=623100 $Y=355900
X565 1472 2 1458 1449 1491 1 1483 FA1S $T=624960 386520 1 0 $X=624960 $Y=381100
X566 1475 2 1460 1471 1468 1 1492 FA1S $T=626200 346200 0 0 $X=626200 $Y=345820
X567 1478 2 1483 1464 1475 1 1494 FA1S $T=626820 366360 0 0 $X=626820 $Y=365980
X568 1484 2 1455 1477 1472 1 1501 FA1S $T=629920 396600 1 0 $X=629920 $Y=391180
X569 1491 2 1488 1512 1497 1 1482 FA1S $T=644800 366360 0 180 $X=633020 $Y=360940
X570 370 2 372 1486 1503 1 360 FA1S $T=647280 326040 0 180 $X=635500 $Y=320620
X571 1499 2 1482 1492 1504 1 1508 FA1S $T=637360 356280 1 0 $X=637360 $Y=350860
X572 1502 2 1465 1493 1498 1 374 FA1S $T=638600 336120 1 0 $X=638600 $Y=330700
X573 1504 2 1515 1514 1511 1 1493 FA1S $T=650380 346200 1 180 $X=638600 $Y=345820
X574 376 2 1510 1507 1523 1 1474 FA1S $T=646660 406680 1 0 $X=646660 $Y=401260
X575 1511 2 1516 1517 1520 1 1503 FA1S $T=648520 326040 0 0 $X=648520 $Y=325660
X576 1497 2 1521 1519 1526 1 1515 FA1S $T=664020 346200 1 180 $X=652240 $Y=345820
X577 1542 2 1555 1548 1547 1 1524 FA1S $T=670840 366360 1 180 $X=659060 $Y=365980
X578 1550 2 1532 1561 1544 1 1568 FA1S $T=664020 376440 0 0 $X=664020 $Y=376060
X579 1573 2 1567 1565 1578 1 1592 FA1S $T=673320 366360 0 0 $X=673320 $Y=365980
X580 1579 2 1570 1576 403 1 1591 FA1S $T=676420 326040 0 0 $X=676420 $Y=325660
X581 405 2 1563 1556 1572 1 1598 FA1S $T=676420 356280 1 0 $X=676420 $Y=350860
X582 406 2 1557 1545 1579 1 1604 FA1S $T=677040 326040 1 0 $X=677040 $Y=320620
X583 1593 2 1607 1581 1582 1 1609 FA1S $T=681380 346200 1 0 $X=681380 $Y=340780
X584 1590 2 1603 1575 1588 1 411 FA1S $T=682000 406680 1 0 $X=682000 $Y=401260
X585 1596 2 1559 1591 1593 1 1616 FA1S $T=683240 336120 1 0 $X=683240 $Y=330700
X586 1602 2 1524 1573 1609 1 1600 FA1S $T=686960 366360 0 0 $X=686960 $Y=365980
X587 1601 2 1616 1542 1598 1 1599 FA1S $T=688820 356280 1 0 $X=688820 $Y=350860
X588 1611 2 1604 416 1596 1 1608 FA1S $T=689440 326040 0 0 $X=689440 $Y=325660
X589 1622 2 1631 1632 417 1 1640 FA1S $T=695640 376440 1 0 $X=695640 $Y=371020
X590 422 2 1606 1621 1618 1 439 FA1S $T=697500 336120 0 0 $X=697500 $Y=335740
X591 1643 2 1633 1638 1639 1 1654 FA1S $T=704940 406680 1 0 $X=704940 $Y=401260
X592 1646 2 1637 1626 1649 1 1670 FA1S $T=706800 386520 1 0 $X=706800 $Y=381100
X593 1647 2 1634 1635 1644 1 447 FA1S $T=707420 346200 1 0 $X=707420 $Y=340780
X594 448 2 1664 1661 1657 1 1683 FA1S $T=717340 406680 0 0 $X=717340 $Y=406300
X595 1673 2 1640 1660 1676 1 1688 FA1S $T=719200 366360 1 0 $X=719200 $Y=360940
X596 1674 2 1682 1663 1622 1 1687 FA1S $T=719200 376440 1 0 $X=719200 $Y=371020
X597 1676 2 1648 1655 1672 1 1693 FA1S $T=720440 356280 1 0 $X=720440 $Y=350860
X598 1680 2 1647 1696 1693 1 1699 FA1S $T=723540 346200 0 0 $X=723540 $Y=345820
X599 1689 2 1701 1678 1702 1 1706 FA1S $T=726640 386520 1 0 $X=726640 $Y=381100
X600 457 2 1683 1686 1643 1 1714 FA1S $T=729120 406680 0 0 $X=729120 $Y=406300
X601 1692 2 1712 1668 1708 1 468 FA1S $T=732220 336120 0 0 $X=732220 $Y=335740
X602 1704 2 1694 1710 1650 1 1696 FA1S $T=732840 356280 1 0 $X=732840 $Y=350860
X603 462 2 1711 1698 1646 1 1725 FA1S $T=738420 386520 0 0 $X=738420 $Y=386140
X604 1717 2 1709 1666 1669 1 1723 FA1S $T=738420 396600 1 0 $X=738420 $Y=391180
X605 1719 2 1697 1651 1652 1 1729 FA1S $T=739660 366360 1 0 $X=739660 $Y=360940
X606 1720 2 1624 1713 1522 1 1733 FA1S $T=739660 366360 0 0 $X=739660 $Y=365980
X607 1721 2 1670 1715 1719 1 1731 FA1S $T=741520 386520 1 0 $X=741520 $Y=381100
X608 1724 2 1704 1688 1729 1 1732 FA1S $T=745240 356280 1 0 $X=745240 $Y=350860
X609 1736 2 1654 1727 1674 1 1745 FA1S $T=751440 396600 1 0 $X=751440 $Y=391180
X610 472 2 469 1714 1736 1 1738 FA1S $T=751440 406680 0 0 $X=751440 $Y=406300
X611 1734 2 1745 1725 1721 1 1735 FA1S $T=752060 386520 0 0 $X=752060 $Y=386140
X612 1739 2 1687 1731 1673 1 1722 FA1S $T=753300 366360 0 0 $X=753300 $Y=365980
X613 1749 2 1628 1748 1525 1 1759 FA1S $T=765080 396600 0 0 $X=765080 $Y=396220
X614 497 2 499 1764 493 1 1756 FA1S $T=784920 326040 1 180 $X=773140 $Y=325660
X615 1779 2 1766 1787 1770 1 1760 FA1S $T=789260 346200 1 180 $X=777480 $Y=345820
X616 1768 2 1760 1782 1777 1 1790 FA1S $T=777480 356280 1 0 $X=777480 $Y=350860
X617 1769 2 1752 1784 1776 1 1793 FA1S $T=778100 376440 0 0 $X=778100 $Y=376060
X618 1786 2 500 1779 1756 1 1773 FA1S $T=783680 336120 0 0 $X=783680 $Y=335740
X619 509 2 517 511 514 1 1777 FA1S $T=798560 326040 1 180 $X=786780 $Y=325660
X620 1799 2 1805 1788 504 1 519 FA1S $T=789880 406680 1 0 $X=789880 $Y=401260
X621 1782 2 1797 1807 1804 1 1792 FA1S $T=802280 356280 0 180 $X=790500 $Y=350860
X622 1840 2 1823 1826 1842 1 1873 FA1S $T=810340 406680 1 0 $X=810340 $Y=401260
X623 1854 2 1829 1863 1843 1 541 FA1S $T=816540 326040 0 0 $X=816540 $Y=325660
X624 1855 2 1849 1833 1857 1 1872 FA1S $T=816540 336120 0 0 $X=816540 $Y=335740
X625 537 2 533 1847 542 1 543 FA1S $T=819020 326040 1 0 $X=819020 $Y=320620
X626 1862 2 1852 1845 1868 1 1883 FA1S $T=819640 396600 1 0 $X=819640 $Y=391180
X627 1868 2 1856 1877 1861 1 1885 FA1S $T=822120 376440 0 0 $X=822120 $Y=376060
X628 1875 2 547 1858 1862 1 1892 FA1S $T=824600 406680 0 0 $X=824600 $Y=406300
X629 544 2 540 1869 1835 1 1936 FA1S $T=826460 396600 0 0 $X=826460 $Y=396220
X630 1884 2 1879 1871 1876 1 1909 FA1S $T=827700 356280 0 0 $X=827700 $Y=355900
X631 1887 2 1865 1870 1886 1 1906 FA1S $T=830800 366360 0 0 $X=830800 $Y=365980
X632 1890 2 1885 1874 1887 1 1903 FA1S $T=831420 386520 1 0 $X=831420 $Y=381100
X633 1893 2 1878 1898 1889 1 1908 FA1S $T=832660 336120 0 0 $X=832660 $Y=335740
X634 1904 2 1895 1837 1910 1 1925 FA1S $T=838860 366360 1 0 $X=838860 $Y=360940
X635 1912 2 1918 1901 1891 1 1895 FA1S $T=851880 376440 0 180 $X=840100 $Y=371020
X636 1910 2 1899 1922 1905 1 1927 FA1S $T=841960 356280 1 0 $X=841960 $Y=350860
X637 1913 2 1921 1907 1900 1 1926 FA1S $T=842580 386520 0 0 $X=842580 $Y=386140
X638 1919 2 1893 1909 1927 1 1929 FA1S $T=845060 346200 1 0 $X=845060 $Y=340780
X639 1920 2 1902 1915 1911 1 1932 FA1S $T=846300 406680 1 0 $X=846300 $Y=401260
X640 555 2 553 1853 1920 1 1938 FA1S $T=846920 406680 0 0 $X=846920 $Y=406300
X641 557 2 1932 1846 1913 1 1940 FA1S $T=849400 396600 1 0 $X=849400 $Y=391180
X642 1931 2 1942 1883 1890 1 1930 FA1S $T=852500 386520 1 0 $X=852500 $Y=381100
X643 1933 2 1944 1903 1904 1 1943 FA1S $T=853740 366360 1 0 $X=853740 $Y=360940
X644 1935 2 1894 1831 1912 1 1944 FA1S $T=853740 376440 1 0 $X=853740 $Y=371020
X645 1939 2 1926 1934 1935 1 1942 FA1S $T=856220 386520 0 0 $X=856220 $Y=386140
X646 1941 2 1884 1925 1906 1 1937 FA1S $T=857460 356280 1 0 $X=857460 $Y=350860
X647 563 2 1938 561 1875 1 1948 FA1S $T=859940 406680 0 0 $X=859940 $Y=406300
X648 1949 2 1892 1940 1939 1 1957 FA1S $T=863040 396600 1 0 $X=863040 $Y=391180
X649 1953 2 1958 1947 571 1 1964 FA1S $T=865520 346200 1 0 $X=865520 $Y=340780
X650 570 2 1979 1962 568 1 1952 FA1S $T=879780 376440 0 180 $X=868000 $Y=371020
X651 575 2 1984 573 1992 1 577 FA1S $T=878540 406680 0 0 $X=878540 $Y=406300
X652 1995 2 2008 1951 581 1 1981 FA1S $T=899000 326040 0 180 $X=887220 $Y=320620
X653 2025 2 2033 2020 2018 1 2001 FA1S $T=912020 386520 0 180 $X=900240 $Y=381100
X654 601 2 598 606 2034 1 608 FA1S $T=911400 326040 1 0 $X=911400 $Y=320620
X655 604 2 2048 2042 2046 1 611 FA1S $T=915740 386520 0 0 $X=915740 $Y=386140
X656 612 2 2054 2069 2062 1 605 FA1S $T=931860 406680 0 180 $X=920080 $Y=401260
X657 2059 2 2055 2045 2031 1 2079 FA1S $T=921320 336120 1 0 $X=921320 $Y=330700
X658 616 2 2078 2066 2073 1 622 FA1S $T=930620 406680 0 0 $X=930620 $Y=406300
X659 2091 2 2083 2077 2092 1 2099 FA1S $T=936820 336120 1 0 $X=936820 $Y=330700
X660 2102 2 2113 2093 2110 1 624 FA1S $T=956660 396600 1 180 $X=944880 $Y=396220
X661 2104 2 2116 2112 2102 1 625 FA1S $T=957280 406680 1 180 $X=945500 $Y=406300
X662 2105 2 2099 2076 627 1 2122 FA1S $T=947980 326040 1 0 $X=947980 $Y=320620
X663 2111 2 2091 2100 2105 1 2125 FA1S $T=950460 336120 1 0 $X=950460 $Y=330700
X664 2118 2 2059 2087 2114 1 2136 FA1S $T=952940 346200 0 0 $X=952940 $Y=345820
X665 2119 2 2108 2101 2120 1 2116 FA1S $T=952940 386520 0 0 $X=952940 $Y=386140
X666 2128 2 2121 2131 2119 1 2135 FA1S $T=959140 396600 0 0 $X=959140 $Y=396220
X667 2130 2 630 2122 632 1 2137 FA1S $T=964720 326040 0 0 $X=964720 $Y=325660
X668 2140 2 2097 2133 2103 1 2141 FA1S $T=966580 386520 0 0 $X=966580 $Y=386140
X669 27 2 751 29 1 NR2 $T=252340 396600 0 0 $X=252340 $Y=396220
X670 34 2 33 13 1 NR2 $T=256680 406680 0 180 $X=254820 $Y=401260
X671 28 2 32 19 1 NR2 $T=257920 406680 0 0 $X=257920 $Y=406300
X672 34 2 750 19 1 NR2 $T=259780 386520 0 0 $X=259780 $Y=386140
X673 36 2 766 29 1 NR2 $T=263500 406680 0 0 $X=263500 $Y=406300
X674 40 2 759 25 1 NR2 $T=266600 326040 0 180 $X=264740 $Y=320620
X675 35 2 44 45 1 NR2 $T=269700 406680 0 0 $X=269700 $Y=406300
X676 47 2 780 776 1 NR2 $T=274660 356280 1 0 $X=274660 $Y=350860
X677 48 2 756 50 1 NR2 $T=275280 326040 0 0 $X=275280 $Y=325660
X678 779 2 793 747 1 NR2 $T=278380 356280 1 0 $X=278380 $Y=350860
X679 51 2 800 54 1 NR2 $T=281480 336120 1 0 $X=281480 $Y=330700
X680 40 2 801 747 1 NR2 $T=283340 356280 1 0 $X=283340 $Y=350860
X681 57 2 803 13 1 NR2 $T=285820 406680 1 0 $X=285820 $Y=401260
X682 779 2 805 776 1 NR2 $T=287680 356280 1 0 $X=287680 $Y=350860
X683 34 2 825 29 1 NR2 $T=292640 396600 0 0 $X=292640 $Y=396220
X684 57 2 63 29 1 NR2 $T=295740 406680 0 180 $X=293880 $Y=401260
X685 47 2 820 747 1 NR2 $T=294500 356280 1 0 $X=294500 $Y=350860
X686 68 2 66 13 1 NR2 $T=298840 406680 1 0 $X=298840 $Y=401260
X687 73 2 827 70 1 NR2 $T=306280 336120 1 180 $X=304420 $Y=335740
X688 57 2 841 19 1 NR2 $T=306280 396600 1 0 $X=306280 $Y=391180
X689 40 2 847 50 1 NR2 $T=310000 356280 0 180 $X=308140 $Y=350860
X690 76 2 852 835 1 NR2 $T=311240 336120 0 0 $X=311240 $Y=335740
X691 79 2 860 835 1 NR2 $T=316200 336120 0 0 $X=316200 $Y=335740
X692 73 2 861 835 1 NR2 $T=316820 346200 1 0 $X=316820 $Y=340780
X693 40 2 863 835 1 NR2 $T=318060 356280 0 0 $X=318060 $Y=355900
X694 83 2 868 835 1 NR2 $T=324880 336120 1 180 $X=323020 $Y=335740
X695 79 2 883 875 1 NR2 $T=326120 336120 0 0 $X=326120 $Y=335740
X696 90 2 829 94 1 NR2 $T=332320 326040 1 0 $X=332320 $Y=320620
X697 896 2 895 875 1 NR2 $T=335420 336120 1 180 $X=333560 $Y=335740
X698 91 2 901 898 1 NR2 $T=334800 356280 0 0 $X=334800 $Y=355900
X699 849 2 897 898 1 NR2 $T=334800 366360 0 0 $X=334800 $Y=365980
X700 73 2 904 898 1 NR2 $T=339140 356280 0 180 $X=337280 $Y=350860
X701 98 2 900 96 1 NR2 $T=339760 326040 0 180 $X=337900 $Y=320620
X702 849 2 909 914 1 NR2 $T=344100 386520 1 0 $X=344100 $Y=381100
X703 919 2 923 898 1 NR2 $T=347200 376440 1 0 $X=347200 $Y=371020
X704 90 2 937 898 1 NR2 $T=354020 366360 1 180 $X=352160 $Y=365980
X705 896 2 922 934 1 NR2 $T=352780 346200 1 0 $X=352780 $Y=340780
X706 90 2 936 934 1 NR2 $T=352780 356280 0 0 $X=352780 $Y=355900
X707 862 2 926 898 1 NR2 $T=357740 356280 1 180 $X=355880 $Y=355900
X708 896 2 945 943 1 NR2 $T=358360 346200 0 0 $X=358360 $Y=345820
X709 862 2 941 914 1 NR2 $T=360220 386520 1 180 $X=358360 $Y=386140
X710 963 2 965 943 1 NR2 $T=370760 376440 0 0 $X=370760 $Y=376060
X711 908 2 977 943 1 NR2 $T=374480 356280 0 0 $X=374480 $Y=355900
X712 91 2 981 943 1 NR2 $T=381300 366360 1 180 $X=379440 $Y=365980
X713 127 2 983 943 1 NR2 $T=385020 356280 1 0 $X=385020 $Y=350860
X714 983 2 991 982 1 NR2 $T=388120 346200 1 0 $X=388120 $Y=340780
X715 996 2 994 943 1 NR2 $T=390600 366360 0 180 $X=388740 $Y=360940
X716 144 2 986 991 1 NR2 $T=393080 346200 1 180 $X=391220 $Y=345820
X717 996 2 1004 1003 1 NR2 $T=396180 376440 1 180 $X=394320 $Y=376060
X718 996 2 1002 896 1 NR2 $T=397420 326040 0 0 $X=397420 $Y=325660
X719 146 2 1017 908 1 NR2 $T=399280 336120 1 0 $X=399280 $Y=330700
X720 127 2 1027 1029 1 NR2 $T=402380 336120 1 0 $X=402380 $Y=330700
X721 127 2 1024 1025 1 NR2 $T=402380 346200 0 0 $X=402380 $Y=345820
X722 1011 2 1028 1026 1 NR2 $T=403000 386520 1 0 $X=403000 $Y=381100
X723 1015 2 1033 1023 1 NR2 $T=404240 366360 1 0 $X=404240 $Y=360940
X724 996 2 1038 908 1 NR2 $T=409200 336120 1 0 $X=409200 $Y=330700
X725 1039 2 1055 1050 1 NR2 $T=419120 356280 1 0 $X=419120 $Y=350860
X726 155 2 1059 1056 1 NR2 $T=422840 326040 1 180 $X=420980 $Y=325660
X727 143 2 1053 146 1 NR2 $T=421600 346200 1 0 $X=421600 $Y=340780
X728 1070 2 1065 1057 1 NR2 $T=425320 356280 0 180 $X=423460 $Y=350860
X729 112 2 167 118 1 NR2 $T=424080 326040 1 0 $X=424080 $Y=320620
X730 796 2 1075 146 1 NR2 $T=426560 336120 0 0 $X=426560 $Y=335740
X731 1072 2 1071 1064 1 NR2 $T=428420 396600 1 180 $X=426560 $Y=396220
X732 1043 2 1064 1058 1 NR2 $T=428420 406680 0 180 $X=426560 $Y=401260
X733 173 2 1078 169 1 NR2 $T=431520 326040 0 180 $X=429660 $Y=320620
X734 143 2 1076 151 1 NR2 $T=429660 326040 0 0 $X=429660 $Y=325660
X735 1080 2 1099 1081 1 NR2 $T=435860 396600 1 0 $X=435860 $Y=391180
X736 62 2 1090 146 1 NR2 $T=438340 336120 1 0 $X=438340 $Y=330700
X737 796 2 1096 151 1 NR2 $T=441440 326040 1 0 $X=441440 $Y=320620
X738 1072 2 1098 1099 1 NR2 $T=443300 386520 1 180 $X=441440 $Y=386140
X739 1093 2 1110 1101 1 NR2 $T=445160 346200 0 0 $X=445160 $Y=345820
X740 796 2 188 150 1 NR2 $T=450740 326040 1 0 $X=450740 $Y=320620
X741 1112 2 1121 1109 1 NR2 $T=450740 396600 1 0 $X=450740 $Y=391180
X742 62 2 1129 150 1 NR2 $T=455700 326040 0 180 $X=453840 $Y=320620
X743 1072 2 1134 1121 1 NR2 $T=455700 396600 1 180 $X=453840 $Y=396220
X744 1113 2 1139 1133 1 NR2 $T=457560 346200 0 0 $X=457560 $Y=345820
X745 62 2 1138 151 1 NR2 $T=458180 326040 0 0 $X=458180 $Y=325660
X746 1145 2 1158 1124 1 NR2 $T=464380 386520 1 180 $X=462520 $Y=386140
X747 205 2 1149 999 1 NR2 $T=464380 396600 0 180 $X=462520 $Y=391180
X748 974 2 1160 205 1 NR2 $T=469960 406680 1 0 $X=469960 $Y=401260
X749 796 2 1166 207 1 NR2 $T=471200 326040 1 0 $X=471200 $Y=320620
X750 1158 2 1174 1072 1 NR2 $T=471200 396600 1 0 $X=471200 $Y=391180
X751 116 2 209 205 1 NR2 $T=471200 406680 0 0 $X=471200 $Y=406300
X752 1172 2 1181 1165 1 NR2 $T=476780 386520 1 180 $X=474920 $Y=386140
X753 1161 2 1162 1177 1 NR2 $T=477400 356280 1 0 $X=477400 $Y=350860
X754 1181 2 1188 1072 1 NR2 $T=479880 386520 0 0 $X=479880 $Y=386140
X755 796 2 1189 159 1 NR2 $T=482980 326040 1 0 $X=482980 $Y=320620
X756 1164 2 1183 1171 1 NR2 $T=482980 356280 1 0 $X=482980 $Y=350860
X757 1191 2 1201 1199 1 NR2 $T=487320 396600 0 180 $X=485460 $Y=391180
X758 1201 2 1212 1072 1 NR2 $T=490420 396600 1 0 $X=490420 $Y=391180
X759 207 2 230 228 1 NR2 $T=495380 326040 1 0 $X=495380 $Y=320620
X760 200 2 1219 221 1 NR2 $T=495380 326040 0 0 $X=495380 $Y=325660
X761 221 2 1230 199 1 NR2 $T=499720 326040 1 0 $X=499720 $Y=320620
X762 1226 2 1240 1237 1 NR2 $T=500960 356280 1 0 $X=500960 $Y=350860
X763 1246 2 1248 1238 1 NR2 $T=507780 356280 0 180 $X=505920 $Y=350860
X764 1234 2 1255 1229 1 NR2 $T=510260 396600 1 0 $X=510260 $Y=391180
X765 221 2 240 228 1 NR2 $T=512120 326040 1 0 $X=512120 $Y=320620
X766 1255 2 1245 1220 1 NR2 $T=513360 386520 0 0 $X=513360 $Y=386140
X767 1265 2 1275 1220 1 NR2 $T=517700 396600 0 180 $X=515840 $Y=391180
X768 1261 2 1265 1271 1 NR2 $T=518320 386520 0 0 $X=518320 $Y=386140
X769 226 2 1266 199 1 NR2 $T=519560 326040 0 0 $X=519560 $Y=325660
X770 213 2 1279 199 1 NR2 $T=524520 326040 1 0 $X=524520 $Y=320620
X771 1280 2 1282 1220 1 NR2 $T=526380 386520 0 180 $X=524520 $Y=381100
X772 250 2 1280 255 1 NR2 $T=525140 406680 1 0 $X=525140 $Y=401260
X773 213 2 256 228 1 NR2 $T=528240 326040 1 0 $X=528240 $Y=320620
X774 226 2 1301 228 1 NR2 $T=533200 326040 1 0 $X=533200 $Y=320620
X775 200 2 1294 228 1 NR2 $T=533200 326040 0 0 $X=533200 $Y=325660
X776 1304 2 1308 1220 1 NR2 $T=535680 406680 1 180 $X=533820 $Y=406300
X777 260 2 1304 1278 1 NR2 $T=537540 396600 1 0 $X=537540 $Y=391180
X778 1358 2 303 1362 1 NR2 $T=565440 406680 1 0 $X=565440 $Y=401260
X779 1365 2 1344 1370 1 NR2 $T=572260 386520 0 0 $X=572260 $Y=386140
X780 1380 2 1349 1398 1 NR2 $T=579080 396600 1 0 $X=579080 $Y=391180
X781 1389 2 1370 1400 1 NR2 $T=584040 386520 0 0 $X=584040 $Y=386140
X782 1380 2 1396 1401 1 NR2 $T=584660 396600 0 0 $X=584660 $Y=396220
X783 1369 2 317 1391 1 NR2 $T=592720 406680 0 0 $X=592720 $Y=406300
X784 316 2 314 1417 1 NR2 $T=598300 326040 1 180 $X=596440 $Y=325660
X785 326 2 204 1417 1 NR2 $T=599540 336120 1 180 $X=597680 $Y=335740
X786 1378 2 318 1385 1 NR2 $T=598920 406680 0 0 $X=598920 $Y=406300
X787 1421 2 1400 1415 1 NR2 $T=602020 386520 1 180 $X=600160 $Y=386140
X788 305 2 332 312 1 NR2 $T=610700 356280 0 180 $X=608840 $Y=350860
X789 330 2 1428 1438 1 NR2 $T=610700 366360 1 0 $X=610700 $Y=360940
X790 330 2 1435 333 1 NR2 $T=610700 406680 0 0 $X=610700 $Y=406300
X791 1422 2 1425 336 1 NR2 $T=613800 326040 1 0 $X=613800 $Y=320620
X792 1452 2 1444 1445 1 NR2 $T=619380 336120 0 0 $X=619380 $Y=335740
X793 330 2 1459 343 1 NR2 $T=620000 346200 1 0 $X=620000 $Y=340780
X794 1457 2 1442 1448 1 NR2 $T=622480 376440 1 0 $X=622480 $Y=371020
X795 351 2 1461 347 1 NR2 $T=626820 396600 0 180 $X=624960 $Y=391180
X796 351 2 1479 357 1 NR2 $T=628680 356280 1 0 $X=628680 $Y=350860
X797 353 2 1470 1438 1 NR2 $T=630540 366360 0 180 $X=628680 $Y=360940
X798 351 2 1481 358 1 NR2 $T=631780 336120 1 0 $X=631780 $Y=330700
X799 353 2 1469 358 1 NR2 $T=633640 406680 0 0 $X=633640 $Y=406300
X800 361 2 1480 357 1 NR2 $T=636120 406680 0 180 $X=634260 $Y=401260
X801 362 2 1485 357 1 NR2 $T=636740 386520 1 180 $X=634880 $Y=386140
X802 362 2 1489 364 1 NR2 $T=636740 336120 1 0 $X=636740 $Y=330700
X803 362 2 1476 365 1 NR2 $T=637360 406680 1 0 $X=637360 $Y=401260
X804 366 2 367 365 1 NR2 $T=639840 406680 1 180 $X=637980 $Y=406300
X805 361 2 1487 368 1 NR2 $T=639220 386520 0 0 $X=639220 $Y=386140
X806 361 2 1500 333 1 NR2 $T=641080 386520 1 0 $X=641080 $Y=381100
X807 361 2 1507 358 1 NR2 $T=641700 406680 1 0 $X=641700 $Y=401260
X808 351 2 1510 365 1 NR2 $T=643560 396600 1 0 $X=643560 $Y=391180
X809 356 2 1516 364 1 NR2 $T=649140 326040 1 0 $X=649140 $Y=320620
X810 375 2 1505 347 1 NR2 $T=649760 356280 1 0 $X=649760 $Y=350860
X811 381 2 1517 357 1 NR2 $T=654100 326040 0 180 $X=652240 $Y=320620
X812 362 2 1520 380 1 NR2 $T=652240 336120 1 0 $X=652240 $Y=330700
X813 375 2 1521 357 1 NR2 $T=654100 346200 0 180 $X=652240 $Y=340780
X814 1518 2 1512 1513 1 NR2 $T=652860 366360 1 0 $X=652860 $Y=360940
X815 381 2 383 358 1 NR2 $T=655340 326040 1 0 $X=655340 $Y=320620
X816 381 2 1519 387 1 NR2 $T=657200 336120 0 0 $X=657200 $Y=335740
X817 353 2 1523 368 1 NR2 $T=662160 396600 0 180 $X=660300 $Y=391180
X818 366 2 1526 380 1 NR2 $T=662780 356280 0 180 $X=660920 $Y=350860
X819 1537 2 389 1527 1 NR2 $T=663400 326040 0 180 $X=661540 $Y=320620
X820 1543 2 1539 1536 1 NR2 $T=665880 386520 1 180 $X=664020 $Y=386140
X821 1549 2 1544 1539 1 NR2 $T=667740 396600 0 180 $X=665880 $Y=391180
X822 1541 2 1556 1546 1 NR2 $T=666500 356280 1 0 $X=666500 $Y=350860
X823 1538 2 1557 1553 1 NR2 $T=667120 336120 0 0 $X=667120 $Y=335740
X824 1438 2 1548 1552 1 NR2 $T=667740 366360 1 0 $X=667740 $Y=360940
X825 1529 2 1547 1534 1 NR2 $T=670840 376440 1 0 $X=670840 $Y=371020
X826 398 2 396 395 1 NR2 $T=674560 326040 0 180 $X=672700 $Y=320620
X827 1569 2 1565 1552 1 NR2 $T=674560 366360 0 180 $X=672700 $Y=360940
X828 1554 2 1549 1562 1 NR2 $T=672700 396600 0 0 $X=672700 $Y=396220
X829 380 2 1563 393 1 NR2 $T=675180 346200 1 180 $X=673320 $Y=345820
X830 1569 2 1570 399 1 NR2 $T=675800 336120 1 0 $X=675800 $Y=330700
X831 400 2 1572 368 1 NR2 $T=677660 366360 0 180 $X=675800 $Y=360940
X832 1438 2 1567 1583 1 NR2 $T=676420 356280 0 0 $X=676420 $Y=355900
X833 398 2 1576 408 1 NR2 $T=678900 336120 1 0 $X=678900 $Y=330700
X834 404 2 1582 368 1 NR2 $T=680760 346200 0 180 $X=678900 $Y=340780
X835 400 2 1581 1574 1 NR2 $T=678900 346200 0 0 $X=678900 $Y=345820
X836 404 2 1578 1574 1 NR2 $T=680760 366360 0 180 $X=678900 $Y=360940
X837 1531 2 1588 1558 1 NR2 $T=682000 406680 0 0 $X=682000 $Y=406300
X838 1595 2 1564 1574 1 NR2 $T=687580 386520 1 180 $X=685720 $Y=386140
X839 1574 2 1603 1605 1 NR2 $T=688820 386520 0 0 $X=688820 $Y=386140
X840 1569 2 1607 408 1 NR2 $T=693780 346200 1 0 $X=693780 $Y=340780
X841 381 2 1618 1569 1 NR2 $T=698740 336120 0 180 $X=696880 $Y=330700
X842 1624 2 1620 1612 1 NR2 $T=701220 386520 1 180 $X=699360 $Y=386140
X843 1625 2 1624 381 1 NR2 $T=701840 366360 1 180 $X=699980 $Y=365980
X844 1623 2 1626 399 1 NR2 $T=700600 386520 1 0 $X=700600 $Y=381100
X845 1625 2 1634 1552 1 NR2 $T=703080 346200 0 0 $X=703080 $Y=345820
X846 1625 2 1621 1605 1 NR2 $T=703080 356280 1 0 $X=703080 $Y=350860
X847 1625 2 1632 399 1 NR2 $T=704940 366360 0 180 $X=703080 $Y=360940
X848 1605 2 426 1569 1 NR2 $T=704940 376440 1 180 $X=703080 $Y=376060
X849 1623 2 1630 1595 1 NR2 $T=703700 356280 0 0 $X=703700 $Y=355900
X850 1641 2 1637 408 1 NR2 $T=706800 386520 1 180 $X=704940 $Y=386140
X851 429 2 1633 427 1 NR2 $T=704940 406680 0 0 $X=704940 $Y=406300
X852 1623 2 1631 408 1 NR2 $T=705560 366360 0 0 $X=705560 $Y=365980
X853 1623 2 1635 1627 1 NR2 $T=706180 356280 0 0 $X=706180 $Y=355900
X854 431 2 433 428 1 NR2 $T=706800 406680 0 0 $X=706800 $Y=406300
X855 1636 2 1644 1587 1 NR2 $T=708040 346200 0 0 $X=708040 $Y=345820
X856 1625 2 1655 408 1 NR2 $T=708660 356280 1 0 $X=708660 $Y=350860
X857 1641 2 1639 399 1 NR2 $T=710520 396600 1 180 $X=708660 $Y=396220
X858 435 2 1638 1627 1 NR2 $T=709280 406680 0 0 $X=709280 $Y=406300
X859 1636 2 1648 1627 1 NR2 $T=712380 356280 1 180 $X=710520 $Y=355900
X860 1636 2 440 1605 1 NR2 $T=711760 346200 0 0 $X=711760 $Y=345820
X861 1623 2 1650 1552 1 NR2 $T=713000 356280 0 0 $X=713000 $Y=355900
X862 442 2 1649 1595 1 NR2 $T=713000 386520 0 0 $X=713000 $Y=386140
X863 435 2 443 427 1 NR2 $T=713620 406680 0 0 $X=713620 $Y=406300
X864 429 2 1652 1627 1 NR2 $T=714240 366360 0 0 $X=714240 $Y=365980
X865 1642 2 438 1645 1 NR2 $T=714860 326040 1 0 $X=714860 $Y=320620
X866 1623 2 1662 1587 1 NR2 $T=714860 346200 0 0 $X=714860 $Y=345820
X867 1636 2 1651 1552 1 NR2 $T=716720 366360 0 180 $X=714860 $Y=360940
X868 442 2 1657 1627 1 NR2 $T=715480 406680 0 0 $X=715480 $Y=406300
X869 446 2 1666 1595 1 NR2 $T=719200 396600 0 180 $X=717340 $Y=391180
X870 1641 2 1664 428 1 NR2 $T=717340 396600 0 0 $X=717340 $Y=396220
X871 435 2 1661 432 1 NR2 $T=719820 406680 1 0 $X=719820 $Y=401260
X872 429 2 1672 1587 1 NR2 $T=720440 346200 0 0 $X=720440 $Y=345820
X873 435 2 1677 1587 1 NR2 $T=720440 386520 0 0 $X=720440 $Y=386140
X874 429 2 1684 1605 1 NR2 $T=721060 346200 1 0 $X=721060 $Y=340780
X875 446 2 1678 1605 1 NR2 $T=724780 386520 0 180 $X=722920 $Y=381100
X876 1659 2 1663 1665 1 NR2 $T=723540 366360 0 0 $X=723540 $Y=365980
X877 1675 2 1686 1695 1 NR2 $T=729740 406680 1 0 $X=729740 $Y=401260
X878 1691 2 1697 1685 1 NR2 $T=731600 366360 0 0 $X=731600 $Y=365980
X879 1700 2 1710 1705 1 NR2 $T=737800 366360 1 0 $X=737800 $Y=360940
X880 481 2 485 483 1 NR2 $T=767560 326040 1 0 $X=767560 $Y=320620
X881 1755 2 1764 1757 1 NR2 $T=774380 336120 0 0 $X=774380 $Y=335740
X882 1753 2 1770 1751 1 NR2 $T=774380 346200 1 0 $X=774380 $Y=340780
X883 1763 2 1775 1765 1 NR2 $T=779960 386520 0 0 $X=779960 $Y=386140
X884 1780 2 1776 1775 1 NR2 $T=784920 386520 1 180 $X=783060 $Y=386140
X885 1785 2 1780 1772 1 NR2 $T=787400 406680 0 180 $X=785540 $Y=401260
X886 502 2 1787 1794 1 NR2 $T=789260 346200 0 0 $X=789260 $Y=345820
X887 513 2 504 503 1 NR2 $T=793600 406680 1 180 $X=791740 $Y=406300
X888 502 2 1797 1800 1 NR2 $T=793600 346200 0 0 $X=793600 $Y=345820
X889 1802 2 1804 518 1 NR2 $T=797940 356280 0 0 $X=797940 $Y=355900
X890 1806 2 1817 1811 1 NR2 $T=800420 336120 1 0 $X=800420 $Y=330700
X891 518 2 1805 1812 1 NR2 $T=801040 406680 0 0 $X=801040 $Y=406300
X892 520 2 1807 1794 1 NR2 $T=803520 356280 0 0 $X=803520 $Y=355900
X893 1813 2 1801 518 1 NR2 $T=805380 386520 1 180 $X=803520 $Y=386140
X894 1812 2 522 520 1 NR2 $T=806000 366360 1 180 $X=804140 $Y=365980
X895 525 2 1826 1812 1 NR2 $T=808480 406680 1 180 $X=806620 $Y=406300
X896 1827 2 1831 1824 1 NR2 $T=810340 376440 1 180 $X=808480 $Y=376060
X897 1836 2 1825 1813 1 NR2 $T=814680 366360 1 180 $X=812820 $Y=365980
X898 1848 2 1841 1812 1 NR2 $T=817160 366360 0 180 $X=815300 $Y=360940
X899 1839 2 1846 1844 1 NR2 $T=815300 396600 0 0 $X=815300 $Y=396220
X900 1836 2 1834 1802 1 NR2 $T=815920 346200 0 0 $X=815920 $Y=345820
X901 1848 2 1870 1794 1 NR2 $T=820260 366360 1 0 $X=820260 $Y=360940
X902 1848 2 1856 535 1 NR2 $T=820260 386520 1 0 $X=820260 $Y=381100
X903 1851 2 1871 1850 1 NR2 $T=825220 356280 1 180 $X=823360 $Y=355900
X904 539 2 1861 1813 1 NR2 $T=825840 386520 0 180 $X=823980 $Y=381100
X905 525 2 1869 1813 1 NR2 $T=825840 396600 1 180 $X=823980 $Y=396220
X906 1867 2 1865 1859 1 NR2 $T=826460 366360 1 180 $X=824600 $Y=365980
X907 1836 2 1877 545 1 NR2 $T=827700 376440 1 0 $X=827700 $Y=371020
X908 1882 2 1878 1794 1 NR2 $T=831420 336120 1 180 $X=829560 $Y=335740
X909 1836 2 1876 1794 1 NR2 $T=831420 346200 1 180 $X=829560 $Y=345820
X910 1882 2 549 1812 1 NR2 $T=835140 326040 1 180 $X=833280 $Y=325660
X911 1888 2 1866 1812 1 NR2 $T=835140 346200 0 180 $X=833280 $Y=340780
X912 548 2 1880 434 1 NR2 $T=835140 396600 0 180 $X=833280 $Y=391180
X913 531 2 1889 1802 1 NR2 $T=838240 346200 0 180 $X=836380 $Y=340780
X914 1888 2 1886 1808 1 NR2 $T=836380 376440 1 0 $X=836380 $Y=371020
X915 550 2 1891 434 1 NR2 $T=838240 396600 0 180 $X=836380 $Y=391180
X916 1836 2 1898 1808 1 NR2 $T=838240 346200 1 0 $X=838240 $Y=340780
X917 531 2 1899 1808 1 NR2 $T=838860 346200 0 0 $X=838860 $Y=345820
X918 1848 2 1900 545 1 NR2 $T=838860 386520 0 0 $X=838860 $Y=386140
X919 1848 2 1902 428 1 NR2 $T=841340 406680 0 180 $X=839480 $Y=401260
X920 1888 2 551 428 1 NR2 $T=841340 406680 1 180 $X=839480 $Y=406300
X921 548 2 1907 1808 1 NR2 $T=840100 396600 1 0 $X=840100 $Y=391180
X922 1888 2 1905 1802 1 NR2 $T=845680 346200 1 180 $X=843820 $Y=345820
X923 539 2 1911 1808 1 NR2 $T=846300 406680 0 180 $X=844440 $Y=401260
X924 1914 2 1901 545 1 NR2 $T=846920 366360 1 180 $X=845060 $Y=365980
X925 548 2 1915 432 1 NR2 $T=845060 396600 1 0 $X=845060 $Y=391180
X926 1916 2 1921 532 1 NR2 $T=848160 386520 1 0 $X=848160 $Y=381100
X927 1914 2 1922 532 1 NR2 $T=848780 346200 0 0 $X=848780 $Y=345820
X928 1836 2 1918 532 1 NR2 $T=850640 366360 1 180 $X=848780 $Y=365980
X929 1978 2 1976 1985 1 NR2 $T=886600 366360 1 0 $X=886600 $Y=360940
X930 572 2 2010 1982 1 NR2 $T=897140 406680 0 180 $X=895280 $Y=401260
X931 2008 2 1994 2004 1 NR2 $T=897760 336120 1 180 $X=895900 $Y=335740
X932 1914 2 2008 582 1 NR2 $T=899000 336120 0 180 $X=897140 $Y=330700
X933 2011 2 2013 2004 1 NR2 $T=898380 346200 1 0 $X=898380 $Y=340780
X934 2009 2 2028 2019 1 NR2 $T=909540 396600 1 180 $X=907680 $Y=396220
X935 2011 2 2061 2040 1 NR2 $T=922560 346200 0 0 $X=922560 $Y=345820
X936 607 2 2077 597 1 NR2 $T=925040 326040 0 0 $X=925040 $Y=325660
X937 610 2 2055 613 1 NR2 $T=925660 326040 1 0 $X=925660 $Y=320620
X938 2056 2 2066 2061 1 NR2 $T=929380 356280 0 180 $X=927520 $Y=350860
X939 617 2 2083 614 1 NR2 $T=936200 326040 0 180 $X=934340 $Y=320620
X940 2081 2 619 2084 1 NR2 $T=934340 406680 1 0 $X=934340 $Y=401260
X941 2064 2 2065 2070 1 NR2 $T=937440 366360 1 0 $X=937440 $Y=360940
X942 618 2 2092 613 1 NR2 $T=942400 326040 0 180 $X=940540 $Y=320620
X943 2098 2 2114 597 1 NR2 $T=947980 346200 0 180 $X=946120 $Y=340780
X944 771 788 2 1 798 OR2 $T=285200 386520 0 0 $X=285200 $Y=386140
X945 1043 1079 2 1 1086 OR2 $T=432140 376440 0 0 $X=432140 $Y=376060
X946 1067 1087 2 1 1094 OR2 $T=435240 376440 0 0 $X=435240 $Y=376060
X947 1086 1094 2 1 1118 OR2 $T=447640 376440 1 0 $X=447640 $Y=371020
X948 1100 1108 2 1 1116 OR2 $T=447640 376440 0 0 $X=447640 $Y=376060
X949 1116 1123 2 1 1122 OR2 $T=452600 376440 0 0 $X=452600 $Y=376060
X950 1140 1131 2 1 1123 OR2 $T=458800 386520 1 180 $X=456320 $Y=386140
X951 1118 1122 2 1 1163 OR2 $T=468100 376440 0 0 $X=468100 $Y=376060
X952 1178 1173 2 1 1167 OR2 $T=476780 376440 1 180 $X=474300 $Y=376060
X953 1193 1194 2 1 1200 OR2 $T=485460 376440 0 0 $X=485460 $Y=376060
X954 1167 1200 2 1 1209 OR2 $T=489180 376440 0 0 $X=489180 $Y=376060
X955 1209 1216 2 1 1214 OR2 $T=492900 376440 1 0 $X=492900 $Y=371020
X956 1224 1227 2 1 1216 OR2 $T=497860 386520 1 0 $X=497860 $Y=381100
X957 1228 1225 2 1 1224 OR2 $T=500340 386520 1 180 $X=497860 $Y=386140
X958 1251 1244 2 1 1227 OR2 $T=509640 376440 1 180 $X=507160 $Y=376060
X959 1300 1292 2 1 1307 OR2 $T=536300 386520 1 0 $X=536300 $Y=381100
X960 1315 1283 2 1 1318 OR2 $T=541880 396600 0 0 $X=541880 $Y=396220
X961 1285 1310 2 1 1322 OR2 $T=542500 386520 0 0 $X=542500 $Y=386140
X962 1337 1307 2 1 1327 OR2 $T=550560 386520 0 180 $X=548080 $Y=381100
X963 1322 1318 2 1 1337 OR2 $T=548080 386520 0 0 $X=548080 $Y=386140
X964 1345 280 2 1 1334 OR2 $T=557380 366360 1 180 $X=554900 $Y=365980
X965 1163 1214 2 1 1359 OR2 $T=563580 376440 0 0 $X=563580 $Y=376060
X966 1359 1336 2 1 1366 OR2 $T=568540 376440 1 0 $X=568540 $Y=371020
X967 311 308 2 1 205 OR2 $T=585280 336120 1 180 $X=582800 $Y=335740
X968 1394 310 2 1 309 OR2 $T=588380 326040 0 180 $X=585900 $Y=320620
X969 312 311 2 1 1095 OR2 $T=589000 346200 0 180 $X=586520 $Y=340780
X970 315 313 2 1 1329 OR2 $T=595200 326040 0 180 $X=592720 $Y=320620
X971 35 783 45 2 1 ND2S $T=277140 406680 1 180 $X=275280 $Y=406300
X972 771 816 788 2 1 ND2S $T=292020 396600 1 0 $X=292020 $Y=391180
X973 819 818 69 2 1 ND2S $T=295120 326040 1 180 $X=293260 $Y=325660
X974 819 810 30 2 1 ND2S $T=295120 336120 1 180 $X=293260 $Y=335740
X975 798 824 816 2 1 ND2S $T=299460 386520 1 180 $X=297600 $Y=386140
X976 819 844 43 2 1 ND2S $T=310000 336120 1 180 $X=308140 $Y=335740
X977 819 866 39 2 1 ND2S $T=319920 336120 1 180 $X=318060 $Y=335740
X978 88 891 53 2 1 ND2S $T=330460 376440 0 180 $X=328600 $Y=371020
X979 69 67 109 2 1 ND2S $T=358360 326040 1 0 $X=358360 $Y=320620
X980 951 950 112 2 1 ND2S $T=364560 346200 1 180 $X=362700 $Y=345820
X981 951 954 109 2 1 ND2S $T=367040 336120 1 180 $X=365180 $Y=335740
X982 951 959 115 2 1 ND2S $T=367040 346200 0 0 $X=367040 $Y=345820
X983 939 944 960 2 1 ND2S $T=367660 336120 1 0 $X=367660 $Y=330700
X984 951 964 118 2 1 ND2S $T=370140 336120 0 0 $X=370140 $Y=335740
X985 951 972 122 2 1 ND2S $T=373240 336120 1 0 $X=373240 $Y=330700
X986 951 967 126 2 1 ND2S $T=376340 336120 0 0 $X=376340 $Y=335740
X987 1007 1001 126 2 1 ND2S $T=395560 326040 1 180 $X=393700 $Y=325660
X988 998 1012 1018 2 1 ND2S $T=397420 406680 1 0 $X=397420 $Y=401260
X989 998 1006 1007 2 1 ND2S $T=400520 386520 0 0 $X=400520 $Y=386140
X990 1026 1030 1011 2 1 ND2S $T=404860 376440 0 180 $X=403000 $Y=371020
X991 154 1034 153 2 1 ND2S $T=407960 406680 1 180 $X=406100 $Y=406300
X992 112 160 122 2 1 ND2S $T=417880 326040 1 0 $X=417880 $Y=320620
X993 1007 1056 118 2 1 ND2S $T=419740 326040 1 180 $X=417880 $Y=325660
X994 1043 1063 1077 2 1 ND2S $T=426560 386520 1 0 $X=426560 $Y=381100
X995 170 1081 1064 2 1 ND2S $T=432140 396600 0 180 $X=430280 $Y=391180
X996 1081 1084 1077 2 1 ND2S $T=435860 386520 0 0 $X=435860 $Y=386140
X997 1092 1109 1099 2 1 ND2S $T=443300 396600 0 180 $X=441440 $Y=391180
X998 1109 1111 1077 2 1 ND2S $T=447640 396600 1 0 $X=447640 $Y=391180
X999 1125 1124 1121 2 1 ND2S $T=455080 386520 1 180 $X=453220 $Y=386140
X1000 1128 1132 1007 2 1 ND2S $T=455700 326040 1 180 $X=453840 $Y=325660
X1001 1128 1119 960 2 1 ND2S $T=455700 336120 1 180 $X=453840 $Y=335740
X1002 1124 1143 1077 2 1 ND2S $T=466860 386520 1 0 $X=466860 $Y=381100
X1003 1128 1176 122 2 1 ND2S $T=473060 336120 1 180 $X=471200 $Y=335740
X1004 1165 1169 1077 2 1 ND2S $T=473060 386520 0 180 $X=471200 $Y=381100
X1005 1147 1165 1158 2 1 ND2S $T=473060 386520 1 180 $X=471200 $Y=386140
X1006 1186 1199 1181 2 1 ND2S $T=482360 396600 0 180 $X=480500 $Y=391180
X1007 1128 1205 126 2 1 ND2S $T=488560 336120 0 180 $X=486700 $Y=330700
X1008 1199 1204 1077 2 1 ND2S $T=487320 396600 1 0 $X=487320 $Y=391180
X1009 1218 1229 1201 2 1 ND2S $T=497240 396600 1 180 $X=495380 $Y=396220
X1010 198 1207 229 2 1 ND2S $T=495380 406680 0 0 $X=495380 $Y=406300
X1011 1229 1232 1239 2 1 ND2S $T=504680 396600 1 0 $X=504680 $Y=391180
X1012 227 1250 109 2 1 ND2S $T=507160 326040 0 0 $X=507160 $Y=325660
X1013 1271 1270 1239 2 1 ND2S $T=520800 386520 0 180 $X=518940 $Y=381100
X1014 245 1257 249 2 1 ND2S $T=518940 406680 0 0 $X=518940 $Y=406300
X1015 253 1291 1280 2 1 ND2S $T=527000 386520 1 180 $X=525140 $Y=386140
X1016 1291 1290 1239 2 1 ND2S $T=532580 386520 0 180 $X=530720 $Y=381100
X1017 1278 1287 1239 2 1 ND2S $T=532580 386520 1 180 $X=530720 $Y=386140
X1018 262 255 1304 2 1 ND2S $T=536920 396600 0 0 $X=536920 $Y=396220
X1019 1339 1343 1334 2 1 ND2S $T=551800 366360 1 180 $X=549940 $Y=365980
X1020 1366 1376 1336 2 1 ND2S $T=576600 386520 0 180 $X=574740 $Y=381100
X1021 1376 1389 1383 2 1 ND2S $T=580940 376440 0 0 $X=580940 $Y=376060
X1022 1364 1388 1392 2 1 ND2S $T=587140 366360 1 0 $X=587140 $Y=360940
X1023 1382 1397 305 2 1 ND2S $T=601400 356280 1 0 $X=601400 $Y=350860
X1024 1410 312 316 2 1 ND2S $T=603880 336120 1 180 $X=602020 $Y=335740
X1025 327 1427 325 2 1 ND2S $T=609460 326040 0 180 $X=607600 $Y=320620
X1026 326 308 1410 2 1 ND2S $T=607600 336120 0 0 $X=607600 $Y=335740
X1027 337 1431 329 2 1 ND2S $T=612560 366360 1 180 $X=610700 $Y=365980
X1028 337 1440 339 2 1 ND2S $T=616280 346200 1 0 $X=616280 $Y=340780
X1029 337 1452 341 2 1 ND2S $T=618140 326040 1 0 $X=618140 $Y=320620
X1030 342 1453 329 2 1 ND2S $T=619380 356280 0 0 $X=619380 $Y=355900
X1031 342 1443 346 2 1 ND2S $T=619380 396600 1 0 $X=619380 $Y=391180
X1032 352 1448 1463 2 1 ND2S $T=627440 376440 0 180 $X=625580 $Y=371020
X1033 371 1457 1495 2 1 ND2S $T=643560 376440 1 0 $X=643560 $Y=371020
X1034 352 1513 345 2 1 ND2S $T=652240 376440 1 0 $X=652240 $Y=371020
X1035 1466 1518 341 2 1 ND2S $T=652860 356280 0 0 $X=652860 $Y=355900
X1036 1495 1527 1530 2 1 ND2S $T=660920 336120 0 0 $X=660920 $Y=335740
X1037 1528 1541 329 2 1 ND2S $T=662780 366360 0 180 $X=660920 $Y=360940
X1038 1530 1534 329 2 1 ND2S $T=662780 376440 0 180 $X=660920 $Y=371020
X1039 1432 1531 388 2 1 ND2S $T=662780 406680 1 180 $X=660920 $Y=406300
X1040 1528 1537 346 2 1 ND2S $T=663400 336120 0 180 $X=661540 $Y=330700
X1041 1528 1538 1533 2 1 ND2S $T=665880 346200 0 180 $X=664020 $Y=340780
X1042 1530 1546 1533 2 1 ND2S $T=665880 366360 0 180 $X=664020 $Y=360940
X1043 1560 394 346 2 1 ND2S $T=668980 326040 1 180 $X=667120 $Y=325660
X1044 1528 390 1495 2 1 ND2S $T=667120 336120 1 0 $X=667120 $Y=330700
X1045 1424 1554 1551 2 1 ND2S $T=667120 406680 1 0 $X=667120 $Y=401260
X1046 346 1553 1530 2 1 ND2S $T=669600 346200 0 180 $X=667740 $Y=340780
X1047 349 1577 388 2 1 ND2S $T=676420 386520 0 0 $X=676420 $Y=386140
X1048 1653 1629 1560 2 1 ND2S $T=704940 336120 0 180 $X=703080 $Y=330700
X1049 397 1642 1610 2 1 ND2S $T=710520 376440 1 180 $X=708660 $Y=376060
X1050 445 1659 444 2 1 ND2S $T=719200 376440 0 180 $X=717340 $Y=371020
X1051 1653 1671 412 2 1 ND2S $T=717960 336120 1 0 $X=717960 $Y=330700
X1052 452 1665 1610 2 1 ND2S $T=719820 376440 1 180 $X=717960 $Y=376060
X1053 397 1675 451 2 1 ND2S $T=723540 396600 0 0 $X=723540 $Y=396220
X1054 1690 1681 441 2 1 ND2S $T=728500 336120 1 180 $X=726640 $Y=335740
X1055 1495 454 1679 2 1 ND2S $T=726640 346200 1 0 $X=726640 $Y=340780
X1056 452 1695 1551 2 1 ND2S $T=728500 396600 1 180 $X=726640 $Y=396220
X1057 445 1685 1610 2 1 ND2S $T=727260 366360 0 0 $X=727260 $Y=365980
X1058 455 1701 412 2 1 ND2S $T=732220 386520 0 0 $X=732220 $Y=386140
X1059 458 1700 444 2 1 ND2S $T=735320 366360 0 0 $X=735320 $Y=365980
X1060 458 1702 460 2 1 ND2S $T=735320 406680 1 0 $X=735320 $Y=401260
X1061 455 1705 1610 2 1 ND2S $T=737800 376440 0 180 $X=735940 $Y=371020
X1062 455 1709 460 2 1 ND2S $T=738420 406680 1 0 $X=738420 $Y=401260
X1063 477 476 475 2 1 ND2S $T=764460 326040 0 180 $X=762600 $Y=320620
X1064 479 1755 484 2 1 ND2S $T=772520 336120 0 180 $X=770660 $Y=330700
X1065 475 1757 486 2 1 ND2S $T=772520 336120 1 180 $X=770660 $Y=335740
X1066 475 1751 484 2 1 ND2S $T=772520 346200 1 180 $X=770660 $Y=345820
X1067 479 1753 467 2 1 ND2S $T=774380 356280 1 0 $X=774380 $Y=350860
X1068 494 1765 1758 2 1 ND2S $T=778720 386520 1 180 $X=776860 $Y=386140
X1069 494 1785 1781 2 1 ND2S $T=788020 396600 0 180 $X=786160 $Y=391180
X1070 467 1803 1796 2 1 ND2S $T=796700 386520 0 180 $X=794840 $Y=381100
X1071 1809 1806 475 2 1 ND2S $T=802280 346200 0 180 $X=800420 $Y=340780
X1072 1815 1818 1781 2 1 ND2S $T=805380 366360 0 180 $X=803520 $Y=360940
X1073 1815 1811 479 2 1 ND2S $T=806000 346200 0 180 $X=804140 $Y=340780
X1074 524 1823 1758 2 1 ND2S $T=808480 406680 0 180 $X=806620 $Y=401260
X1075 526 1824 1821 2 1 ND2S $T=810960 376440 0 180 $X=809100 $Y=371020
X1076 1815 1838 1758 2 1 ND2S $T=811580 346200 0 180 $X=809720 $Y=340780
X1077 1809 1839 528 2 1 ND2S $T=809720 396600 0 0 $X=809720 $Y=396220
X1078 526 1844 1781 2 1 ND2S $T=814060 396600 0 180 $X=812200 $Y=391180
X1079 1830 1827 1816 2 1 ND2S $T=814680 376440 0 180 $X=812820 $Y=371020
X1080 529 1842 460 2 1 ND2S $T=815300 406680 0 0 $X=815300 $Y=406300
X1081 1830 1859 1821 2 1 ND2S $T=818400 366360 0 0 $X=818400 $Y=365980
X1082 538 1850 1821 2 1 ND2S $T=818400 376440 1 0 $X=818400 $Y=371020
X1083 534 1853 1758 2 1 ND2S $T=820260 406680 1 180 $X=818400 $Y=406300
X1084 1860 1864 1816 2 1 ND2S $T=822740 346200 1 180 $X=820880 $Y=345820
X1085 529 1851 1816 2 1 ND2S $T=829560 366360 0 180 $X=827700 $Y=360940
X1086 477 552 528 2 1 ND2S $T=844440 326040 1 180 $X=842580 $Y=325660
X1087 1983 1988 1974 2 1 ND2S $T=888460 346200 1 180 $X=886600 $Y=345820
X1088 2012 1996 2003 2 1 ND2S $T=894660 366360 1 0 $X=894660 $Y=360940
X1089 589 2034 590 2 1 ND2S $T=908300 326040 0 180 $X=906440 $Y=320620
X1090 515 2031 590 2 1 ND2S $T=908300 336120 0 180 $X=906440 $Y=330700
X1091 2024 2033 1975 2 1 ND2S $T=910780 386520 0 0 $X=910780 $Y=386140
X1092 594 2045 588 2 1 ND2S $T=918220 336120 0 180 $X=916360 $Y=330700
X1093 2010 603 2035 2 1 ND2S $T=918220 406680 0 180 $X=916360 $Y=401260
X1094 2024 2048 586 2 1 ND2S $T=922560 386520 1 0 $X=922560 $Y=381100
X1095 2028 2073 2050 2 1 ND2S $T=926900 406680 1 180 $X=925040 $Y=406300
X1096 2071 2076 484 2 1 ND2S $T=930620 326040 1 180 $X=928760 $Y=325660
X1097 515 2087 588 2 1 ND2S $T=936200 346200 1 180 $X=934340 $Y=345820
X1098 615 2095 588 2 1 ND2S $T=946740 356280 0 180 $X=944880 $Y=350860
X1099 1456 548 1980 2 1 XOR2HS $T=883500 396600 1 0 $X=883500 $Y=391180
X1100 602 2043 2039 2 1 XOR2HS $T=915740 366360 0 0 $X=915740 $Y=365980
X1101 1767 2117 2134 2 1 XOR2HS $T=964720 366360 0 0 $X=964720 $Y=365980
X1102 249 264 1324 2 1 XNR2HS $T=555520 406680 1 180 $X=549940 $Y=406300
X1103 1415 1421 1401 2 1 XNR2HS $T=604500 396600 1 0 $X=604500 $Y=391180
X1104 696 692 2 1 702 9 MUX2 $T=221340 396600 0 0 $X=221340 $Y=396220
X1105 10 11 2 1 695 698 MUX2 $T=226300 336120 0 180 $X=221960 $Y=330700
X1106 703 700 2 1 697 696 MUX2 $T=226920 366360 1 180 $X=222580 $Y=365980
X1107 704 11 2 1 708 711 MUX2 $T=227540 336120 0 0 $X=227540 $Y=335740
X1108 17 700 2 1 710 709 MUX2 $T=235600 356280 1 180 $X=231260 $Y=355900
X1109 22 11 2 1 16 704 MUX2 $T=241800 326040 0 180 $X=237460 $Y=320620
X1110 721 700 2 1 734 720 MUX2 $T=238080 366360 1 0 $X=238080 $Y=360940
X1111 717 18 2 1 729 21 MUX2 $T=238080 396600 1 0 $X=238080 $Y=391180
X1112 732 11 2 1 726 721 MUX2 $T=247380 346200 0 180 $X=243040 $Y=340780
X1113 745 692 2 1 725 717 MUX2 $T=256060 386520 1 180 $X=251720 $Y=386140
X1114 752 749 2 1 736 737 MUX2 $T=257920 356280 0 180 $X=253580 $Y=350860
X1115 740 770 2 1 761 760 MUX2 $T=268460 366360 1 180 $X=264120 $Y=365980
X1116 757 749 2 1 774 752 MUX2 $T=264740 346200 0 0 $X=264740 $Y=345820
X1117 768 770 2 1 755 740 MUX2 $T=269080 366360 0 180 $X=264740 $Y=360940
X1118 764 741 2 1 782 778 MUX2 $T=270320 386520 1 0 $X=270320 $Y=381100
X1119 808 741 2 1 787 764 MUX2 $T=282720 386520 0 180 $X=278380 $Y=381100
X1120 1087 1094 2 1 1105 1079 MUX2 $T=442060 376440 1 0 $X=442060 $Y=371020
X1121 1123 1122 2 1 1136 1094 MUX2 $T=454460 376440 1 0 $X=454460 $Y=371020
X1122 1131 1123 2 1 1141 1108 MUX2 $T=456320 376440 0 0 $X=456320 $Y=376060
X1123 1141 1122 2 1 1151 1105 MUX2 $T=461900 376440 0 0 $X=461900 $Y=376060
X1124 1194 1200 2 1 1180 1173 MUX2 $T=482980 376440 1 180 $X=478640 $Y=376060
X1125 1217 1214 2 1 1196 1136 MUX2 $T=490420 376440 0 180 $X=486080 $Y=371020
X1126 1227 1216 2 1 1217 1200 MUX2 $T=497860 376440 1 180 $X=493520 $Y=376060
X1127 1216 1214 2 1 1222 1122 MUX2 $T=501580 376440 0 180 $X=497240 $Y=371020
X1128 1244 1227 2 1 1235 1225 MUX2 $T=505920 376440 1 180 $X=501580 $Y=376060
X1129 1235 1216 2 1 1247 1180 MUX2 $T=504060 376440 1 0 $X=504060 $Y=371020
X1130 1247 1214 2 1 1260 1151 MUX2 $T=512120 376440 0 0 $X=512120 $Y=376060
X1131 1305 1307 2 1 1317 1313 MUX2 $T=539400 376440 0 0 $X=539400 $Y=376060
X1132 1292 1307 2 1 1319 1318 MUX2 $T=540020 376440 1 0 $X=540020 $Y=371020
X1133 1319 1327 2 1 1312 1196 MUX2 $T=545600 366360 1 180 $X=541260 $Y=365980
X1134 1283 1318 2 1 1313 1310 MUX2 $T=545600 386520 0 180 $X=541260 $Y=381100
X1135 1317 1336 2 1 1320 1260 MUX2 $T=548700 376440 0 180 $X=544360 $Y=371020
X1136 1307 1327 2 1 1321 1222 MUX2 $T=548700 376440 1 180 $X=544360 $Y=376060
X1137 998 141 1 2 142 AN2 $T=396180 406680 0 180 $X=393700 $Y=401260
X1138 1032 1031 1 2 1039 AN2 $T=407340 356280 1 0 $X=407340 $Y=350860
X1139 1073 1085 1 2 1101 AN2 $T=441440 346200 0 0 $X=441440 $Y=345820
X1140 1135 1142 1 2 1177 AN2 $T=473680 346200 0 0 $X=473680 $Y=345820
X1141 1195 1208 1 2 1237 AN2 $T=500960 346200 0 0 $X=500960 $Y=345820
X1142 1288 257 1 2 1293 AN2 $T=530100 366360 1 0 $X=530100 $Y=360940
X1143 1615 415 1 2 1619 AN2 $T=698740 406680 0 0 $X=698740 $Y=406300
X1144 1968 1974 1 2 1986 AN2 $T=885980 336120 0 0 $X=885980 $Y=335740
X1145 1558 1531 2 1588 1 409 AOI12HS $T=685720 406680 0 0 $X=685720 $Y=406300
X1146 1028 152 1030 1 2 1037 OA12 $T=404240 376440 0 0 $X=404240 $Y=376060
X1147 1031 1032 1044 1 2 1050 OA12 $T=413540 356280 1 0 $X=413540 $Y=350860
X1148 1085 1073 1082 1 2 1093 OA12 $T=434620 346200 0 0 $X=434620 $Y=345820
X1149 1142 1135 1137 1 2 1161 OA12 $T=467480 346200 0 0 $X=467480 $Y=345820
X1150 224 1095 1210 1 2 1218 OA12 $T=489800 396600 0 0 $X=489800 $Y=396220
X1151 1208 1195 1190 1 2 1226 OA12 $T=494140 356280 0 0 $X=494140 $Y=355900
X1152 1252 1241 236 1 2 1243 OA12 $T=510880 396600 1 180 $X=507160 $Y=396220
X1153 247 1241 1272 1 2 1273 OA12 $T=518320 396600 0 0 $X=518320 $Y=396220
X1154 257 1288 1276 1 2 1296 OA12 $T=529480 366360 0 0 $X=529480 $Y=365980
X1155 1619 1620 420 1 2 1628 OA12 $T=698740 396600 0 0 $X=698740 $Y=396220
X1156 1998 1965 1991 1 2 1985 OA12 $T=893420 366360 0 180 $X=889700 $Y=360940
X1157 1986 1994 1991 1 2 1958 OA12 $T=894040 336120 1 180 $X=890320 $Y=335740
X1158 2049 2067 2096 1 2 2103 OA12 $T=947980 396600 1 0 $X=947980 $Y=391180
X1159 730 6 12 2 1 718 QDFFRBS $T=247380 406680 0 180 $X=235600 $Y=401260
X1160 916 82 104 2 1 939 QDFFRBS $T=345960 336120 0 0 $X=345960 $Y=335740
X1161 693 1 2 698 BUF1CK $T=220720 336120 0 0 $X=220720 $Y=335740
X1162 694 1 2 696 BUF1CK $T=221340 386520 0 0 $X=221340 $Y=386140
X1163 706 1 2 709 BUF1CK $T=228160 366360 0 0 $X=228160 $Y=365980
X1164 15 1 2 9 BUF1CK $T=231880 406680 0 0 $X=231880 $Y=406300
X1165 715 1 2 717 BUF1CK $T=232500 386520 0 0 $X=232500 $Y=386140
X1166 712 1 2 10 BUF1CK $T=233120 326040 1 0 $X=233120 $Y=320620
X1167 713 1 2 703 BUF1CK $T=233120 366360 1 0 $X=233120 $Y=360940
X1168 714 1 2 711 BUF1CK $T=233740 376440 0 0 $X=233740 $Y=376060
X1169 719 1 2 721 BUF1CK $T=236220 356280 1 0 $X=236220 $Y=350860
X1170 723 1 2 704 BUF1CK $T=240560 336120 1 0 $X=240560 $Y=330700
X1171 728 1 2 17 BUF1CK $T=248000 346200 0 0 $X=248000 $Y=345820
X1172 731 1 2 737 BUF1CK $T=250480 356280 1 0 $X=250480 $Y=350860
X1173 738 1 2 740 BUF1CK $T=251100 366360 0 0 $X=251100 $Y=365980
X1174 739 1 2 745 BUF1CK $T=251720 376440 0 0 $X=251720 $Y=376060
X1175 744 1 2 732 BUF1CK $T=254820 336120 1 0 $X=254820 $Y=330700
X1176 754 1 2 757 BUF1CK $T=259160 346200 1 0 $X=259160 $Y=340780
X1177 758 1 2 752 BUF1CK $T=262260 346200 0 0 $X=262260 $Y=345820
X1178 762 1 2 764 BUF1CK $T=263500 376440 0 0 $X=263500 $Y=376060
X1179 763 1 2 760 BUF1CK $T=265360 386520 1 0 $X=265360 $Y=381100
X1180 773 1 2 768 BUF1CK $T=272180 356280 1 0 $X=272180 $Y=350860
X1181 769 1 2 778 BUF1CK $T=272180 396600 1 0 $X=272180 $Y=391180
X1182 811 1 2 808 BUF1CK $T=291400 376440 0 0 $X=291400 $Y=376060
X1183 982 1 2 985 BUF1CK $T=380680 326040 0 0 $X=380680 $Y=325660
X1184 141 1 2 1005 BUF1CK $T=392460 396600 0 0 $X=392460 $Y=396220
X1185 1015 1 2 1019 BUF1CK $T=400520 366360 1 0 $X=400520 $Y=360940
X1186 1031 1 2 1041 BUF1CK $T=412920 366360 0 0 $X=412920 $Y=365980
X1187 1070 1 2 1074 BUF1CK $T=430280 366360 0 0 $X=430280 $Y=365980
X1188 1085 1 2 1115 BUF1CK $T=449500 356280 0 0 $X=449500 $Y=355900
X1189 1113 1 2 1130 BUF1CK $T=456940 356280 0 0 $X=456940 $Y=355900
X1190 1142 1 2 1152 BUF1CK $T=467480 356280 1 0 $X=467480 $Y=350860
X1191 1208 1 2 1206 BUF1CK $T=491040 356280 0 0 $X=491040 $Y=355900
X1192 1254 1 2 1281 BUF1CK $T=527000 366360 1 0 $X=527000 $Y=360940
X1193 1364 1 2 1374 BUF1CK $T=574740 366360 1 0 $X=574740 $Y=360940
X1194 1387 1 2 1384 BUF1CK $T=582800 356280 0 0 $X=582800 $Y=355900
X1195 1406 1 2 1404 BUF1CK $T=592100 356280 0 0 $X=592100 $Y=355900
X1196 1403 1 2 1413 BUF1CK $T=595820 346200 0 0 $X=595820 $Y=345820
X1197 1416 1 2 1420 BUF1CK $T=598300 366360 0 0 $X=598300 $Y=365980
X1198 1422 1 2 1426 BUF1CK $T=605120 336120 1 0 $X=605120 $Y=330700
X1199 44 783 1 791 2 OR2B1S $T=275280 406680 1 0 $X=275280 $Y=401260
X1200 1298 1297 1 1300 2 OR2B1S $T=535680 386520 0 0 $X=535680 $Y=386140
X1201 1410 311 1 1394 2 OR2B1S $T=589620 326040 1 180 $X=586520 $Y=325660
X1202 101 906 902 1 2 ND2 $T=342240 396600 1 180 $X=340380 $Y=396220
X1203 906 918 911 1 2 ND2 $T=344720 406680 1 0 $X=344720 $Y=401260
X1204 122 1029 126 1 2 ND2 $T=406100 336120 1 0 $X=406100 $Y=330700
X1205 112 176 118 1 2 ND2 $T=435860 326040 1 0 $X=435860 $Y=320620
X1206 1243 1271 1255 1 2 ND2 $T=515840 386520 0 180 $X=513980 $Y=381100
X1207 1273 1278 1265 1 2 ND2 $T=523900 386520 1 180 $X=522040 $Y=386140
X1208 272 1333 275 1 2 ND2 $T=548700 326040 1 0 $X=548700 $Y=320620
X1209 280 1339 1345 1 2 ND2 $T=560480 366360 1 0 $X=560480 $Y=360940
X1210 1366 1375 1377 1 2 ND2 $T=575360 386520 0 0 $X=575360 $Y=386140
X1211 1398 1415 1409 1 2 ND2 $T=593960 386520 0 180 $X=592100 $Y=381100
X1212 1466 1445 345 1 2 ND2 $T=626820 336120 0 180 $X=624960 $Y=330700
X1213 345 1536 382 1 2 ND2 $T=657200 396600 1 180 $X=655340 $Y=396220
X1214 1535 1529 349 1 2 ND2 $T=662780 376440 1 180 $X=660920 $Y=376060
X1215 1551 1543 341 1 2 ND2 $T=668980 386520 1 180 $X=667120 $Y=386140
X1216 1424 1558 391 1 2 ND2 $T=668980 406680 1 180 $X=667120 $Y=406300
X1217 341 1562 1566 1 2 ND2 $T=672700 406680 1 0 $X=672700 $Y=401260
X1218 1653 1645 441 1 2 ND2 $T=715480 326040 1 180 $X=713620 $Y=325660
X1219 455 1691 444 1 2 ND2 $T=732220 376440 1 0 $X=732220 $Y=371020
X1220 498 1772 444 1 2 ND2 $T=781820 406680 1 180 $X=779960 $Y=406300
X1221 1781 1763 498 1 2 ND2 $T=786160 386520 0 0 $X=786160 $Y=386140
X1222 498 513 1796 1 2 ND2 $T=796700 406680 0 0 $X=796700 $Y=406300
X1223 538 1867 1816 1 2 ND2 $T=825840 376440 0 180 $X=823980 $Y=371020
X1224 101 902 1 918 2 111 OAI12HS $T=346580 406680 1 0 $X=346580 $Y=401260
X1225 998 138 1 135 2 995 OAI12HS $T=392460 406680 0 180 $X=388740 $Y=401260
X1226 227 1219 1 115 2 1215 OAI12HS $T=500340 326040 0 0 $X=500340 $Y=325660
X1227 248 1264 1 1269 2 1276 OAI12HS $T=526380 346200 1 180 $X=522660 $Y=345820
X1228 2132 2107 1 2127 2 634 OAI12HS $T=972160 386520 0 180 $X=968440 $Y=381100
X1229 985 1 119 132 976 130 2 OAI22S $T=386880 326040 1 180 $X=383160 $Y=325660
X1230 986 1 134 986 975 991 2 OAI22S $T=385640 346200 0 0 $X=385640 $Y=345820
X1231 999 1 135 831 993 990 2 OAI22S $T=391840 396600 0 180 $X=388120 $Y=391180
X1232 213 1 159 143 1175 207 2 OAI22S $T=479880 326040 0 180 $X=476160 $Y=320620
X1233 251 1 282 1350 1353 273 2 OAI22S $T=557380 336120 1 0 $X=557380 $Y=330700
X1234 284 1 214 286 287 290 2 OAI22S $T=558000 406680 0 0 $X=558000 $Y=406300
X1235 247 1 282 1325 1354 273 2 OAI22S $T=564820 346200 0 180 $X=561100 $Y=340780
X1236 1361 1 299 286 300 1372 2 OAI22S $T=572260 396600 0 0 $X=572260 $Y=396220
X1237 1361 1 1372 286 304 1360 2 OAI22S $T=577840 406680 0 0 $X=577840 $Y=406300
X1238 1372 1 295 307 1385 1360 2 OAI22S $T=585280 406680 0 180 $X=581560 $Y=401260
X1239 299 1 295 307 1391 1372 2 OAI22S $T=587760 406680 1 180 $X=584040 $Y=406300
X1240 1420 1 1418 1368 1421 1375 2 OAI22S $T=604500 386520 0 180 $X=600780 $Y=381100
X1241 1397 1 1399 1382 1423 1421 2 OAI22S $T=601400 376440 1 0 $X=601400 $Y=371020
X1242 1444 1 1445 1444 1451 1452 2 OAI22S $T=615660 326040 0 0 $X=615660 $Y=325660
X1243 1442 1 1448 1442 1446 1457 2 OAI22S $T=616280 376440 1 0 $X=616280 $Y=371020
X1244 1512 1 1513 1512 1514 1518 2 OAI22S $T=646660 356280 0 0 $X=646660 $Y=355900
X1245 389 1 1527 389 1545 1537 2 OAI22S $T=669600 326040 0 180 $X=665880 $Y=320620
X1246 1556 1 1546 1556 1555 1541 2 OAI22S $T=673320 356280 1 180 $X=669600 $Y=355900
X1247 1557 1 1553 1557 1559 1538 2 OAI22S $T=675800 336120 1 180 $X=672080 $Y=335740
X1248 1549 1 1562 1549 1575 1554 2 OAI22S $T=680760 396600 1 180 $X=677040 $Y=396220
X1249 438 1 1645 438 437 1642 2 OAI22S $T=713000 326040 0 180 $X=709280 $Y=320620
X1250 1663 1 1665 1663 1660 1659 2 OAI22S $T=721680 366360 1 180 $X=717960 $Y=365980
X1251 1697 1 1685 1697 1694 1691 2 OAI22S $T=735320 366360 0 180 $X=731600 $Y=360940
X1252 1686 1 1695 1686 1698 1675 2 OAI22S $T=735940 396600 0 180 $X=732220 $Y=391180
X1253 1764 1 1757 1764 1766 1755 2 OAI22S $T=783060 336120 1 180 $X=779340 $Y=335740
X1254 1780 1 1772 1780 1788 1785 2 OAI22S $T=785540 406680 0 0 $X=785540 $Y=406300
X1255 1817 1 1811 1817 1814 1806 2 OAI22S $T=807860 336120 1 180 $X=804140 $Y=335740
X1256 1831 1 1824 1831 1837 1827 2 OAI22S $T=811580 376440 0 0 $X=811580 $Y=376060
X1257 1846 1 1844 1846 1845 1839 2 OAI22S $T=819640 386520 1 180 $X=815920 $Y=386140
X1258 1865 1 1859 1865 1879 1867 2 OAI22S $T=835140 366360 0 180 $X=831420 $Y=360940
X1259 1976 1 1978 1976 1979 1985 2 OAI22S $T=885360 366360 0 0 $X=885360 $Y=365980
X1260 1987 1 2007 1987 1977 2006 2 OAI22S $T=895900 386520 1 0 $X=895900 $Y=381100
X1261 619 1 2084 619 621 2081 2 OAI22S $T=943640 406680 0 180 $X=939920 $Y=401260
X1262 2109 1 2070 2109 2112 1998 2 OAI22S $T=959760 356280 1 180 $X=956040 $Y=355900
X1263 1500 359 1495 1454 1 2 1488 AO13S $T=641700 376440 0 180 $X=637360 $Y=371020
X1264 1677 415 1679 1669 1 2 1682 AO13S $T=725400 386520 0 0 $X=725400 $Y=386140
X1265 1880 1881 528 1835 1 2 1894 AO13S $T=831420 386520 0 0 $X=831420 $Y=386140
X1266 788 799 52 798 1 771 2 AOI22S $T=286440 396600 0 180 $X=282720 $Y=391180
X1267 1008 139 147 142 1 1007 2 AOI22S $T=399280 406680 0 0 $X=399280 $Y=406300
X1268 139 1051 1042 162 1 1054 2 AOI22S $T=416640 396600 0 0 $X=416640 $Y=396220
X1269 141 1051 1045 161 1 1054 2 AOI22S $T=416640 406680 0 0 $X=416640 $Y=406300
X1270 177 1051 174 172 1 1054 2 AOI22S $T=434000 406680 1 180 $X=430280 $Y=406300
X1271 179 1054 1088 165 1 181 2 AOI22S $T=437100 406680 0 0 $X=437100 $Y=406300
X1272 179 1054 1104 163 1 185 2 AOI22S $T=447020 406680 0 180 $X=443300 $Y=401260
X1273 204 198 1185 211 1 210 2 AOI22S $T=479880 406680 1 180 $X=476160 $Y=406300
X1274 359 1466 1454 1463 1 354 2 AOI22S $T=634260 376440 0 180 $X=630540 $Y=371020
X1275 415 445 1669 1551 1 451 2 AOI22S $T=722300 396600 1 0 $X=722300 $Y=391180
X1276 1828 1830 1835 1781 1 1679 2 AOI22S $T=812200 386520 1 180 $X=808480 $Y=386140
X1277 1974 2013 2007 584 1 2017 2 AOI22S $T=897760 356280 0 0 $X=897760 $Y=355900
X1278 2003 1993 2006 2015 1 2022 2 AOI22S $T=897760 366360 0 0 $X=897760 $Y=365980
X1279 1974 2013 1978 2026 1 2023 2 AOI22S $T=902720 356280 1 0 $X=902720 $Y=350860
X1280 584 1762 2021 2000 1 2009 2 AOI22S $T=903340 376440 0 0 $X=903340 $Y=376060
X1281 2003 1993 2018 2022 1 2032 2 AOI22S $T=904580 376440 1 0 $X=904580 $Y=371020
X1282 2011 2013 2020 591 1 2030 2 AOI22S $T=905200 346200 1 0 $X=905200 $Y=340780
X1283 1975 1971 593 2027 1 1980 2 AOI22S $T=908920 396600 0 180 $X=905200 $Y=391180
X1284 2003 1993 596 2032 1 2039 2 AOI22S $T=910780 366360 0 0 $X=910780 $Y=365980
X1285 1975 1971 600 1980 1 2038 2 AOI22S $T=915740 396600 1 180 $X=912020 $Y=396220
X1286 2003 1993 2046 2039 1 2051 2 AOI22S $T=917600 376440 1 0 $X=917600 $Y=371020
X1287 2011 2013 2042 607 1 2053 2 AOI22S $T=919460 336120 0 0 $X=919460 $Y=335740
X1288 2003 1993 2054 2051 1 2058 2 AOI22S $T=927520 376440 0 180 $X=923800 $Y=371020
X1289 2067 2049 2062 2038 1 2060 2 AOI22S $T=928760 396600 0 180 $X=925040 $Y=391180
X1290 586 2014 2069 2057 1 2044 2 AOI22S $T=931860 386520 0 180 $X=928140 $Y=381100
X1291 2067 2049 2078 2060 1 2085 2 AOI22S $T=933100 396600 1 0 $X=933100 $Y=391180
X1292 2052 515 2086 2000 1 2068 2 AOI22S $T=938060 376440 1 180 $X=934340 $Y=376060
X1293 2067 2049 2093 2085 1 2088 2 AOI22S $T=943020 396600 1 180 $X=939300 $Y=396220
X1294 2067 2049 2101 2088 1 2094 2 AOI22S $T=946740 386520 1 180 $X=943020 $Y=386140
X1295 2067 2049 2097 2094 1 2096 2 AOI22S $T=947360 396600 0 180 $X=943640 $Y=391180
X1296 2107 2014 2110 2021 1 2115 2 AOI22S $T=953560 386520 1 0 $X=953560 $Y=381100
X1297 2107 2014 2120 2115 1 2126 2 AOI22S $T=960380 376440 0 0 $X=960380 $Y=376060
X1298 2107 2132 2131 2126 1 2134 2 AOI22S $T=965340 376440 1 0 $X=965340 $Y=371020
X1299 2107 2132 2133 2134 1 2086 2 AOI22S $T=972780 376440 1 0 $X=972780 $Y=371020
X1300 2132 2107 639 2127 1 2086 2 AOI22S $T=974640 386520 1 0 $X=974640 $Y=381100
X1301 62 40 1 2 BUF2 $T=291400 356280 1 0 $X=291400 $Y=350860
X1302 83 896 1 2 BUF2 $T=334800 346200 1 0 $X=334800 $Y=340780
X1303 62 200 1 2 BUF2 $T=461280 326040 0 0 $X=461280 $Y=325660
X1304 1610 475 1 2 BUF2 $T=755780 386520 1 0 $X=755780 $Y=381100
X1305 479 1816 1 2 BUF2 $T=802900 346200 0 0 $X=802900 $Y=345820
X1306 59 47 1 2 INV2 $T=287060 346200 0 0 $X=287060 $Y=345820
X1307 88 90 1 2 INV2 $T=350920 376440 0 0 $X=350920 $Y=376060
X1308 127 121 1 2 INV2 $T=381300 326040 0 180 $X=379440 $Y=320620
X1309 129 127 1 2 INV2 $T=381300 346200 1 180 $X=379440 $Y=345820
X1310 127 960 1 2 INV2 $T=388740 326040 0 0 $X=388740 $Y=325660
X1311 91 1009 1 2 INV2 $T=392460 356280 0 0 $X=392460 $Y=355900
X1312 59 143 1 2 INV2 $T=393700 346200 1 0 $X=393700 $Y=340780
X1313 95 150 1 2 INV2 $T=403620 326040 1 0 $X=403620 $Y=320620
X1314 1009 155 1 2 INV2 $T=408580 326040 0 0 $X=408580 $Y=325660
X1315 90 1128 1 2 INV2 $T=455700 326040 1 0 $X=455700 $Y=320620
X1316 292 286 1 2 INV2 $T=562960 406680 0 180 $X=561100 $Y=401260
X1317 371 375 1 2 INV2 $T=652860 336120 0 0 $X=652860 $Y=335740
X1318 345 343 1 2 INV2 $T=656580 346200 1 0 $X=656580 $Y=340780
X1319 391 1540 1 2 INV2 $T=665880 406680 0 180 $X=664020 $Y=401260
X1320 1587 436 1 2 INV2 $T=709900 366360 0 0 $X=709900 $Y=365980
X1321 1540 441 1 2 INV2 $T=714240 336120 1 180 $X=712380 $Y=335740
X1322 475 1810 1 2 INV2 $T=799800 386520 1 0 $X=799800 $Y=381100
X1323 510 1809 1 2 INV2 $T=801040 376440 0 0 $X=801040 $Y=376060
X1324 1456 579 1 2 INV2 $T=893420 346200 1 0 $X=893420 $Y=340780
X1325 700 698 1 700 8 707 2 MOAI1S $T=223200 356280 0 0 $X=223200 $Y=355900
X1326 692 711 1 692 13 699 2 MOAI1S $T=233120 386520 0 180 $X=229400 $Y=381100
X1327 722 709 1 722 19 724 2 MOAI1S $T=238700 376440 0 0 $X=238700 $Y=376060
X1328 18 720 1 18 20 730 2 MOAI1S $T=239320 406680 0 0 $X=239320 $Y=406300
X1329 23 22 1 23 25 727 2 MOAI1S $T=247380 326040 1 0 $X=247380 $Y=320620
X1330 31 732 1 31 747 748 2 MOAI1S $T=254820 346200 1 0 $X=254820 $Y=340780
X1331 749 737 1 749 29 753 2 MOAI1S $T=257920 366360 0 0 $X=257920 $Y=365980
X1332 741 760 1 741 37 742 2 MOAI1S $T=267840 386520 1 180 $X=264120 $Y=386140
X1333 24 745 1 24 776 775 2 MOAI1S $T=270940 366360 1 0 $X=270940 $Y=360940
X1334 741 778 1 741 49 790 2 MOAI1S $T=273420 396600 0 0 $X=273420 $Y=396220
X1335 789 51 1 789 51 786 2 MOAI1S $T=282720 326040 0 180 $X=279000 $Y=320620
X1336 52 791 1 52 791 56 2 MOAI1S $T=282100 406680 1 0 $X=282100 $Y=401260
X1337 54 786 1 54 786 809 2 MOAI1S $T=285820 326040 0 0 $X=285820 $Y=325660
X1338 807 804 1 807 804 806 2 MOAI1S $T=291400 376440 0 180 $X=287680 $Y=371020
X1339 792 806 1 792 806 831 2 MOAI1S $T=289540 386520 1 0 $X=289540 $Y=381100
X1340 799 824 1 799 824 72 2 MOAI1S $T=298840 396600 1 0 $X=298840 $Y=391180
X1341 840 834 1 840 834 838 2 MOAI1S $T=308140 376440 1 180 $X=304420 $Y=376060
X1342 828 838 1 828 838 843 2 MOAI1S $T=304420 386520 0 0 $X=304420 $Y=386140
X1343 825 839 1 825 839 869 2 MOAI1S $T=313100 396600 0 0 $X=313100 $Y=396220
X1344 854 855 1 854 855 857 2 MOAI1S $T=314340 386520 0 0 $X=314340 $Y=386140
X1345 822 857 1 822 857 874 2 MOAI1S $T=314960 396600 1 0 $X=314960 $Y=391180
X1346 75 869 1 75 869 85 2 MOAI1S $T=323020 396600 0 0 $X=323020 $Y=396220
X1347 876 703 1 876 875 867 2 MOAI1S $T=327980 356280 1 180 $X=324260 $Y=355900
X1348 871 873 1 871 873 879 2 MOAI1S $T=325500 386520 1 0 $X=325500 $Y=381100
X1349 865 879 1 865 879 890 2 MOAI1S $T=325500 396600 1 0 $X=325500 $Y=391180
X1350 888 887 1 888 887 886 2 MOAI1S $T=332940 386520 1 180 $X=329220 $Y=386140
X1351 893 885 1 893 885 887 2 MOAI1S $T=335420 396600 1 0 $X=335420 $Y=391180
X1352 63 89 1 63 89 97 2 MOAI1S $T=337280 406680 0 0 $X=337280 $Y=406300
X1353 876 808 1 876 914 910 2 MOAI1S $T=343480 376440 0 0 $X=343480 $Y=376060
X1354 911 902 1 911 902 105 2 MOAI1S $T=346580 406680 0 0 $X=346580 $Y=406300
X1355 876 768 1 876 934 916 2 MOAI1S $T=350920 346200 0 0 $X=350920 $Y=345820
X1356 31 757 1 103 94 942 2 MOAI1S $T=353400 326040 0 0 $X=353400 $Y=325660
X1357 110 944 1 110 944 915 2 MOAI1S $T=364560 326040 1 180 $X=360840 $Y=325660
X1358 961 890 1 119 962 978 2 MOAI1S $T=370140 386520 0 0 $X=370140 $Y=386140
X1359 961 886 1 119 116 958 2 MOAI1S $T=370760 396600 1 0 $X=370760 $Y=391180
X1360 961 874 1 119 974 973 2 MOAI1S $T=376960 396600 1 0 $X=376960 $Y=391180
X1361 984 983 1 984 983 928 2 MOAI1S $T=385020 336120 1 180 $X=381300 $Y=335740
X1362 961 843 1 119 989 992 2 MOAI1S $T=383160 386520 1 0 $X=383160 $Y=381100
X1363 140 134 1 130 809 136 2 MOAI1S $T=393080 326040 0 180 $X=389360 $Y=320620
X1364 1002 1001 1 1002 1001 1000 2 MOAI1S $T=396800 336120 1 180 $X=393080 $Y=335740
X1365 1004 1006 1 1004 1006 145 2 MOAI1S $T=394320 386520 0 0 $X=394320 $Y=386140
X1366 995 1005 1 990 1012 1022 2 MOAI1S $T=394940 396600 0 0 $X=394940 $Y=396220
X1367 1014 1019 1 1013 130 987 2 MOAI1S $T=400520 366360 0 180 $X=396800 $Y=360940
X1368 140 1011 1 1016 990 1021 2 MOAI1S $T=396800 386520 1 0 $X=396800 $Y=381100
X1369 1015 1023 1 1033 1037 1044 2 MOAI1S $T=409820 366360 1 0 $X=409820 $Y=360940
X1370 1029 1038 1 1029 1038 1052 2 MOAI1S $T=413540 336120 1 0 $X=413540 $Y=330700
X1371 1014 1041 1 1047 990 1046 2 MOAI1S $T=419120 366360 1 180 $X=415400 $Y=365980
X1372 1058 1063 1 1058 1063 1079 2 MOAI1S $T=424700 376440 0 0 $X=424700 $Y=376060
X1373 1014 1074 1 1068 1060 1062 2 MOAI1S $T=430280 366360 1 180 $X=426560 $Y=365980
X1374 170 1071 1 170 1071 1067 2 MOAI1S $T=430900 386520 1 180 $X=427180 $Y=386140
X1375 1070 1057 1 1065 1055 1082 2 MOAI1S $T=427800 356280 1 0 $X=427800 $Y=350860
X1376 1080 1084 1 1080 1084 1087 2 MOAI1S $T=433380 386520 1 0 $X=433380 $Y=381100
X1377 1092 1098 1 1092 1098 1100 2 MOAI1S $T=440820 376440 0 0 $X=440820 $Y=376060
X1378 1014 1115 1 1106 1060 1102 2 MOAI1S $T=449500 356280 1 180 $X=445780 $Y=355900
X1379 1112 1111 1 1112 1111 1108 2 MOAI1S $T=450120 386520 1 180 $X=446400 $Y=386140
X1380 188 187 1 188 187 1107 2 MOAI1S $T=450740 326040 1 180 $X=447020 $Y=325660
X1381 1014 1130 1 1127 1060 1120 2 MOAI1S $T=456940 356280 1 180 $X=453220 $Y=355900
X1382 1125 1134 1 1125 1134 1140 2 MOAI1S $T=455700 396600 1 0 $X=455700 $Y=391180
X1383 1145 1143 1 1145 1143 1131 2 MOAI1S $T=463760 386520 0 180 $X=460040 $Y=381100
X1384 1113 1133 1 1139 1110 1137 2 MOAI1S $T=460660 346200 0 0 $X=460660 $Y=345820
X1385 118 126 1 143 202 1148 2 MOAI1S $T=467480 326040 0 180 $X=463760 $Y=320620
X1386 1150 1152 1 1153 1060 1159 2 MOAI1S $T=466860 366360 1 0 $X=466860 $Y=360940
X1387 1147 1174 1 1147 1174 1178 2 MOAI1S $T=474920 396600 0 0 $X=474920 $Y=396220
X1388 1172 1169 1 1172 1169 1173 2 MOAI1S $T=475540 386520 1 0 $X=475540 $Y=381100
X1389 1150 1182 1 1184 1168 1187 2 MOAI1S $T=479260 366360 1 0 $X=479260 $Y=360940
X1390 1186 1188 1 1186 1188 1193 2 MOAI1S $T=482360 386520 1 0 $X=482360 $Y=381100
X1391 1150 1206 1 1202 1168 1203 2 MOAI1S $T=491040 356280 1 180 $X=487320 $Y=355900
X1392 1191 1204 1 1191 1204 1194 2 MOAI1S $T=489180 386520 0 0 $X=489180 $Y=386140
X1393 1218 1212 1 1218 1212 1228 2 MOAI1S $T=494140 396600 1 0 $X=494140 $Y=391180
X1394 1150 231 1 1233 1168 1236 2 MOAI1S $T=499720 356280 0 0 $X=499720 $Y=355900
X1395 1234 1232 1 1234 1232 1225 2 MOAI1S $T=504060 396600 1 180 $X=500340 $Y=396220
X1396 1243 1245 1 1243 1245 1251 2 MOAI1S $T=507160 386520 1 0 $X=507160 $Y=381100
X1397 1246 1238 1 1248 1240 1259 2 MOAI1S $T=510880 356280 1 0 $X=510880 $Y=350860
X1398 1261 1270 1 1261 1270 1244 2 MOAI1S $T=519560 376440 0 0 $X=519560 $Y=376060
X1399 254 1281 1 1277 1168 1274 2 MOAI1S $T=527000 366360 0 180 $X=523280 $Y=360940
X1400 1273 1275 1 1273 1275 1285 2 MOAI1S $T=523900 396600 1 0 $X=523900 $Y=391180
X1401 250 252 1 250 252 1283 2 MOAI1S $T=523900 406680 0 0 $X=523900 $Y=406300
X1402 253 1282 1 253 1282 1286 2 MOAI1S $T=525760 376440 1 0 $X=525760 $Y=371020
X1403 258 1290 1 258 1290 1298 2 MOAI1S $T=530720 396600 1 0 $X=530720 $Y=391180
X1404 260 1287 1 260 1287 1310 2 MOAI1S $T=530720 396600 0 0 $X=530720 $Y=396220
X1405 1150 1299 1 1302 1168 1306 2 MOAI1S $T=535060 366360 1 0 $X=535060 $Y=360940
X1406 262 1308 1 262 1308 1315 2 MOAI1S $T=539400 406680 0 0 $X=539400 $Y=406300
X1407 1314 1316 1 1314 1316 1325 2 MOAI1S $T=542500 336120 0 0 $X=542500 $Y=335740
X1408 254 249 1 1324 270 269 2 MOAI1S $T=544360 406680 0 0 $X=544360 $Y=406300
X1409 1323 1328 1 1323 1328 1316 2 MOAI1S $T=549940 346200 0 180 $X=546220 $Y=340780
X1410 254 1338 1 1332 273 1330 2 MOAI1S $T=552420 356280 0 180 $X=548700 $Y=350860
X1411 277 1341 1 277 1341 1350 2 MOAI1S $T=552420 326040 0 0 $X=552420 $Y=325660
X1412 1338 1343 1 1338 1343 1352 2 MOAI1S $T=553660 376440 1 0 $X=553660 $Y=371020
X1413 1335 285 1 1335 285 1341 2 MOAI1S $T=558620 326040 1 0 $X=558620 $Y=320620
X1414 281 1352 1 282 289 1355 2 MOAI1S $T=559240 386520 1 0 $X=559240 $Y=381100
X1415 293 251 1 295 1360 1358 2 MOAI1S $T=564200 406680 0 0 $X=564200 $Y=406300
X1416 292 294 1 1357 1361 1362 2 MOAI1S $T=565440 396600 1 0 $X=565440 $Y=391180
X1417 291 297 1 296 1252 1363 2 MOAI1S $T=566680 326040 1 0 $X=566680 $Y=320620
X1418 292 251 1 1360 284 1369 2 MOAI1S $T=569160 406680 0 0 $X=569160 $Y=406300
X1419 292 247 1 1361 1371 1378 2 MOAI1S $T=571640 396600 1 0 $X=571640 $Y=391180
X1420 291 302 1 296 224 301 2 MOAI1S $T=579700 326040 0 180 $X=575980 $Y=320620
X1421 1374 1379 1 1365 1382 1381 2 MOAI1S $T=577220 366360 1 0 $X=577220 $Y=360940
X1422 1384 305 1 1382 1376 1373 2 MOAI1S $T=582800 356280 1 180 $X=579080 $Y=355900
X1423 1312 1388 1 1364 1392 1395 2 MOAI1S $T=582800 376440 1 0 $X=582800 $Y=371020
X1424 1398 1402 1 1404 1397 1412 2 MOAI1S $T=588380 356280 0 0 $X=588380 $Y=355900
X1425 1409 1402 1 1413 1397 1408 2 MOAI1S $T=595820 346200 1 180 $X=592100 $Y=345820
X1426 1426 1427 1 1433 328 1437 2 MOAI1S $T=607600 336120 1 0 $X=607600 $Y=330700
X1427 1529 1534 1 1529 1534 1532 2 MOAI1S $T=668360 376440 0 180 $X=664640 $Y=371020
X1428 1543 1536 1 1543 1536 1571 2 MOAI1S $T=670840 396600 1 0 $X=670840 $Y=391180
X1429 397 392 1 397 366 401 2 MOAI1S $T=675180 406680 0 0 $X=675180 $Y=406300
X1430 1549 1571 1 1549 1571 1580 2 MOAI1S $T=677040 396600 1 0 $X=677040 $Y=391180
X1431 1564 1577 1 1564 1577 1586 2 MOAI1S $T=680760 386520 0 0 $X=680760 $Y=386140
X1432 373 410 1 373 410 1615 2 MOAI1S $T=691920 406680 0 0 $X=691920 $Y=406300
X1433 1630 1629 1 1630 1629 424 2 MOAI1S $T=706800 326040 1 180 $X=703080 $Y=325660
X1434 1667 1658 1 1667 1658 449 2 MOAI1S $T=719820 326040 1 0 $X=719820 $Y=320620
X1435 1662 1671 1 1662 1671 1667 2 MOAI1S $T=721680 326040 0 0 $X=721680 $Y=325660
X1436 1684 1681 1 1684 1681 453 2 MOAI1S $T=731600 326040 1 180 $X=727880 $Y=325660
X1437 1700 1705 1 1700 1705 1712 2 MOAI1S $T=737180 346200 0 0 $X=737180 $Y=345820
X1438 1753 1751 1 1753 1751 1752 2 MOAI1S $T=773140 356280 1 180 $X=769420 $Y=355900
X1439 1763 1765 1 1763 1765 1778 2 MOAI1S $T=779960 396600 1 0 $X=779960 $Y=391180
X1440 1780 1778 1 1780 1778 1774 2 MOAI1S $T=786780 396600 1 180 $X=783060 $Y=396220
X1441 1801 1803 1 1801 1803 1798 2 MOAI1S $T=800420 386520 1 180 $X=796700 $Y=386140
X1442 1825 1818 1 1825 1818 1822 2 MOAI1S $T=811580 366360 0 180 $X=807860 $Y=360940
X1443 1832 1820 1 1832 1820 1829 2 MOAI1S $T=814060 336120 1 180 $X=810340 $Y=335740
X1444 1834 1838 1 1834 1838 1832 2 MOAI1S $T=815300 346200 1 0 $X=815300 $Y=340780
X1445 1851 1850 1 1851 1850 1849 2 MOAI1S $T=821500 356280 0 180 $X=817780 $Y=350860
X1446 1866 1864 1 1866 1864 1863 2 MOAI1S $T=828320 346200 0 180 $X=824600 $Y=340780
X1447 1970 1896 1 1970 1896 1968 2 MOAI1S $T=884120 346200 0 180 $X=880400 $Y=340780
X1448 1954 1993 1 1996 578 1999 2 MOAI1S $T=890940 366360 0 0 $X=890940 $Y=365980
X1449 2012 1965 1 2012 1965 2015 2 MOAI1S $T=903340 366360 0 180 $X=899620 $Y=360940
X1450 585 2004 1 585 2004 2023 2 MOAI1S $T=901480 336120 0 0 $X=901480 $Y=335740
X1451 589 2004 1 589 2004 2017 2 MOAI1S $T=908300 356280 1 180 $X=904580 $Y=355900
X1452 2024 2005 1 2024 2029 2027 2 MOAI1S $T=905200 386520 0 0 $X=905200 $Y=386140
X1453 2012 2026 1 2012 2026 2022 2 MOAI1S $T=909540 366360 0 180 $X=905820 $Y=360940
X1454 2010 2035 1 2010 2035 592 2 MOAI1S $T=913260 406680 0 180 $X=909540 $Y=401260
X1455 1997 595 1 1997 595 2030 2 MOAI1S $T=913880 336120 1 180 $X=910160 $Y=335740
X1456 1997 2037 1 2040 2037 2041 2 MOAI1S $T=912020 346200 0 0 $X=912020 $Y=345820
X1457 1762 1973 1 1762 1973 2032 2 MOAI1S $T=915740 366360 0 180 $X=912020 $Y=360940
X1458 2013 595 1 1914 2041 2035 2 MOAI1S $T=913880 356280 1 0 $X=913880 $Y=350860
X1459 2000 2026 1 2000 2026 2044 2 MOAI1S $T=913880 376440 0 0 $X=913880 $Y=376060
X1460 1762 2029 1 1762 2029 2038 2 MOAI1S $T=913880 386520 1 0 $X=913880 $Y=381100
X1461 2047 595 1 2047 595 2051 2 MOAI1S $T=918840 356280 0 0 $X=918840 $Y=355900
X1462 2024 2009 1 2024 2009 2057 2 MOAI1S $T=918840 376440 0 0 $X=918840 $Y=376060
X1463 2028 2050 1 2028 2050 609 2 MOAI1S $T=918840 406680 0 0 $X=918840 $Y=406300
X1464 2013 2052 1 1914 2056 2050 2 MOAI1S $T=920700 356280 1 0 $X=920700 $Y=350860
X1465 1860 1954 1 1860 1954 2070 2 MOAI1S $T=924420 356280 0 0 $X=924420 $Y=355900
X1466 2040 2063 1 2040 2063 2053 2 MOAI1S $T=931240 346200 0 180 $X=927520 $Y=340780
X1467 2072 2029 1 2075 2029 2060 2 MOAI1S $T=930000 386520 0 0 $X=930000 $Y=386140
X1468 2074 2043 1 2074 2043 2058 2 MOAI1S $T=934340 376440 0 180 $X=930620 $Y=371020
X1469 2043 2052 1 2043 2052 2080 2 MOAI1S $T=931240 356280 0 0 $X=931240 $Y=355900
X1470 2065 2058 1 1998 2080 2081 2 MOAI1S $T=931860 366360 1 0 $X=931860 $Y=360940
X1471 2040 615 1 2040 615 2056 2 MOAI1S $T=932480 356280 1 0 $X=932480 $Y=350860
X1472 2036 2082 1 2036 2082 2085 2 MOAI1S $T=935580 386520 0 0 $X=935580 $Y=386140
X1473 1961 2052 1 1961 2052 2094 2 MOAI1S $T=940540 376440 1 0 $X=940540 $Y=371020
X1474 2089 2082 1 2089 2082 2088 2 MOAI1S $T=941160 376440 0 0 $X=941160 $Y=376060
X1475 2075 2068 1 2075 2068 2115 2 MOAI1S $T=946740 376440 1 0 $X=946740 $Y=371020
X1476 2098 1961 1 2098 1961 2096 2 MOAI1S $T=947360 376440 0 0 $X=947360 $Y=376060
X1477 2047 615 1 2047 615 2109 2 MOAI1S $T=949220 356280 0 0 $X=949220 $Y=355900
X1478 2065 2106 1 1998 2109 2113 2 MOAI1S $T=952320 366360 0 0 $X=952320 $Y=365980
X1479 2036 2068 1 2036 2117 2126 2 MOAI1S $T=957280 376440 1 0 $X=957280 $Y=371020
X1480 620 2117 1 620 2117 2127 2 MOAI1S $T=959140 366360 0 0 $X=959140 $Y=365980
X1481 227 1262 1128 226 2 200 1 AOI13HS $T=516460 326040 1 180 $X=512740 $Y=325660
X1482 1662 1668 1653 412 2 1656 1 AOI13HS $T=719820 336120 1 180 $X=716100 $Y=335740
X1483 1834 1833 1815 1758 2 1819 1 AOI13HS $T=812820 346200 1 180 $X=809100 $Y=345820
X1484 1045 1 157 1043 2 1034 ND3 $T=412920 406680 1 180 $X=410440 $Y=406300
X1485 1042 1 158 1058 2 156 ND3 $T=414160 406680 0 180 $X=411680 $Y=401260
X1486 316 1 321 313 2 1425 ND3 $T=601400 326040 1 0 $X=601400 $Y=320620
X1487 320 1 310 1417 2 1425 ND3 $T=602020 326040 0 0 $X=602020 $Y=325660
X1488 1564 1 388 1561 2 349 ND3 $T=673320 386520 0 180 $X=670840 $Y=381100
X1489 1630 1 1560 1658 2 1653 ND3 $T=708040 336120 1 0 $X=708040 $Y=330700
X1490 1684 1 441 1708 2 1690 ND3 $T=732220 346200 1 0 $X=732220 $Y=340780
X1491 1801 1 1796 1784 2 467 ND3 $T=793600 386520 1 180 $X=791120 $Y=386140
X1492 1825 1 1781 1820 2 1815 ND3 $T=810960 356280 1 180 $X=808480 $Y=355900
X1493 1866 1 1816 1857 2 1860 ND3 $T=826460 356280 0 180 $X=823980 $Y=350860
X1494 1965 1 1997 1991 2 1988 ND3 $T=895280 346200 1 180 $X=892800 $Y=345820
X1495 51 54 1 800 804 789 2 MOAI1 $T=291400 336120 0 180 $X=287060 $Y=330700
X1496 1164 1171 1 1183 1190 1162 2 MOAI1 $T=478020 346200 0 0 $X=478020 $Y=345820
X1497 1268 1266 1 1268 1263 1266 2 MOAI1 $T=523280 336120 0 180 $X=518940 $Y=330700
X1498 1262 1263 1 1262 1288 1263 2 MOAI1 $T=524520 336120 1 0 $X=524520 $Y=330700
X1499 524 1973 1 524 1975 1973 2 MOAI1 $T=881640 386520 1 0 $X=881640 $Y=381100
X1500 1809 1860 1 1809 1998 1860 2 MOAI1 $T=890940 356280 0 0 $X=890940 $Y=355900
X1501 2084 2021 586 2 2014 2044 1 AO22 $T=939300 386520 0 180 $X=934340 $Y=381100
X1502 1010 960 896 996 2 1024 1 1026 MUX3 $T=397420 356280 1 0 $X=397420 $Y=350860
X1503 908 1007 996 1035 2 1048 1 1049 MUX3 $T=411060 346200 1 0 $X=411060 $Y=340780
X1504 149 1037 1023 2 1 1013 XOR3 $T=412920 366360 1 180 $X=401760 $Y=365980
X1505 1011 1026 152 2 1 1016 XOR3 $T=415400 386520 1 180 $X=404240 $Y=386140
X1506 1055 1070 1057 2 1 1068 XOR3 $T=442060 356280 1 180 $X=430900 $Y=355900
X1507 1110 1113 1133 2 1 1127 XOR3 $T=447020 356280 1 0 $X=447020 $Y=350860
X1508 1162 1164 1171 2 1 1184 XOR3 $T=472440 356280 0 0 $X=472440 $Y=355900
X1509 1240 1246 1238 2 1 1233 XOR3 $T=517080 356280 1 180 $X=505920 $Y=355900
X1510 839 825 75 1 2 799 MAO222 $T=306280 396600 1 180 $X=301320 $Y=396220
X1511 828 840 834 1 2 855 MAO222 $T=310000 376440 0 0 $X=310000 $Y=376060
X1512 822 855 854 1 2 873 MAO222 $T=316820 376440 0 0 $X=316820 $Y=376060
X1513 1328 1323 1314 1 2 1347 MAO222 $T=553040 346200 1 0 $X=553040 $Y=340780
X1514 1383 1336 1386 1 2 1377 MAO222 $T=583420 386520 0 180 $X=578460 $Y=381100
X1515 1368 1393 1399 1 2 1386 MAO222 $T=589000 386520 0 180 $X=584040 $Y=381100
X1516 1395 1321 1403 1 2 1393 MAO222 $T=590240 376440 1 180 $X=585280 $Y=376060
X1517 178 1051 175 1 2 1080 AO12 $T=435860 396600 1 180 $X=432140 $Y=396220
X1518 192 1051 190 1 2 1112 AO12 $T=453840 406680 0 180 $X=450120 $Y=401260
X1519 179 201 1149 1 2 1155 AO12 $T=461900 406680 1 0 $X=461900 $Y=401260
X1520 206 1051 203 1 2 1145 AO12 $T=468720 396600 1 180 $X=465000 $Y=396220
X1521 214 208 212 1 2 1172 AO12 $T=480500 406680 0 180 $X=476780 $Y=401260
X1522 1254 1264 1259 1 2 1269 AO12 $T=517080 356280 1 0 $X=517080 $Y=350860
X1523 718 720 1 2 BUF2CK $T=235600 406680 0 0 $X=235600 $Y=406300
X1524 1164 1182 1 2 BUF2CK $T=482980 366360 1 0 $X=482980 $Y=360940
X1525 1289 1299 1 2 BUF2CK $T=538780 366360 1 0 $X=538780 $Y=360940
X1526 46 2 1 796 BUF3 $T=275280 346200 1 0 $X=275280 $Y=340780
X1527 796 2 1 226 BUF3 $T=489800 326040 1 0 $X=489800 $Y=320620
X1528 1335 1 276 1342 2 ND2P $T=550560 326040 1 0 $X=550560 $Y=320620
X1529 1333 1 1342 1328 2 ND2P $T=554280 326040 1 0 $X=554280 $Y=320620
X1530 1348 1 1351 283 2 ND2P $T=557380 366360 0 0 $X=557380 $Y=365980
X1531 1338 1 1339 1351 2 ND2P $T=561100 366360 0 0 $X=561100 $Y=365980
X1532 1346 1 1356 1348 2 ND2P $T=564820 366360 0 0 $X=564820 $Y=365980
X1533 1364 1375 1365 1320 2 1 MXL2HS $T=579080 376440 0 180 $X=573500 $Y=371020
X1534 1406 1375 1398 1411 2 1 MXL2HS $T=597680 376440 0 180 $X=592100 $Y=371020
X1535 1403 1375 1409 1414 2 1 MXL2HS $T=600160 376440 1 180 $X=594580 $Y=376060
X1536 1990 1975 1982 550 2 1 MXL2HS $T=891560 406680 0 180 $X=885980 $Y=401260
X1537 1990 586 2019 539 2 1 MXL2HS $T=905200 406680 0 180 $X=899620 $Y=401260
X1538 110 2 944 925 1 AN2B1S $T=362080 336120 1 180 $X=358980 $Y=335740
X1539 1298 2 1292 1305 1 AN2B1S $T=535060 376440 0 0 $X=535060 $Y=376060
X1540 1214 2 1336 1368 1 AN2B1S $T=568540 376440 0 0 $X=568540 $Y=376060
X1541 804 807 817 834 1 2 MAO222P $T=296360 376440 0 0 $X=296360 $Y=376060
X1542 873 865 871 885 1 2 MAO222P $T=322400 386520 0 0 $X=322400 $Y=386140
X1543 893 888 885 902 1 2 MAO222P $T=331080 396600 0 0 $X=331080 $Y=396220
X1544 1296 2 1293 1 264 NR2P $T=539400 366360 1 180 $X=535680 $Y=365980
X1545 2007 2 2006 1 1987 NR2P $T=897760 376440 0 0 $X=897760 $Y=376060
X1546 1215 1219 115 1219 227 1215 1 2 1211 OA222 $T=497860 336120 0 180 $X=492280 $Y=330700
X1547 1961 529 538 1916 550 548 1 2 1971 OA222 $T=876680 396600 1 0 $X=876680 $Y=391180
X1548 2000 1961 583 2005 539 2009 1 2 2014 OA222 $T=894040 396600 0 0 $X=894040 $Y=396220
X1549 1044 1031 1032 2 1 1047 XNR3 $T=416020 366360 1 0 $X=416020 $Y=360940
X1550 1082 1085 1073 2 1 1106 XNR3 $T=433380 356280 1 0 $X=433380 $Y=350860
X1551 1137 1142 1135 2 1 1153 XNR3 $T=459420 356280 0 0 $X=459420 $Y=355900
X1552 1190 1208 1195 2 1 1202 XNR3 $T=498480 356280 0 180 $X=487320 $Y=350860
X1553 1259 1254 1264 2 1 1277 XNR3 $T=520800 356280 1 0 $X=520800 $Y=350860
X1554 1276 1289 1288 2 1 1302 XNR3 $T=529480 346200 0 0 $X=529480 $Y=345820
X1555 220 1095 1 215 1191 1185 2 OAI112HS $T=487320 406680 0 180 $X=482980 $Y=401260
X1556 238 1241 1 234 1234 232 2 OAI112HS $T=507780 406680 1 180 $X=503440 $Y=406300
X1557 251 1241 1 246 1261 243 2 OAI112HS $T=521420 406680 0 180 $X=517080 $Y=401260
X1558 311 1407 1 1329 1402 1417 2 OAI112HS $T=589620 336120 0 0 $X=589620 $Y=335740
X1559 1088 180 1095 183 2 1 1092 OA112 $T=438340 396600 0 0 $X=438340 $Y=396220
X1560 1104 186 1095 189 2 1 1125 OA112 $T=445160 396600 0 0 $X=445160 $Y=396220
X1561 195 197 1095 1144 2 1 1147 OA112 $T=457560 396600 0 0 $X=457560 $Y=396220
X1562 1415 1389 1398 1409 2 1 1405 OA112 $T=595200 386520 1 180 $X=590240 $Y=386140
X1563 1262 200 1 1279 1262 2 1279 1284 226 OAI222S $T=523900 326040 0 0 $X=523900 $Y=325660
X1564 1220 2 1291 258 1292 1 NR3 $T=532580 376440 1 180 $X=529480 $Y=376060
X1565 1422 2 327 321 1410 1 NR3 $T=611320 326040 1 180 $X=608220 $Y=325660
X1566 223 217 216 2 1155 1 1186 AN4B1S $T=486700 406680 1 180 $X=482360 $Y=406300
X1567 222 1207 225 2 1160 1 1210 AN4B1S $T=489180 406680 1 0 $X=489180 $Y=401260
X1568 239 1257 241 2 242 1 1272 AN4B1S $T=512740 406680 0 0 $X=512740 $Y=406300
X1569 284 1 2 1361 BUF3CK $T=572880 406680 0 0 $X=572880 $Y=406300
X1570 1344 184 1331 267 1 2 QDFFRBP $T=556760 396600 0 180 $X=544360 $Y=391180
X1571 1349 184 1331 268 1 2 QDFFRBP $T=559240 406680 0 180 $X=546840 $Y=401260
X1572 1396 184 1331 323 1 2 QDFFRBP $T=590860 406680 1 0 $X=590860 $Y=401260
X1573 1356 1345 1 2 INV1CK $T=564200 346200 0 0 $X=564200 $Y=345820
.ENDS
***************************************
.SUBCKT TIE0 O VCC GND
** N=4 EP=3 IP=0 FDC=0
.ENDS
***************************************
.SUBCKT OR3 I3 I2 I1 VCC GND O
** N=7 EP=6 IP=0 FDC=0
.ENDS
***************************************
.SUBCKT ICV_9 1 2 3 4 5 6 7 8 9 10 11 12 13 14 15 16 17 18 19 20
+ 21 22 23 24 25 26 27 28 29 30 31 32 33 34 35 36 37 38 39 40
+ 41 42 43 44 45 46 47 48 49 50 51 52 53 54 55 56 57 58 59 60
+ 61 62 63 64 65 66 67 68 69 70 71 72 73 74 75 76 77 78 79 80
+ 81 82 83 84 85 86 87 88 89 90 91 92 93 94 95 96 97 98 99 100
+ 101 102 103 104 105 106 108 109 110 111 112 113 114 115 116 117 119 120 121 122
+ 123 124 125 126 127 128 130 131 132 133 134 135 136 137 138 139 140 141 142 143
+ 144 145 147 148 149 150 151 152 153 155 156 157 158 159 160 161 162 164 165 166
+ 167 168 169 170 171 172 173 174 175 176 177 178 179 180 181 182 183 184 185 186
+ 187 188 189 190 191 192 193 194 195 196 197 198 199 200 201 202 203 204 205 206
+ 207 208 209 210 211 212 213 214 215 216 217 218 219 220 221 222 223 224 225 226
+ 227 228 229 230 231 232 233 234 235 236 237 238 239 240 241 242 243 244 245 246
+ 247 248 249 250 251 252 253 254 255 256 257 258 259 260 261 262 263 264 265 266
+ 267 268 269 270 271 272 273 274 275 276 277 278 279 280 281 282 283 284 285 286
+ 287 288 289 290 291 292 293 294 295 296 297 298 299 300 301 302 303 304 305 306
+ 307 308 309 310 311 312 313 314 315 316 317 318 319 320 321 322 323 324 325 326
+ 327 328 329 330 331 332 333 334 335 336 337 338 339 340 341 342 343 344 345 346
+ 347 348 349 350 351 352 353 354 355 356 357 358 359 360 361 386
** N=1545 EP=356 IP=7237 FDC=0
X0 358 1541 1541 1541 359 1541 333 YA2GSD $T=1199700 166820 0 90 $X=1060200 $Y=169670
X1 360 1527 1527 1527 361 357 355 YA2GSD $T=1199700 256140 0 90 $X=1060200 $Y=258990
X2 1063 2 1 TIE1 $T=628680 245400 1 0 $X=628680 $Y=239980
X3 6 2 1 4 BUF1 $T=225060 285720 1 180 $X=222580 $Y=285340
X4 11 2 1 6 BUF1 $T=229400 225240 0 180 $X=226920 $Y=219820
X5 406 2 1 395 BUF1 $T=248000 265560 0 180 $X=245520 $Y=260140
X6 399 2 1 406 BUF1 $T=251100 265560 1 180 $X=248620 $Y=265180
X7 24 2 1 23 BUF1 $T=251100 305880 1 180 $X=248620 $Y=305500
X8 406 2 1 414 BUF1 $T=254200 255480 1 0 $X=254200 $Y=250060
X9 20 2 1 399 BUF1 $T=256680 315960 1 0 $X=256680 $Y=310540
X10 432 2 1 396 BUF1 $T=262880 285720 1 180 $X=260400 $Y=285340
X11 432 2 1 420 BUF1 $T=268460 285720 1 0 $X=268460 $Y=280300
X12 34 2 1 444 BUF1 $T=269700 315960 0 0 $X=269700 $Y=315580
X13 415 2 1 437 BUF1 $T=270940 295800 1 0 $X=270940 $Y=290380
X14 406 2 1 461 BUF1 $T=278380 265560 1 0 $X=278380 $Y=260140
X15 487 2 1 463 BUF1 $T=296980 245400 0 180 $X=294500 $Y=239980
X16 487 2 1 490 BUF1 $T=296980 245400 1 0 $X=296980 $Y=239980
X17 47 2 1 510 BUF1 $T=310000 315960 1 180 $X=307520 $Y=315580
X18 52 2 1 542 BUF1 $T=321160 295800 0 0 $X=321160 $Y=295420
X19 552 2 1 487 BUF1 $T=331080 255480 0 180 $X=328600 $Y=250060
X20 60 2 1 11 BUF1 $T=334180 225240 0 180 $X=331700 $Y=219820
X21 54 2 1 569 BUF1 $T=337280 295800 1 0 $X=337280 $Y=290380
X22 48 2 1 588 BUF1 $T=343480 265560 0 0 $X=343480 $Y=265180
X23 71 2 1 442 BUF1 $T=354640 295800 1 180 $X=352160 $Y=295420
X24 73 2 1 24 BUF1 $T=354640 315960 1 180 $X=352160 $Y=315580
X25 76 2 1 535 BUF1 $T=360220 315960 1 180 $X=357740 $Y=315580
X26 605 2 1 553 BUF1 $T=362080 245400 0 180 $X=359600 $Y=239980
X27 552 2 1 605 BUF1 $T=363940 245400 1 180 $X=361460 $Y=245020
X28 610 2 1 560 BUF1 $T=363940 275640 0 180 $X=361460 $Y=270220
X29 560 2 1 578 BUF1 $T=364560 245400 0 0 $X=364560 $Y=245020
X30 618 2 1 552 BUF1 $T=367660 255480 0 0 $X=367660 $Y=255100
X31 552 2 1 629 BUF1 $T=370140 265560 1 0 $X=370140 $Y=260140
X32 570 2 1 84 BUF1 $T=376340 315960 0 0 $X=376340 $Y=315580
X33 82 2 1 72 BUF1 $T=380680 305880 1 180 $X=378200 $Y=305500
X34 649 2 1 568 BUF1 $T=384400 305880 1 180 $X=381920 $Y=305500
X35 651 2 1 570 BUF1 $T=386880 295800 1 180 $X=384400 $Y=295420
X36 618 2 1 648 BUF1 $T=389980 255480 0 180 $X=387500 $Y=250060
X37 610 2 1 659 BUF1 $T=387500 265560 0 0 $X=387500 $Y=265180
X38 82 2 1 672 BUF1 $T=390600 305880 1 0 $X=390600 $Y=300460
X39 82 2 1 610 BUF1 $T=390600 305880 0 0 $X=390600 $Y=305500
X40 673 2 1 618 BUF1 $T=399280 285720 0 180 $X=396800 $Y=280300
X41 663 2 1 666 BUF1 $T=397420 265560 0 0 $X=397420 $Y=265180
X42 666 2 1 670 BUF1 $T=399280 245400 0 0 $X=399280 $Y=245020
X43 659 2 1 654 BUF1 $T=399280 255480 1 0 $X=399280 $Y=250060
X44 672 2 1 682 BUF1 $T=399900 305880 1 0 $X=399900 $Y=300460
X45 569 2 1 686 BUF1 $T=401760 265560 0 0 $X=401760 $Y=265180
X46 689 2 1 708 BUF1 $T=417880 225240 0 0 $X=417880 $Y=224860
X47 671 2 1 707 BUF1 $T=417880 245400 0 0 $X=417880 $Y=245020
X48 99 2 1 649 BUF1 $T=420360 305880 0 180 $X=417880 $Y=300460
X49 680 2 1 735 BUF1 $T=429040 285720 1 0 $X=429040 $Y=280300
X50 730 2 1 109 BUF1 $T=437100 305880 0 0 $X=437100 $Y=305500
X51 674 2 1 767 BUF1 $T=438340 245400 0 0 $X=438340 $Y=245020
X52 756 2 1 110 BUF1 $T=443920 305880 1 180 $X=441440 $Y=305500
X53 111 2 1 112 BUF1 $T=441440 315960 0 0 $X=441440 $Y=315580
X54 666 2 1 746 BUF1 $T=442060 265560 1 0 $X=442060 $Y=260140
X55 764 2 1 651 BUF1 $T=447020 285720 1 180 $X=444540 $Y=285340
X56 682 2 1 750 BUF1 $T=445160 295800 0 0 $X=445160 $Y=295420
X57 96 2 1 759 BUF1 $T=449500 315960 0 180 $X=447020 $Y=310540
X58 100 2 1 778 BUF1 $T=452600 255480 0 0 $X=452600 $Y=255100
X59 688 2 1 791 BUF1 $T=453220 255480 1 0 $X=453220 $Y=250060
X60 777 2 1 117 BUF1 $T=455700 305880 1 180 $X=453220 $Y=305500
X61 792 2 1 811 BUF1 $T=464380 305880 0 0 $X=464380 $Y=305500
X62 784 2 1 123 BUF1 $T=465620 305880 1 0 $X=465620 $Y=300460
X63 93 2 1 125 BUF1 $T=470580 315960 0 0 $X=470580 $Y=315580
X64 749 2 1 816 BUF1 $T=471200 255480 0 0 $X=471200 $Y=255100
X65 128 2 1 130 BUF1 $T=476160 315960 1 0 $X=476160 $Y=310540
X66 128 2 1 828 BUF1 $T=476780 305880 0 0 $X=476780 $Y=305500
X67 771 2 1 847 BUF1 $T=479880 265560 1 0 $X=479880 $Y=260140
X68 662 2 1 855 BUF1 $T=494140 275640 0 0 $X=494140 $Y=275260
X69 137 2 1 858 BUF1 $T=503440 275640 0 180 $X=500960 $Y=270220
X70 131 2 1 934 BUF1 $T=530100 295800 0 0 $X=530100 $Y=295420
X71 764 2 1 167 BUF1 $T=566680 305880 1 0 $X=566680 $Y=300460
X72 1012 2 1 160 BUF1 $T=572880 295800 1 180 $X=570400 $Y=295420
X73 172 2 1 971 BUF1 $T=584040 295800 1 180 $X=581560 $Y=295420
X74 172 2 1 1046 BUF1 $T=607600 295800 1 0 $X=607600 $Y=290380
X75 1046 2 1 1042 BUF1 $T=618760 285720 1 0 $X=618760 $Y=280300
X76 198 2 1 1066 BUF1 $T=630540 315960 1 180 $X=628060 $Y=315580
X77 203 2 1 60 BUF1 $T=634880 225240 0 180 $X=632400 $Y=219820
X78 216 2 1 1085 BUF1 $T=652240 265560 0 0 $X=652240 $Y=265180
X79 221 2 1 1110 BUF1 $T=655340 275640 0 0 $X=655340 $Y=275260
X80 220 2 1 1088 BUF1 $T=655340 315960 1 0 $X=655340 $Y=310540
X81 207 2 1 1115 BUF1 $T=657820 305880 0 0 $X=657820 $Y=305500
X82 204 2 1 1089 BUF1 $T=658440 315960 0 0 $X=658440 $Y=315580
X83 222 2 1 1116 BUF1 $T=660300 315960 1 0 $X=660300 $Y=310540
X84 226 2 1 1125 BUF1 $T=672700 265560 1 180 $X=670220 $Y=265180
X85 228 2 1 226 BUF1 $T=674560 315960 1 180 $X=672080 $Y=315580
X86 234 2 1 1119 BUF1 $T=686960 315960 0 180 $X=684480 $Y=310540
X87 1046 2 1 1163 BUF1 $T=685100 285720 0 0 $X=685100 $Y=285340
X88 251 2 1 203 BUF1 $T=727260 225240 0 180 $X=724780 $Y=219820
X89 1163 2 1 258 BUF1 $T=739040 305880 0 0 $X=739040 $Y=305500
X90 1163 2 1 1223 BUF1 $T=739660 285720 1 0 $X=739660 $Y=280300
X91 1085 2 1 1281 BUF1 $T=779960 245400 0 0 $X=779960 $Y=245020
X92 281 2 1 1283 BUF1 $T=783680 255480 1 0 $X=783680 $Y=250060
X93 1282 2 1 1277 BUF1 $T=788020 275640 0 0 $X=788020 $Y=275260
X94 288 2 1 274 BUF1 $T=794220 315960 0 180 $X=791740 $Y=310540
X95 287 2 1 1300 BUF1 $T=794220 255480 1 0 $X=794220 $Y=250060
X96 269 2 1 1329 BUF1 $T=815300 275640 1 0 $X=815300 $Y=270220
X97 295 2 1 1276 BUF1 $T=818400 275640 0 0 $X=818400 $Y=275260
X98 301 2 1 251 BUF1 $T=822120 225240 0 180 $X=819640 $Y=219820
X99 1270 2 1 1341 BUF1 $T=820260 275640 1 0 $X=820260 $Y=270220
X100 298 2 1 1328 BUF1 $T=830180 295800 1 0 $X=830180 $Y=290380
X101 1328 2 1 1357 BUF1 $T=836380 295800 1 0 $X=836380 $Y=290380
X102 1357 2 1 315 BUF1 $T=868000 305880 1 180 $X=865520 $Y=305500
X103 1315 2 1 321 BUF1 $T=872340 305880 0 0 $X=872340 $Y=305500
X104 319 2 1 1282 BUF1 $T=876060 315960 0 0 $X=876060 $Y=315580
X105 1282 2 1 1436 BUF1 $T=895900 285720 1 0 $X=895900 $Y=280300
X106 323 2 1 1447 BUF1 $T=899000 315960 0 0 $X=899000 $Y=315580
X107 1440 2 1 1442 BUF1 $T=903340 295800 0 0 $X=903340 $Y=295420
X108 328 2 1 1325 BUF1 $T=906440 275640 1 180 $X=903960 $Y=275260
X109 325 2 1 1437 BUF1 $T=903960 305880 1 0 $X=903960 $Y=300460
X110 1283 2 1 339 BUF1 $T=928140 255480 0 0 $X=928140 $Y=255100
X111 1527 2 1 1541 BUF1 $T=974020 225240 1 0 $X=974020 $Y=219820
X112 355 2 1 333 BUF1 $T=976500 235320 0 180 $X=974020 $Y=229900
X113 1527 2 1 357 BUF1 $T=975260 275640 0 0 $X=975260 $Y=275260
X114 387 7 13 2 1 393 QDFFRBN $T=221960 305880 0 0 $X=221960 $Y=305500
X115 14 7 395 2 1 402 QDFFRBN $T=230640 245400 0 0 $X=230640 $Y=245020
X116 3 7 395 2 1 400 QDFFRBN $T=230640 255480 1 0 $X=230640 $Y=250060
X117 19 7 13 2 1 388 QDFFRBN $T=242420 295800 0 180 $X=230640 $Y=290380
X118 390 7 395 2 1 404 QDFFRBN $T=232500 265560 0 0 $X=232500 $Y=265180
X119 391 7 399 2 1 408 QDFFRBN $T=233120 275640 1 0 $X=233120 $Y=270220
X120 16 7 20 2 1 405 QDFFRBN $T=234980 315960 0 0 $X=234980 $Y=315580
X121 403 7 399 2 1 416 QDFFRBN $T=244900 285720 0 0 $X=244900 $Y=285340
X122 22 7 414 2 1 418 QDFFRBN $T=247380 235320 1 0 $X=247380 $Y=229900
X123 409 7 414 2 1 425 QDFFRBN $T=251100 235320 0 0 $X=251100 $Y=234940
X124 410 411 395 2 1 426 QDFFRBN $T=251100 255480 0 0 $X=251100 $Y=255100
X125 412 7 399 2 1 31 QDFFRBN $T=254200 315960 0 0 $X=254200 $Y=315580
X126 419 7 399 2 1 33 QDFFRBN $T=258540 295800 0 0 $X=258540 $Y=295420
X127 439 411 406 2 1 422 QDFFRBN $T=274660 255480 0 180 $X=262880 $Y=250060
X128 433 411 399 2 1 424 QDFFRBN $T=275280 275640 1 180 $X=263500 $Y=275260
X129 37 411 414 2 1 394 QDFFRBN $T=275900 225240 0 180 $X=264120 $Y=219820
X130 431 411 406 2 1 449 QDFFRBN $T=264740 265560 1 0 $X=264740 $Y=260140
X131 460 411 406 2 1 434 QDFFRBN $T=283340 245400 0 180 $X=271560 $Y=239980
X132 450 411 414 2 1 445 QDFFRBN $T=285820 235320 0 180 $X=274040 $Y=229900
X133 447 411 461 2 1 468 QDFFRBN $T=274040 275640 1 0 $X=274040 $Y=270220
X134 472 411 461 2 1 452 QDFFRBN $T=292020 255480 1 180 $X=280240 $Y=255100
X135 477 411 488 2 1 498 QDFFRBN $T=291400 225240 0 0 $X=291400 $Y=224860
X136 467 411 488 2 1 499 QDFFRBN $T=292020 255480 1 0 $X=292020 $Y=250060
X137 504 411 488 2 1 523 QDFFRBN $T=305040 235320 1 0 $X=305040 $Y=229900
X138 527 411 488 2 1 503 QDFFRBN $T=318060 245400 1 180 $X=306280 $Y=245020
X139 520 411 505 2 1 544 QDFFRBN $T=313720 255480 0 0 $X=313720 $Y=255100
X140 526 411 488 2 1 551 QDFFRBN $T=316200 225240 1 0 $X=316200 $Y=219820
X141 547 411 560 2 1 567 QDFFRBN $T=327360 255480 0 0 $X=327360 $Y=255100
X142 562 411 578 2 1 581 QDFFRBN $T=334800 225240 0 0 $X=334800 $Y=224860
X143 572 411 560 2 1 592 QDFFRBN $T=340380 245400 0 0 $X=340380 $Y=245020
X144 571 411 560 2 1 596 QDFFRBN $T=341620 255480 0 0 $X=341620 $Y=255100
X145 580 70 72 2 1 545 QDFFRBN $T=345340 315960 1 0 $X=345340 $Y=310540
X146 586 70 72 2 1 59 QDFFRBN $T=349060 305880 1 0 $X=349060 $Y=300460
X147 589 411 578 2 1 608 QDFFRBN $T=350300 225240 0 0 $X=350300 $Y=224860
X148 587 411 560 2 1 623 QDFFRBN $T=357120 265560 1 0 $X=357120 $Y=260140
X149 609 70 72 2 1 67 QDFFRBN $T=362080 305880 1 0 $X=362080 $Y=300460
X150 625 411 578 2 1 613 QDFFRBN $T=376340 235320 1 180 $X=364560 $Y=234940
X151 614 411 578 2 1 636 QDFFRBN $T=365800 225240 1 0 $X=365800 $Y=219820
X152 616 411 610 2 1 639 QDFFRBN $T=365800 275640 1 0 $X=365800 $Y=270220
X153 607 411 610 2 1 646 QDFFRBN $T=368900 275640 0 0 $X=368900 $Y=275260
X154 641 411 578 2 1 621 QDFFRBN $T=382540 255480 0 180 $X=370760 $Y=250060
X155 638 411 654 2 1 661 QDFFRBN $T=378820 235320 0 0 $X=378820 $Y=234940
X156 645 411 659 2 1 665 QDFFRBN $T=380680 255480 0 0 $X=380680 $Y=255100
X157 647 411 659 2 1 667 QDFFRBN $T=382540 275640 0 0 $X=382540 $Y=275260
X158 669 411 610 2 1 77 QDFFRBN $T=396800 295800 0 180 $X=385020 $Y=290380
X159 633 411 610 2 1 78 QDFFRBN $T=386880 295800 0 0 $X=386880 $Y=295420
X160 658 411 659 2 1 676 QDFFRBN $T=388120 275640 1 0 $X=388120 $Y=270220
X161 635 411 654 2 1 677 QDFFRBN $T=388740 235320 1 0 $X=388740 $Y=229900
X162 89 70 672 2 1 679 QDFFRBN $T=389360 315960 0 0 $X=389360 $Y=315580
X163 668 411 659 2 1 687 QDFFRBN $T=394940 255480 0 0 $X=394940 $Y=255100
X164 675 411 682 2 1 91 QDFFRBN $T=398660 295800 0 0 $X=398660 $Y=295420
X165 683 411 654 2 1 701 QDFFRBN $T=403620 235320 0 0 $X=403620 $Y=234940
X166 684 411 654 2 1 691 QDFFRBN $T=404240 225240 1 0 $X=404240 $Y=219820
X167 685 411 654 2 1 715 QDFFRBN $T=404240 255480 1 0 $X=404240 $Y=250060
X168 706 411 682 2 1 95 QDFFRBN $T=419120 305880 0 0 $X=419120 $Y=305500
X169 716 411 682 2 1 724 QDFFRBN $T=421600 295800 0 0 $X=421600 $Y=295420
X170 721 411 682 2 1 730 QDFFRBN $T=423460 305880 1 0 $X=423460 $Y=300460
X171 737 411 750 2 1 757 QDFFRBN $T=431520 295800 1 0 $X=431520 $Y=290380
X172 743 411 750 2 1 760 QDFFRBN $T=434620 275640 1 0 $X=434620 $Y=270220
X173 747 411 682 2 1 756 QDFFRBN $T=435860 305880 1 0 $X=435860 $Y=300460
X174 768 411 750 2 1 792 QDFFRBN $T=448880 285720 0 0 $X=448880 $Y=285340
X175 773 411 750 2 1 790 QDFFRBN $T=450740 275640 1 0 $X=450740 $Y=270220
X176 780 411 750 2 1 777 QDFFRBN $T=453220 305880 1 0 $X=453220 $Y=300460
X177 800 411 750 2 1 784 QDFFRBN $T=468720 295800 1 180 $X=456940 $Y=295420
X178 983 156 971 2 1 126 QDFFRBN $T=552420 305880 0 180 $X=540640 $Y=300460
X179 1003 156 971 2 1 127 QDFFRBN $T=566060 305880 0 180 $X=554280 $Y=300460
X180 1014 156 971 2 1 164 QDFFRBN $T=578460 285720 1 180 $X=566680 $Y=285340
X181 1018 156 971 2 1 168 QDFFRBN $T=587140 305880 0 180 $X=575360 $Y=300460
X182 1009 156 172 2 1 170 QDFFRBN $T=575360 305880 0 0 $X=575360 $Y=305500
X183 171 156 172 2 1 177 QDFFRBN $T=581560 315960 0 0 $X=581560 $Y=315580
X184 1036 156 1042 2 1 1024 QDFFRBN $T=593960 285720 0 0 $X=593960 $Y=285340
X185 1039 156 1046 2 1 1050 QDFFRBN $T=600160 305880 1 0 $X=600160 $Y=300460
X186 1055 156 1046 2 1 185 QDFFRBN $T=617520 275640 0 180 $X=605740 $Y=270220
X187 1059 156 1046 2 1 1047 QDFFRBN $T=623100 295800 1 180 $X=611320 $Y=295420
X188 1064 156 1042 2 1 1033 QDFFRBN $T=625580 255480 1 180 $X=613800 $Y=255100
X189 1099 217 1042 2 1 1121 QDFFRBN $T=652240 285720 0 0 $X=652240 $Y=285340
X190 1169 217 1042 2 1 1186 QDFFRBN $T=692540 295800 1 0 $X=692540 $Y=290380
X191 240 217 1163 2 1 1205 QDFFRBN $T=705560 295800 1 0 $X=705560 $Y=290380
X192 243 217 1163 2 1 1203 QDFFRBN $T=708660 305880 1 0 $X=708660 $Y=300460
X193 1194 217 1163 2 1 1206 QDFFRBN $T=709900 285720 1 0 $X=709900 $Y=280300
X194 1183 217 1163 2 1 1210 QDFFRBN $T=710520 275640 1 0 $X=710520 $Y=270220
X195 1216 217 1223 2 1 1228 QDFFRBN $T=730980 295800 0 0 $X=730980 $Y=295420
X196 1217 217 1223 2 1 1220 QDFFRBN $T=732220 265560 0 0 $X=732220 $Y=265180
X197 1219 217 1223 2 1 1230 QDFFRBN $T=733460 255480 0 0 $X=733460 $Y=255100
X198 1197 217 1223 2 1 1226 QDFFRBN $T=734700 265560 1 0 $X=734700 $Y=260140
X199 1221 217 258 2 1 1232 QDFFRBN $T=745860 305880 0 0 $X=745860 $Y=305500
X200 1207 217 1223 2 1 1231 QDFFRBN $T=746480 275640 1 0 $X=746480 $Y=270220
X201 1307 217 298 2 1 1316 QDFFRBN $T=802900 305880 1 0 $X=802900 $Y=300460
X202 1288 217 1328 2 1 1335 QDFFRBN $T=807860 285720 1 0 $X=807860 $Y=280300
X203 1317 217 298 2 1 1330 QDFFRBN $T=808480 285720 0 0 $X=808480 $Y=285340
X204 1347 217 298 2 1 1327 QDFFRBN $T=828320 295800 1 180 $X=816540 $Y=295420
X205 1358 217 298 2 1 304 QDFFRBN $T=840720 315960 0 180 $X=828940 $Y=310540
X206 1361 217 1328 2 1 1345 QDFFRBN $T=846920 285720 0 180 $X=835140 $Y=280300
X207 1350 217 1328 2 1 1359 QDFFRBN $T=836380 285720 0 0 $X=836380 $Y=285340
X208 1366 217 1357 2 1 1374 QDFFRBN $T=842580 295800 1 0 $X=842580 $Y=290380
X209 1376 217 1357 2 1 1340 QDFFRBN $T=854980 315960 1 180 $X=843200 $Y=315580
X210 1381 217 1328 2 1 1363 QDFFRBN $T=859940 285720 0 180 $X=848160 $Y=280300
X211 1389 217 1357 2 1 1372 QDFFRBN $T=861800 285720 1 180 $X=850020 $Y=285340
X212 1379 217 315 2 1 316 QDFFRBN $T=857460 315960 1 0 $X=857460 $Y=310540
X213 1398 217 1357 2 1 1386 QDFFRBN $T=874820 305880 0 180 $X=863040 $Y=300460
X214 1401 217 1357 2 1 1382 QDFFRBN $T=875440 285720 1 180 $X=863660 $Y=285340
X215 388 2 5 1 INV1S $T=224440 305880 0 180 $X=223200 $Y=300460
X216 400 2 8 1 INV1S $T=226300 275640 1 180 $X=225060 $Y=275260
X217 402 2 10 1 INV1S $T=226920 265560 0 180 $X=225680 $Y=260140
X218 394 2 15 1 INV1S $T=234360 235320 1 180 $X=233120 $Y=234940
X219 418 2 29 1 INV1S $T=259780 295800 1 0 $X=259780 $Y=290380
X220 33 2 415 1 INV1S $T=265980 315960 0 180 $X=264740 $Y=310540
X221 454 2 432 1 INV1S $T=279620 255480 0 180 $X=278380 $Y=250060
X222 463 2 454 1 INV1S $T=282720 255480 0 180 $X=281480 $Y=250060
X223 461 2 482 1 INV1S $T=290160 265560 1 0 $X=290160 $Y=260140
X224 482 2 488 1 INV1S $T=296360 255480 0 0 $X=296360 $Y=255100
X225 482 2 505 1 INV1S $T=296360 265560 1 0 $X=296360 $Y=260140
X226 545 2 61 1 INV1S $T=334180 315960 1 0 $X=334180 $Y=310540
X227 59 2 550 1 INV1S $T=337280 305880 0 0 $X=337280 $Y=305500
X228 67 2 582 1 INV1S $T=350920 295800 0 0 $X=350920 $Y=295420
X229 80 2 71 1 INV1S $T=366420 315960 0 180 $X=365180 $Y=310540
X230 78 2 628 1 INV1S $T=373240 295800 0 0 $X=373240 $Y=295420
X231 77 2 74 1 INV1S $T=394940 305880 0 0 $X=394940 $Y=305500
X232 618 2 663 1 INV1S $T=396180 265560 0 0 $X=396180 $Y=265180
X233 676 2 662 1 INV1S $T=401140 275640 1 0 $X=401140 $Y=270220
X234 91 2 678 1 INV1S $T=403000 285720 0 180 $X=401760 $Y=280300
X235 90 2 680 1 INV1S $T=403000 315960 0 0 $X=403000 $Y=315580
X236 687 2 671 1 INV1S $T=407340 265560 0 0 $X=407340 $Y=265180
X237 93 2 94 1 INV1S $T=409200 315960 0 0 $X=409200 $Y=315580
X238 691 2 689 1 INV1S $T=415400 235320 1 0 $X=415400 $Y=229900
X239 701 2 674 1 INV1S $T=415400 245400 1 0 $X=415400 $Y=239980
X240 724 2 101 1 INV1S $T=427800 285720 0 180 $X=426560 $Y=280300
X241 715 2 688 1 INV1S $T=430280 255480 0 0 $X=430280 $Y=255100
X242 730 2 732 1 INV1S $T=431520 285720 1 180 $X=430280 $Y=285340
X243 110 2 108 1 INV1S $T=439580 315960 0 180 $X=438340 $Y=310540
X244 757 2 106 1 INV1S $T=442060 295800 1 180 $X=440820 $Y=295420
X245 104 2 758 1 INV1S $T=442060 315960 1 0 $X=442060 $Y=310540
X246 760 2 749 1 INV1S $T=454460 265560 1 0 $X=454460 $Y=260140
X247 777 2 116 1 INV1S $T=458800 305880 1 180 $X=457560 $Y=305500
X248 792 2 765 1 INV1S $T=461900 305880 0 0 $X=461900 $Y=305500
X249 123 2 121 1 INV1S $T=469340 315960 1 180 $X=468100 $Y=315580
X250 790 2 771 1 INV1S $T=478020 275640 1 0 $X=478020 $Y=270220
X251 818 2 835 1 INV1S $T=485460 295800 0 0 $X=485460 $Y=295420
X252 860 2 864 1 INV1S $T=496620 265560 0 0 $X=496620 $Y=265180
X253 861 2 868 1 INV1S $T=496620 295800 1 0 $X=496620 $Y=290380
X254 887 2 923 1 INV1S $T=510260 255480 1 0 $X=510260 $Y=250060
X255 908 2 885 1 INV1S $T=513360 305880 1 0 $X=513360 $Y=300460
X256 894 2 892 1 INV1S $T=519560 275640 0 0 $X=519560 $Y=275260
X257 939 2 929 1 INV1S $T=526380 295800 1 180 $X=525140 $Y=295420
X258 126 2 831 1 INV1S $T=535060 285720 0 0 $X=535060 $Y=285340
X259 956 2 962 1 INV1S $T=538160 305880 0 0 $X=538160 $Y=305500
X260 944 2 969 1 INV1S $T=542500 305880 0 0 $X=542500 $Y=305500
X261 972 2 986 1 INV1S $T=546220 245400 0 0 $X=546220 $Y=245020
X262 981 2 973 1 INV1S $T=547460 315960 1 180 $X=546220 $Y=315580
X263 155 2 157 1 INV1S $T=550560 315960 1 0 $X=550560 $Y=310540
X264 996 2 1001 1 INV1S $T=563580 265560 1 0 $X=563580 $Y=260140
X265 161 2 764 1 INV1S $T=564200 305880 0 0 $X=564200 $Y=305500
X266 170 2 136 1 INV1S $T=572880 315960 1 180 $X=571640 $Y=315580
X267 168 2 889 1 INV1S $T=572260 305880 1 0 $X=572260 $Y=300460
X268 1025 2 88 1 INV1S $T=589000 305880 0 180 $X=587760 $Y=300460
X269 1024 2 1028 1 INV1S $T=594580 275640 1 180 $X=593340 $Y=275260
X270 179 2 180 1 INV1S $T=593340 315960 0 0 $X=593340 $Y=315580
X271 1035 2 1025 1 INV1S $T=593960 305880 1 0 $X=593960 $Y=300460
X272 178 2 775 1 INV1S $T=598920 295800 0 0 $X=598920 $Y=295420
X273 1025 2 183 1 INV1S $T=598920 305880 1 0 $X=598920 $Y=300460
X274 196 2 199 1 INV1S $T=625580 315960 1 0 $X=625580 $Y=310540
X275 1068 2 1081 1 INV1S $T=628680 265560 0 0 $X=628680 $Y=265180
X276 1067 2 1070 1 INV1S $T=628680 285720 0 0 $X=628680 $Y=285340
X277 1069 2 1077 1 INV1S $T=639220 285720 1 0 $X=639220 $Y=280300
X278 212 2 213 1 INV1S $T=657200 305880 1 180 $X=655960 $Y=305500
X279 255 2 1209 1 INV1S $T=734080 305880 1 180 $X=732840 $Y=305500
X280 265 2 1295 1 INV1S $T=794840 315960 0 0 $X=794840 $Y=315580
X281 291 2 1270 1 INV1S $T=799800 315960 1 180 $X=798560 $Y=315580
X282 262 2 1315 1 INV1S $T=871720 315960 0 0 $X=871720 $Y=315580
X283 1422 2 1402 1 INV1S $T=887220 265560 1 180 $X=885980 $Y=265180
X284 1426 2 1413 1 INV1S $T=889080 265560 1 180 $X=887840 $Y=265180
X285 1417 2 1420 1 INV1S $T=890940 285720 1 180 $X=889700 $Y=285340
X286 323 2 1424 1 INV1S $T=889700 315960 0 0 $X=889700 $Y=315580
X287 324 2 1433 1 INV1S $T=897760 285720 1 180 $X=896520 $Y=285340
X288 319 2 1461 1 INV1S $T=904580 315960 1 0 $X=904580 $Y=310540
X289 329 2 326 1 INV1S $T=905820 315960 1 180 $X=904580 $Y=315580
X290 331 2 335 1 INV1S $T=926280 315960 1 0 $X=926280 $Y=310540
X291 1488 2 301 1 INV1S $T=931240 225240 0 180 $X=930000 $Y=219820
X292 1485 2 1511 1 INV1S $T=940540 265560 0 0 $X=940540 $Y=265180
X293 1474 2 1517 1 INV1S $T=944880 285720 1 0 $X=944880 $Y=280300
X294 1490 2 1518 1 INV1S $T=951080 295800 0 0 $X=951080 $Y=295420
X295 1503 2 1523 1 INV1S $T=954800 285720 0 0 $X=954800 $Y=285340
X296 348 2 1521 1 INV1S $T=955420 315960 0 0 $X=955420 $Y=315580
X297 1527 2 1488 1 INV1S $T=960380 225240 0 180 $X=959140 $Y=219820
X298 350 2 1526 1 INV1S $T=959140 295800 0 0 $X=959140 $Y=295420
X299 1488 2 353 1 INV1S $T=967200 225240 1 0 $X=967200 $Y=219820
X300 446 428 2 430 438 1 28 FA1 $T=274660 305880 0 180 $X=259160 $Y=300460
X301 465 443 2 441 462 1 430 FA1 $T=284580 285720 1 180 $X=269080 $Y=285340
X302 428 448 2 466 474 1 41 FA1 $T=274040 305880 0 0 $X=274040 $Y=305500
X303 473 455 2 436 457 1 438 FA1 $T=290160 305880 0 180 $X=274660 $Y=300460
X304 483 471 2 464 491 1 457 FA1 $T=300700 275640 1 180 $X=285200 $Y=275260
X305 455 45 2 501 492 1 474 FA1 $T=292020 305880 0 0 $X=292020 $Y=305500
X306 481 478 2 489 508 1 462 FA1 $T=308140 285720 1 180 $X=292640 $Y=285340
X307 509 511 2 512 524 1 491 FA1 $T=318060 275640 1 180 $X=302560 $Y=275260
X308 766 786 2 789 751 1 872 FA1 $T=449500 225240 0 0 $X=449500 $Y=224860
X309 794 754 2 785 801 1 779 FA1 $T=469960 245400 1 180 $X=454460 $Y=245020
X310 799 822 2 821 795 1 834 FA1 $T=468720 255480 1 0 $X=468720 $Y=250060
X311 802 799 2 820 779 1 836 FA1 $T=469340 235320 0 0 $X=469340 $Y=234940
X312 809 825 2 824 813 1 838 FA1 $T=470580 295800 1 0 $X=470580 $Y=290380
X313 818 815 2 845 817 1 853 FA1 $T=476160 305880 1 0 $X=476160 $Y=300460
X314 826 806 2 850 832 1 866 FA1 $T=482360 255480 0 0 $X=482360 $Y=255100
X315 841 863 2 867 836 1 888 FA1 $T=487940 235320 0 0 $X=487940 $Y=234940
X316 839 802 2 873 782 1 912 FA1 $T=489800 235320 1 0 $X=489800 $Y=229900
X317 833 902 2 899 872 1 918 FA1 $T=500340 225240 1 0 $X=500340 $Y=219820
X318 924 903 2 901 888 1 886 FA1 $T=520800 245400 0 180 $X=505300 $Y=239980
X319 911 933 2 936 890 1 946 FA1 $T=515220 265560 1 0 $X=515220 $Y=260140
X320 910 930 2 937 912 1 958 FA1 $T=517080 235320 1 0 $X=517080 $Y=229900
X321 921 841 2 945 918 1 960 FA1 $T=518940 225240 1 0 $X=518940 $Y=219820
X322 972 953 2 948 865 1 942 FA1 $T=544980 245400 1 180 $X=529480 $Y=245020
X323 952 909 2 911 942 1 984 FA1 $T=535060 265560 1 0 $X=535060 $Y=260140
X324 961 924 2 958 960 1 1000 FA1 $T=538780 235320 1 0 $X=538780 $Y=229900
X325 976 986 2 927 951 1 996 FA1 $T=546220 255480 1 0 $X=546220 $Y=250060
X326 1095 206 2 1077 1074 1 1073 FA1 $T=649140 285720 1 180 $X=633640 $Y=285340
X327 1098 208 2 209 1073 1 202 FA1 $T=649140 315960 1 180 $X=633640 $Y=315580
X328 1108 1081 2 1078 1082 1 1074 FA1 $T=652240 265560 0 180 $X=636740 $Y=260140
X329 1169 1184 2 1185 238 1 1188 FA1 $T=691300 305880 1 0 $X=691300 $Y=300460
X330 1189 1177 2 1175 1188 1 1173 FA1 $T=708660 275640 0 180 $X=693160 $Y=270220
X331 1201 1182 2 1159 1173 1 1178 FA1 $T=713620 265560 1 180 $X=698120 $Y=265180
X332 1187 1198 2 1166 1178 1 1204 FA1 $T=704940 255480 1 0 $X=704940 $Y=250060
X333 1213 1195 2 1196 1204 1 1191 FA1 $T=724780 245400 0 180 $X=709280 $Y=239980
X334 1193 1209 2 248 1215 1 252 FA1 $T=713620 305880 0 0 $X=713620 $Y=305500
X335 1199 249 2 246 1192 1 1215 FA1 $T=716100 315960 0 0 $X=716100 $Y=315580
X336 1221 260 2 1098 1218 1 261 FA1 $T=737800 315960 0 0 $X=737800 $Y=315580
X337 263 1226 2 1227 1233 1 1225 FA1 $T=758260 285720 1 180 $X=742760 $Y=285340
X338 256 1228 2 1232 1225 1 264 FA1 $T=742760 305880 1 0 $X=742760 $Y=300460
X339 259 1231 2 1230 1214 1 1233 FA1 $T=744620 275640 0 0 $X=744620 $Y=275260
X340 1292 1271 2 1269 283 1 1262 FA1 $T=790500 305880 0 180 $X=775000 $Y=300460
X341 1288 1286 2 1267 1262 1 1313 FA1 $T=791120 285720 1 0 $X=791120 $Y=280300
X342 1314 1296 2 1265 1313 1 1289 FA1 $T=807240 265560 1 180 $X=791740 $Y=265180
X343 1318 1333 2 1309 1289 1 1344 FA1 $T=809100 265560 0 0 $X=809100 $Y=265180
X344 1346 1353 2 1321 1344 1 1364 FA1 $T=826460 265560 0 0 $X=826460 $Y=265180
X345 305 1359 2 1363 1337 1 1369 FA1 $T=829560 305880 1 0 $X=829560 $Y=300460
X346 1367 1375 2 1362 1364 1 1384 FA1 $T=843200 265560 0 0 $X=843200 $Y=265180
X347 312 1374 2 1372 1369 1 1370 FA1 $T=861800 305880 0 180 $X=846300 $Y=300460
X348 310 1382 2 1386 1370 1 314 FA1 $T=847540 305880 0 0 $X=847540 $Y=305500
X349 1398 313 2 1392 1391 1 1379 FA1 $T=872960 295800 0 180 $X=857460 $Y=290380
X350 1389 318 2 1397 1393 1 1401 FA1 $T=861180 285720 1 0 $X=861180 $Y=280300
X351 1373 1399 2 1402 1418 1 1396 FA1 $T=887220 255480 1 180 $X=871720 $Y=255100
X352 1355 1413 2 1416 1410 1 1418 FA1 $T=872340 275640 1 0 $X=872340 $Y=270220
X353 1397 1414 2 1409 1396 1 1448 FA1 $T=872960 245400 0 0 $X=872960 $Y=245020
X354 1392 1477 2 1479 1448 1 1516 FA1 $T=915740 235320 1 0 $X=915740 $Y=229900
X355 347 1524 2 1491 1516 1 1532 FA1 $T=951080 255480 1 0 $X=951080 $Y=250060
X356 344 1530 2 1531 1532 1 1535 FA1 $T=954180 265560 0 0 $X=954180 $Y=265180
X357 351 1538 2 1539 1535 1 356 FA1 $T=962240 305880 1 0 $X=962240 $Y=300460
X358 492 2 500 507 495 1 478 FA1S $T=303800 295800 1 180 $X=292020 $Y=295420
X359 49 2 522 53 521 1 507 FA1S $T=317440 315960 0 180 $X=305660 $Y=310540
X360 495 2 519 517 525 1 513 FA1S $T=319920 295800 0 180 $X=308140 $Y=290380
X361 508 2 534 513 528 1 511 FA1S $T=321160 285720 0 180 $X=309380 $Y=280300
X362 521 2 543 539 530 1 517 FA1S $T=322400 305880 0 180 $X=310620 $Y=300460
X363 524 2 554 537 549 1 533 FA1S $T=331700 275640 1 180 $X=319920 $Y=275260
X364 528 2 564 563 557 1 537 FA1S $T=336660 295800 0 180 $X=324880 $Y=290380
X365 525 2 548 561 532 1 563 FA1S $T=324880 295800 0 0 $X=324880 $Y=295420
X366 557 2 579 598 576 1 575 FA1S $T=352780 295800 0 180 $X=341000 $Y=290380
X367 549 2 574 575 600 1 593 FA1S $T=342240 285720 1 0 $X=342240 $Y=280300
X368 600 2 604 615 591 1 624 FA1S $T=356500 285720 1 0 $X=356500 $Y=280300
X369 632 2 622 617 626 1 644 FA1S $T=370760 295800 1 0 $X=370760 $Y=290380
X370 698 2 704 702 693 1 681 FA1S $T=417880 285720 0 180 $X=406100 $Y=280300
X371 699 2 703 690 709 1 712 FA1S $T=409200 265560 1 0 $X=409200 $Y=260140
X372 722 2 720 714 699 1 723 FA1S $T=419740 245400 1 0 $X=419740 $Y=239980
X373 736 2 726 727 739 1 714 FA1S $T=437100 255480 0 180 $X=425320 $Y=250060
X374 751 2 744 748 722 1 740 FA1S $T=436480 245400 1 0 $X=436480 $Y=239980
X375 754 2 752 738 745 1 770 FA1S $T=437720 255480 0 0 $X=437720 $Y=255100
X376 762 2 769 770 736 1 748 FA1S $T=451980 255480 0 180 $X=440200 $Y=250060
X377 782 2 793 794 762 1 786 FA1S $T=452600 235320 0 0 $X=452600 $Y=234940
X378 795 2 783 753 787 1 801 FA1S $T=457560 255480 0 0 $X=457560 $Y=255100
X379 806 2 807 798 804 1 822 FA1S $T=465620 265560 0 0 $X=465620 $Y=265180
X380 819 2 823 812 814 1 832 FA1S $T=472440 275640 0 0 $X=472440 $Y=275260
X381 830 2 842 826 834 1 863 FA1S $T=478640 245400 0 0 $X=478640 $Y=245020
X382 837 2 851 809 819 1 854 FA1S $T=482360 275640 1 0 $X=482360 $Y=270220
X383 846 2 852 835 838 1 862 FA1S $T=484220 285720 0 0 $X=484220 $Y=285340
X384 856 2 843 849 853 1 861 FA1S $T=489180 295800 0 0 $X=489180 $Y=295420
X385 860 2 857 854 866 1 878 FA1S $T=492900 265560 1 0 $X=492900 $Y=260140
X386 865 2 879 878 830 1 887 FA1S $T=494140 255480 1 0 $X=494140 $Y=250060
X387 871 2 859 889 848 1 849 FA1S $T=505920 305880 1 180 $X=494140 $Y=305500
X388 880 2 135 136 871 1 876 FA1S $T=499100 315960 1 0 $X=499100 $Y=310540
X389 883 2 870 868 846 1 906 FA1S $T=500340 285720 0 0 $X=500340 $Y=285340
X390 890 2 900 862 837 1 877 FA1S $T=501580 275640 0 0 $X=501580 $Y=275260
X391 891 2 805 876 856 1 908 FA1S $T=501580 305880 1 0 $X=501580 $Y=300460
X392 893 2 907 885 883 1 915 FA1S $T=502820 295800 1 0 $X=502820 $Y=290380
X393 904 2 874 896 886 1 917 FA1S $T=505920 255480 0 0 $X=505920 $Y=255100
X394 922 2 142 141 880 1 935 FA1S $T=514600 315960 1 0 $X=514600 $Y=310540
X395 925 2 919 935 891 1 939 FA1S $T=517080 305880 1 0 $X=517080 $Y=300460
X396 932 2 920 929 893 1 949 FA1S $T=520180 295800 1 0 $X=520180 $Y=290380
X397 944 2 905 955 925 1 956 FA1S $T=525760 305880 0 0 $X=525760 $Y=305500
X398 950 2 940 941 946 1 967 FA1S $T=528240 275640 1 0 $X=528240 $Y=270220
X399 149 2 147 151 922 1 955 FA1S $T=528240 315960 0 0 $X=528240 $Y=315580
X400 951 2 923 943 938 1 965 FA1S $T=528860 255480 1 0 $X=528860 $Y=250060
X401 959 2 954 914 932 1 968 FA1S $T=533200 295800 1 0 $X=533200 $Y=290380
X402 963 2 926 906 898 1 977 FA1S $T=535060 265560 0 0 $X=535060 $Y=265180
X403 964 2 947 913 950 1 978 FA1S $T=535680 285720 1 0 $X=535680 $Y=280300
X404 152 2 931 957 153 1 981 FA1S $T=538780 315960 1 0 $X=538780 $Y=310540
X405 974 2 962 968 964 1 985 FA1S $T=540640 285720 0 0 $X=540640 $Y=285340
X406 980 2 915 928 963 1 992 FA1S $T=543120 275640 1 0 $X=543120 $Y=270220
X407 155 2 969 973 959 1 991 FA1S $T=544980 305880 0 0 $X=544980 $Y=305500
X408 987 2 967 992 984 1 1004 FA1S $T=548700 265560 0 0 $X=548700 $Y=265180
X409 989 2 949 978 980 1 1002 FA1S $T=549940 285720 1 0 $X=549940 $Y=280300
X410 990 2 977 952 904 1 1006 FA1S $T=552420 255480 0 0 $X=552420 $Y=255100
X411 1069 2 1054 1065 1071 1 1068 FA1S $T=624340 285720 1 0 $X=624340 $Y=280300
X412 1082 2 1075 1079 1094 1 1096 FA1S $T=638600 275640 1 0 $X=638600 $Y=270220
X413 211 2 214 1080 1086 1 1078 FA1S $T=651000 305880 1 180 $X=639220 $Y=305500
X414 1094 2 1102 1106 1092 1 1083 FA1S $T=656580 285720 0 180 $X=644800 $Y=280300
X415 1100 2 1117 1087 1105 1 1084 FA1S $T=657820 255480 1 180 $X=646040 $Y=255100
X416 1104 2 1113 1130 1107 1 1087 FA1S $T=659680 245400 1 180 $X=647900 $Y=245020
X417 1111 2 1103 1093 1136 1 1124 FA1S $T=654100 235320 0 0 $X=654100 $Y=234940
X418 1117 2 1109 1120 1114 1 1131 FA1S $T=657200 265560 0 0 $X=657200 $Y=265180
X419 1105 2 1118 1126 1129 1 1112 FA1S $T=670220 285720 0 180 $X=658440 $Y=280300
X420 1126 2 225 1135 1123 1 1139 FA1S $T=662160 295800 1 0 $X=662160 $Y=290380
X421 1138 2 1127 1133 1132 1 1148 FA1S $T=667740 305880 0 0 $X=667740 $Y=305500
X422 1129 2 1137 1141 1145 1 1153 FA1S $T=671460 285720 0 0 $X=671460 $Y=285340
X423 1142 2 1147 1124 1104 1 1155 FA1S $T=672080 235320 0 0 $X=672080 $Y=234940
X424 1144 2 1140 1134 1146 1 1152 FA1S $T=673320 275640 1 0 $X=673320 $Y=270220
X425 1149 2 1138 1122 1160 1 1164 FA1S $T=677660 305880 1 0 $X=677660 $Y=300460
X426 1154 2 1144 1128 1158 1 1167 FA1S $T=679520 265560 0 0 $X=679520 $Y=265180
X427 1156 2 1153 1139 235 1 1168 FA1S $T=680140 295800 1 0 $X=680140 $Y=290380
X428 1159 2 1167 1084 1161 1 1177 FA1S $T=682000 255480 0 0 $X=682000 $Y=255100
X429 1160 2 1143 233 1151 1 1176 FA1S $T=682620 305880 0 0 $X=682620 $Y=305500
X430 1161 2 1152 1131 1149 1 1172 FA1S $T=683240 285720 1 0 $X=683240 $Y=280300
X431 1166 2 1154 1155 1100 1 1182 FA1S $T=686960 255480 1 0 $X=686960 $Y=250060
X432 1170 2 1157 1162 1165 1 1179 FA1S $T=687580 235320 0 0 $X=687580 $Y=234940
X433 1171 2 1176 1148 236 1 237 FA1S $T=687580 315960 1 0 $X=687580 $Y=310540
X434 1175 2 1112 1172 1156 1 1184 FA1S $T=690060 285720 0 0 $X=690060 $Y=285340
X435 1181 2 1170 1150 1174 1 1195 FA1S $T=695020 245400 0 0 $X=695020 $Y=245020
X436 1183 2 1083 1180 1189 1 1194 FA1S $T=696880 285720 1 0 $X=696880 $Y=280300
X437 1185 2 1164 1168 1171 1 242 FA1S $T=697500 305880 0 0 $X=697500 $Y=305500
X438 1192 2 244 239 241 1 1180 FA1S $T=714240 315960 1 180 $X=702460 $Y=315580
X439 1196 2 1111 1179 1142 1 1198 FA1S $T=708660 235320 0 0 $X=708660 $Y=234940
X440 1197 2 1108 1193 1187 1 1219 FA1S $T=708660 265560 1 0 $X=708660 $Y=260140
X441 1207 2 1096 1199 1201 1 1217 FA1S $T=717960 265560 0 0 $X=717960 $Y=265180
X442 1208 2 1202 1203 1205 1 250 FA1S $T=717960 295800 0 0 $X=717960 $Y=295420
X443 1212 2 1206 1200 1208 1 254 FA1S $T=723540 285720 1 0 $X=723540 $Y=280300
X444 1214 2 1220 1210 1212 1 257 FA1S $T=726020 275640 0 0 $X=726020 $Y=275260
X445 1216 2 1095 247 1213 1 1224 FA1S $T=727260 285720 0 0 $X=727260 $Y=285340
X446 1235 2 1247 1245 1238 1 1229 FA1S $T=764460 245400 1 180 $X=752680 $Y=245020
X447 1234 2 1229 1240 1246 1 1250 FA1S $T=753920 265560 0 0 $X=753920 $Y=265180
X448 1249 2 1261 1239 1252 1 1236 FA1S $T=771280 285720 1 180 $X=759500 $Y=285340
X449 1248 2 1242 1253 1235 1 1258 FA1S $T=761360 255480 0 0 $X=761360 $Y=255100
X450 1246 2 271 1243 1256 1 1259 FA1S $T=761360 305880 0 0 $X=761360 $Y=305500
X451 1253 2 1241 1263 1254 1 1240 FA1S $T=773760 275640 0 180 $X=761980 $Y=270220
X452 1261 2 1275 1279 1266 1 1255 FA1S $T=781820 275640 1 180 $X=770040 $Y=275260
X453 1264 2 1272 1255 279 1 1257 FA1S $T=783060 295800 0 180 $X=771280 $Y=290380
X454 1265 2 1258 1274 1234 1 1286 FA1S $T=773760 265560 0 0 $X=773760 $Y=265180
X455 1267 2 1236 1250 1264 1 1271 FA1S $T=773760 285720 0 0 $X=773760 $Y=285340
X456 1269 2 1259 1257 1273 1 286 FA1S $T=776240 305880 0 0 $X=776240 $Y=305500
X457 1273 2 1260 1287 285 1 276 FA1S $T=789260 315960 0 180 $X=777480 $Y=310540
X458 1280 2 1284 1290 1278 1 1268 FA1S $T=791740 235320 0 180 $X=779960 $Y=229900
X459 1285 2 1293 1268 1249 1 1274 FA1S $T=794840 255480 1 180 $X=783060 $Y=255100
X460 1252 2 1299 1294 1291 1 1272 FA1S $T=796700 295800 0 180 $X=784920 $Y=290380
X461 1256 2 1302 1308 1298 1 1287 FA1S $T=803520 305880 1 180 $X=791740 $Y=305500
X462 1301 2 1280 1306 1248 1 1312 FA1S $T=794220 235320 0 0 $X=794220 $Y=234940
X463 1309 2 1320 1312 1285 1 1296 FA1S $T=808480 265560 0 180 $X=796700 $Y=260140
X464 1311 2 1319 1297 1305 1 1293 FA1S $T=809100 275640 1 180 $X=797320 $Y=275260
X465 1310 2 1311 1303 1304 1 1320 FA1S $T=799800 255480 1 0 $X=799800 $Y=250060
X466 1307 2 1322 294 1314 1 1317 FA1S $T=803520 295800 0 0 $X=803520 $Y=295420
X467 1324 2 1334 1316 1326 1 296 FA1S $T=818400 305880 1 180 $X=806620 $Y=305500
X468 1326 2 1330 1336 299 1 297 FA1S $T=819640 315960 1 180 $X=807860 $Y=315580
X469 1321 2 1310 1331 1301 1 1333 FA1S $T=808480 245400 0 0 $X=808480 $Y=245020
X470 1332 2 1343 1339 1323 1 1306 FA1S $T=823980 235320 0 180 $X=812200 $Y=229900
X471 1337 2 1345 1327 1324 1 303 FA1S $T=816540 305880 1 0 $X=816540 $Y=300460
X472 1347 2 1349 302 1318 1 1351 FA1S $T=822740 285720 0 0 $X=822740 $Y=285340
X473 1350 2 1355 307 1346 1 1361 FA1S $T=826460 275640 1 0 $X=826460 $Y=270220
X474 1352 2 1354 1365 1332 1 1331 FA1S $T=838860 245400 1 180 $X=827080 $Y=245020
X475 1356 2 1360 1348 1338 1 1365 FA1S $T=832660 255480 0 0 $X=832660 $Y=255100
X476 1362 2 1356 1371 1352 1 1353 FA1S $T=845680 255480 0 180 $X=833900 $Y=250060
X477 1358 2 1292 306 1368 1 309 FA1S $T=833900 305880 0 0 $X=833900 $Y=305500
X478 1366 2 1373 308 1367 1 1381 FA1S $T=841960 275640 1 0 $X=841960 $Y=270220
X479 1388 2 1387 1378 1383 1 1375 FA1S $T=855600 255480 0 0 $X=855600 $Y=255100
X480 1387 2 1390 1377 1380 1 1371 FA1S $T=858080 235320 0 0 $X=858080 $Y=234940
X481 1400 2 1395 1407 1411 1 1416 FA1S $T=871100 265560 0 0 $X=871100 $Y=265180
X482 1409 2 1400 1425 1415 1 1399 FA1S $T=885980 255480 0 180 $X=874200 $Y=250060
X483 1410 2 1423 1431 1408 1 1349 FA1S $T=886600 295800 1 180 $X=874820 $Y=295420
X484 1408 2 1404 1419 1428 1 1322 FA1S $T=876060 305880 1 0 $X=876060 $Y=300460
X485 1422 2 1444 1427 1439 1 1426 FA1S $T=902100 275640 1 180 $X=890320 $Y=275260
X486 1438 2 1443 1429 1441 1 1415 FA1S $T=902720 255480 0 180 $X=890940 $Y=250060
X487 1456 2 1450 1453 1438 1 1469 FA1S $T=905820 245400 0 0 $X=905820 $Y=245020
X488 1462 2 1454 1449 1455 1 1425 FA1S $T=907680 255480 0 0 $X=907680 $Y=255100
X489 1465 2 1470 1451 1468 1 1450 FA1S $T=919460 275640 0 180 $X=907680 $Y=270220
X490 1474 2 1476 1471 1463 1 1485 FA1S $T=916980 285720 0 0 $X=916980 $Y=285340
X491 1483 2 1459 1484 1478 1 1473 FA1S $T=931860 265560 0 180 $X=920080 $Y=260140
X492 1479 2 1462 1469 1473 1 1414 FA1S $T=921320 245400 1 0 $X=921320 $Y=239980
X493 1480 2 1475 1457 1465 1 1492 FA1S $T=921940 275640 1 0 $X=921940 $Y=270220
X494 1491 2 1492 1495 1456 1 1477 FA1S $T=937440 245400 1 180 $X=925660 $Y=245020
X495 1490 2 1481 1486 1472 1 1503 FA1S $T=927520 295800 1 0 $X=927520 $Y=290380
X496 1497 2 1489 1482 1494 1 1512 FA1S $T=932480 285720 0 0 $X=932480 $Y=285340
X497 1506 2 1514 1511 1483 1 1495 FA1S $T=949220 255480 1 180 $X=937440 $Y=255100
X498 1502 2 1496 1500 1498 1 1514 FA1S $T=937440 275640 1 0 $X=937440 $Y=270220
X499 345 2 1501 1493 1504 1 1519 FA1S $T=940540 315960 0 0 $X=940540 $Y=315580
X500 1515 2 1499 1505 1513 1 1520 FA1S $T=944880 305880 1 0 $X=944880 $Y=300460
X501 349 2 1508 1510 1515 1 1528 FA1S $T=950460 315960 1 0 $X=950460 $Y=310540
X502 1522 2 1520 1509 1497 1 1534 FA1S $T=952320 295800 1 0 $X=952320 $Y=290380
X503 1525 2 1517 1507 1502 1 1533 FA1S $T=955420 275640 1 0 $X=955420 $Y=270220
X504 1531 2 1537 1533 1506 1 1524 FA1S $T=970300 265560 0 180 $X=958520 $Y=260140
X505 1529 2 1512 1523 1480 1 1537 FA1S $T=959140 285720 1 0 $X=959140 $Y=280300
X506 352 2 1519 1521 1522 1 1540 FA1S $T=962860 315960 0 0 $X=962860 $Y=315580
X507 354 2 1528 1540 1536 1 1538 FA1S $T=965340 315960 1 0 $X=965340 $Y=310540
X508 1536 2 1518 1526 1525 1 1542 FA1S $T=965960 295800 0 0 $X=965960 $Y=295420
X509 1539 2 1542 1534 1529 1 1530 FA1S $T=978360 285720 1 180 $X=966580 $Y=285340
X510 35 2 466 26 1 NR2 $T=271560 315960 0 180 $X=269700 $Y=310540
X511 36 2 443 437 1 NR2 $T=271560 285720 1 0 $X=271560 $Y=280300
X512 32 2 436 442 1 NR2 $T=272180 305880 0 0 $X=272180 $Y=305500
X513 35 2 441 444 1 NR2 $T=275280 295800 0 0 $X=275280 $Y=295420
X514 36 2 448 444 1 NR2 $T=275280 315960 0 0 $X=275280 $Y=315580
X515 35 2 464 437 1 NR2 $T=283340 285720 1 0 $X=283340 $Y=280300
X516 451 2 459 446 1 NR2 $T=284580 315960 0 0 $X=284580 $Y=315580
X517 36 2 471 442 1 NR2 $T=285200 285720 1 0 $X=285200 $Y=280300
X518 473 2 469 465 1 NR2 $T=288920 295800 1 180 $X=287060 $Y=295420
X519 35 2 470 442 1 NR2 $T=287680 275640 1 0 $X=287680 $Y=270220
X520 510 2 489 444 1 NR2 $T=306900 295800 0 180 $X=305040 $Y=290380
X521 47 2 501 43 1 NR2 $T=306900 315960 1 180 $X=305040 $Y=315580
X522 48 2 500 43 1 NR2 $T=307520 305880 0 180 $X=305660 $Y=300460
X523 510 2 512 437 1 NR2 $T=311240 275640 1 0 $X=311240 $Y=270220
X524 48 2 50 51 1 NR2 $T=311240 315960 0 0 $X=311240 $Y=315580
X525 52 2 519 43 1 NR2 $T=315580 295800 1 180 $X=313720 $Y=295420
X526 52 2 522 51 1 NR2 $T=316200 315960 1 180 $X=314340 $Y=315580
X527 54 2 532 43 1 NR2 $T=319300 295800 1 180 $X=317440 $Y=295420
X528 54 2 530 51 1 NR2 $T=319300 315960 1 180 $X=317440 $Y=315580
X529 510 2 540 442 1 NR2 $T=319920 275640 1 0 $X=319920 $Y=270220
X530 48 2 534 444 1 NR2 $T=323640 285720 1 0 $X=323640 $Y=280300
X531 550 2 539 538 1 NR2 $T=327360 305880 0 180 $X=325500 $Y=300460
X532 48 2 554 437 1 NR2 $T=328600 285720 1 0 $X=328600 $Y=280300
X533 61 2 58 546 1 NR2 $T=331080 315960 0 180 $X=329220 $Y=310540
X534 542 2 564 444 1 NR2 $T=336040 285720 0 180 $X=334180 $Y=280300
X535 542 2 574 437 1 NR2 $T=337900 275640 0 0 $X=337900 $Y=275260
X536 569 2 576 444 1 NR2 $T=339760 285720 1 180 $X=337900 $Y=285340
X537 582 2 561 559 1 NR2 $T=339760 305880 0 180 $X=337900 $Y=300460
X538 569 2 591 437 1 NR2 $T=348440 285720 1 180 $X=346580 $Y=285340
X539 588 2 590 442 1 NR2 $T=349680 265560 0 0 $X=349680 $Y=265180
X540 542 2 630 442 1 NR2 $T=354640 285720 1 180 $X=352780 $Y=285340
X541 74 2 598 599 1 NR2 $T=358360 295800 0 180 $X=356500 $Y=290380
X542 569 2 626 71 1 NR2 $T=368900 295800 0 180 $X=367040 $Y=290380
X543 628 2 615 611 1 NR2 $T=369520 295800 1 180 $X=367660 $Y=295420
X544 569 2 693 671 1 NR2 $T=409200 275640 0 0 $X=409200 $Y=275260
X545 678 2 690 695 1 NR2 $T=409820 265560 0 0 $X=409820 $Y=265180
X546 100 2 710 671 1 NR2 $T=419740 265560 1 180 $X=417880 $Y=265180
X547 686 2 709 708 1 NR2 $T=418500 255480 0 0 $X=418500 $Y=255100
X548 588 2 719 707 1 NR2 $T=419120 235320 0 0 $X=419120 $Y=234940
X549 100 2 720 708 1 NR2 $T=423460 245400 1 180 $X=421600 $Y=245020
X550 93 2 731 103 1 NR2 $T=427180 315960 1 180 $X=425320 $Y=315580
X551 732 2 738 728 1 NR2 $T=429660 275640 1 0 $X=429660 $Y=270220
X552 101 2 727 705 1 NR2 $T=432140 265560 0 180 $X=430280 $Y=260140
X553 588 2 744 708 1 NR2 $T=432760 235320 0 0 $X=432760 $Y=234940
X554 686 2 739 674 1 NR2 $T=434620 245400 0 180 $X=432760 $Y=239980
X555 105 2 104 100 1 NR2 $T=434620 305880 1 180 $X=432760 $Y=305500
X556 686 2 745 688 1 NR2 $T=434000 255480 0 0 $X=434000 $Y=255100
X557 759 2 741 707 1 NR2 $T=442060 235320 0 180 $X=440200 $Y=229900
X558 108 2 753 755 1 NR2 $T=441440 285720 1 0 $X=441440 $Y=280300
X559 759 2 789 708 1 NR2 $T=447020 235320 1 0 $X=447020 $Y=229900
X560 673 2 73 775 1 NR2 $T=450120 305880 1 0 $X=450120 $Y=300460
X561 114 2 772 106 1 NR2 $T=450120 305880 0 0 $X=450120 $Y=305500
X562 778 2 769 767 1 NR2 $T=452600 245400 1 180 $X=450740 $Y=245020
X563 686 2 787 749 1 NR2 $T=461280 265560 1 180 $X=459420 $Y=265180
X564 588 2 793 767 1 NR2 $T=462520 245400 1 0 $X=462520 $Y=239980
X565 778 2 785 791 1 NR2 $T=462520 255480 1 0 $X=462520 $Y=250060
X566 116 2 798 781 1 NR2 $T=463140 275640 1 0 $X=463140 $Y=270220
X567 686 2 804 771 1 NR2 $T=468100 275640 1 0 $X=468100 $Y=270220
X568 121 2 812 692 1 NR2 $T=469960 285720 1 0 $X=469960 $Y=280300
X569 124 2 815 106 1 NR2 $T=472440 305880 0 180 $X=470580 $Y=300460
X570 124 2 813 765 1 NR2 $T=471200 295800 0 0 $X=471200 $Y=295420
X571 686 2 814 662 1 NR2 $T=471820 275640 1 0 $X=471820 $Y=270220
X572 588 2 820 791 1 NR2 $T=474300 245400 0 0 $X=474300 $Y=245020
X573 778 2 821 816 1 NR2 $T=476780 255480 0 0 $X=476780 $Y=255100
X574 828 2 797 707 1 NR2 $T=480500 235320 0 180 $X=478640 $Y=229900
X575 831 2 825 803 1 NR2 $T=482360 285720 0 180 $X=480500 $Y=280300
X576 131 2 133 125 1 NR2 $T=482980 315960 0 0 $X=482980 $Y=315580
X577 588 2 842 816 1 NR2 $T=489180 255480 1 0 $X=489180 $Y=250060
X578 778 2 850 847 1 NR2 $T=489180 265560 1 0 $X=489180 $Y=260140
X579 778 2 851 662 1 NR2 $T=489180 275640 0 0 $X=489180 $Y=275260
X580 125 2 852 855 1 NR2 $T=489800 295800 1 0 $X=489800 $Y=290380
X581 858 2 867 791 1 NR2 $T=494140 245400 0 180 $X=492280 $Y=239980
X582 778 2 859 134 1 NR2 $T=494760 315960 1 0 $X=494760 $Y=310540
X583 125 2 857 847 1 NR2 $T=497860 275640 1 0 $X=497860 $Y=270220
X584 137 2 870 855 1 NR2 $T=501580 285720 0 180 $X=499720 $Y=280300
X585 858 2 873 767 1 NR2 $T=500960 245400 1 0 $X=500960 $Y=239980
X586 858 2 879 816 1 NR2 $T=500960 255480 0 0 $X=500960 $Y=255100
X587 828 2 899 708 1 NR2 $T=509020 235320 1 180 $X=507160 $Y=234940
X588 137 2 900 847 1 NR2 $T=507160 285720 1 0 $X=507160 $Y=280300
X589 828 2 901 791 1 NR2 $T=509640 245400 0 0 $X=509640 $Y=245020
X590 130 2 907 855 1 NR2 $T=514600 285720 0 0 $X=514600 $Y=285340
X591 916 2 902 707 1 NR2 $T=517700 235320 1 180 $X=515840 $Y=234940
X592 916 2 903 767 1 NR2 $T=517700 245400 1 180 $X=515840 $Y=245020
X593 130 2 894 816 1 NR2 $T=517700 275640 0 0 $X=517700 $Y=275260
X594 145 2 920 855 1 NR2 $T=520800 285720 0 180 $X=518940 $Y=280300
X595 916 2 930 708 1 NR2 $T=523280 235320 1 180 $X=521420 $Y=234940
X596 934 2 926 791 1 NR2 $T=524520 255480 0 180 $X=522660 $Y=250060
X597 916 2 933 816 1 NR2 $T=524520 255480 0 0 $X=524520 $Y=255100
X598 130 2 936 847 1 NR2 $T=524520 275640 1 0 $X=524520 $Y=270220
X599 916 2 940 847 1 NR2 $T=524520 275640 0 0 $X=524520 $Y=275260
X600 828 2 937 767 1 NR2 $T=525140 235320 0 0 $X=525140 $Y=234940
X601 916 2 948 791 1 NR2 $T=525140 245400 1 0 $X=525140 $Y=239980
X602 148 2 150 765 1 NR2 $T=529480 315960 0 180 $X=527620 $Y=310540
X603 934 2 941 816 1 NR2 $T=531340 265560 1 180 $X=529480 $Y=265180
X604 148 2 943 707 1 NR2 $T=530720 255480 0 0 $X=530720 $Y=255100
X605 934 2 947 847 1 NR2 $T=532580 285720 0 180 $X=530720 $Y=280300
X606 934 2 945 707 1 NR2 $T=533820 235320 1 180 $X=531960 $Y=234940
X607 148 2 957 855 1 NR2 $T=533820 315960 1 0 $X=533820 $Y=310540
X608 934 2 954 855 1 NR2 $T=538160 305880 0 180 $X=536300 $Y=300460
X609 934 2 953 767 1 NR2 $T=538780 245400 1 0 $X=538780 $Y=239980
X610 921 2 966 910 1 NR2 $T=539400 225240 1 0 $X=539400 $Y=219820
X611 970 2 999 961 1 NR2 $T=555520 225240 1 0 $X=555520 $Y=219820
X612 1005 2 1010 1000 1 NR2 $T=566680 235320 1 180 $X=564820 $Y=234940
X613 88 2 161 166 1 NR2 $T=566060 315960 1 0 $X=566060 $Y=310540
X614 173 2 1035 178 1 NR2 $T=592100 305880 1 0 $X=592100 $Y=300460
X615 1038 2 1036 1040 1 NR2 $T=595200 285720 1 0 $X=595200 $Y=280300
X616 186 2 1039 775 1 NR2 $T=603880 295800 0 180 $X=602020 $Y=290380
X617 775 2 1040 1045 1 NR2 $T=602640 285720 1 0 $X=602640 $Y=280300
X618 1039 2 187 184 1 NR2 $T=604500 315960 0 0 $X=604500 $Y=315580
X619 1057 2 193 1056 1 NR2 $T=618760 305880 0 0 $X=618760 $Y=305500
X620 199 2 1072 205 1 NR2 $T=631780 305880 0 0 $X=631780 $Y=305500
X621 200 2 201 204 1 NR2 $T=631780 315960 1 0 $X=631780 $Y=310540
X622 200 2 1080 207 1 NR2 $T=637360 315960 1 0 $X=637360 $Y=310540
X623 200 2 1062 1088 1 NR2 $T=643560 295800 1 0 $X=643560 $Y=290380
X624 1085 2 1093 1089 1 NR2 $T=646660 245400 1 0 $X=646660 $Y=239980
X625 213 2 1086 1088 1 NR2 $T=649140 315960 1 0 $X=649140 $Y=310540
X626 215 2 1103 1119 1 NR2 $T=652240 245400 1 0 $X=652240 $Y=239980
X627 213 2 1092 205 1 NR2 $T=652240 305880 0 0 $X=652240 $Y=305500
X628 219 2 1090 1088 1 NR2 $T=655960 305880 1 0 $X=655960 $Y=300460
X629 1115 2 1113 1085 1 NR2 $T=660300 265560 0 180 $X=658440 $Y=260140
X630 1101 2 1102 1097 1 NR2 $T=658440 295800 1 0 $X=658440 $Y=290380
X631 1116 2 1114 224 1 NR2 $T=660920 275640 0 0 $X=660920 $Y=275260
X632 1115 2 1123 1119 1 NR2 $T=661540 305880 1 0 $X=661540 $Y=300460
X633 1115 2 1120 1125 1 NR2 $T=664020 265560 1 0 $X=664020 $Y=260140
X634 1089 2 1109 1119 1 NR2 $T=665880 275640 0 180 $X=664020 $Y=270220
X635 1088 2 1127 1119 1 NR2 $T=664020 305880 0 0 $X=664020 $Y=305500
X636 1089 2 1128 1125 1 NR2 $T=667120 265560 1 0 $X=667120 $Y=260140
X637 1088 2 1135 226 1 NR2 $T=667120 285720 0 0 $X=667120 $Y=285340
X638 207 2 1132 224 1 NR2 $T=667120 305880 1 0 $X=667120 $Y=300460
X639 1088 2 1134 216 1 NR2 $T=667740 275640 0 0 $X=667740 $Y=275260
X640 227 2 1118 223 1 NR2 $T=669600 315960 0 180 $X=667740 $Y=310540
X641 215 2 1130 224 1 NR2 $T=669600 245400 1 0 $X=669600 $Y=239980
X642 229 2 1133 1089 1 NR2 $T=673320 305880 0 180 $X=671460 $Y=300460
X643 229 2 1107 1110 1 NR2 $T=674560 265560 0 180 $X=672700 $Y=260140
X644 1110 2 1136 224 1 NR2 $T=675180 245400 0 180 $X=673320 $Y=239980
X645 229 2 1140 215 1 NR2 $T=673320 275640 0 0 $X=673320 $Y=275260
X646 1089 2 1137 224 1 NR2 $T=675180 285720 0 180 $X=673320 $Y=280300
X647 205 2 1143 216 1 NR2 $T=674560 315960 0 0 $X=674560 $Y=315580
X648 230 2 1141 216 1 NR2 $T=677660 295800 1 180 $X=675800 $Y=295420
X649 1116 2 1147 1125 1 NR2 $T=677660 225240 0 0 $X=677660 $Y=224860
X650 1085 2 1150 215 1 NR2 $T=679520 255480 0 180 $X=677660 $Y=250060
X651 231 2 1146 1110 1 NR2 $T=678900 275640 0 0 $X=678900 $Y=275260
X652 229 2 1145 1116 1 NR2 $T=678900 285720 1 0 $X=678900 $Y=280300
X653 231 2 1151 1116 1 NR2 $T=678900 315960 1 0 $X=678900 $Y=310540
X654 231 2 232 1089 1 NR2 $T=680760 315960 1 180 $X=678900 $Y=315580
X655 1110 2 1165 1119 1 NR2 $T=682000 245400 1 0 $X=682000 $Y=239980
X656 215 2 1157 1125 1 NR2 $T=685100 245400 0 0 $X=685100 $Y=245020
X657 1116 2 1158 1119 1 NR2 $T=690060 275640 0 180 $X=688200 $Y=270220
X658 1085 2 1162 1116 1 NR2 $T=692540 235320 0 180 $X=690680 $Y=229900
X659 1110 2 1174 1125 1 NR2 $T=690680 245400 0 0 $X=690680 $Y=245020
X660 1186 2 1190 1121 1 NR2 $T=705560 285720 0 0 $X=705560 $Y=285340
X661 1200 2 1202 1190 1 NR2 $T=720440 285720 1 180 $X=718580 $Y=285340
X662 1222 2 253 245 1 NR2 $T=735940 305880 0 180 $X=734080 $Y=300460
X663 1181 2 1222 1191 1 NR2 $T=737180 245400 0 0 $X=737180 $Y=245020
X664 1237 2 1242 1244 1 NR2 $T=761360 295800 1 0 $X=761360 $Y=290380
X665 269 2 1247 277 1 NR2 $T=768180 245400 1 0 $X=768180 $Y=239980
X666 1251 2 1241 266 1 NR2 $T=770040 295800 0 0 $X=770040 $Y=295420
X667 274 2 1245 1085 1 NR2 $T=773140 255480 0 180 $X=771280 $Y=250060
X668 1270 2 1266 277 1 NR2 $T=781200 275640 0 180 $X=779340 $Y=270220
X669 282 2 280 1270 1 NR2 $T=781200 315960 1 180 $X=779340 $Y=315580
X670 282 2 1238 281 1 NR2 $T=781820 255480 0 180 $X=779960 $Y=250060
X671 1270 2 1254 1276 1 NR2 $T=782440 275640 1 0 $X=782440 $Y=270220
X672 1282 2 284 277 1 NR2 $T=784920 315960 1 180 $X=783060 $Y=315580
X673 1277 2 1275 1276 1 NR2 $T=787400 275640 1 180 $X=785540 $Y=275260
X674 1277 2 1263 287 1 NR2 $T=786160 275640 1 0 $X=786160 $Y=270220
X675 282 2 1279 269 1 NR2 $T=786780 285720 0 0 $X=786780 $Y=285340
X676 269 2 1284 1276 1 NR2 $T=788640 245400 1 0 $X=788640 $Y=239980
X677 1270 2 1290 287 1 NR2 $T=788640 255480 1 0 $X=788640 $Y=250060
X678 1283 2 1278 277 1 NR2 $T=791120 245400 1 180 $X=789260 $Y=245020
X679 274 2 1294 287 1 NR2 $T=789260 285720 0 0 $X=789260 $Y=285340
X680 1277 2 1297 1281 1 NR2 $T=791740 275640 0 0 $X=791740 $Y=275260
X681 282 2 289 1282 1 NR2 $T=791740 315960 0 0 $X=791740 $Y=315580
X682 1295 2 1291 281 1 NR2 $T=796080 285720 1 180 $X=794220 $Y=285340
X683 1295 2 1298 269 1 NR2 $T=796700 305880 0 180 $X=794840 $Y=300460
X684 1295 2 290 1270 1 NR2 $T=795460 315960 1 0 $X=795460 $Y=310540
X685 1283 2 1304 1276 1 NR2 $T=799800 245400 1 180 $X=797940 $Y=245020
X686 292 2 1299 1281 1 NR2 $T=799800 295800 0 180 $X=797940 $Y=290380
X687 292 2 1302 287 1 NR2 $T=801660 295800 1 180 $X=799800 $Y=295420
X688 288 2 1308 295 1 NR2 $T=801040 315960 1 0 $X=801040 $Y=310540
X689 269 2 1303 1300 1 NR2 $T=802900 235320 1 0 $X=802900 $Y=229900
X690 1295 2 1305 1315 1 NR2 $T=803520 285720 0 0 $X=803520 $Y=285340
X691 292 2 293 295 1 NR2 $T=803520 315960 0 0 $X=803520 $Y=315580
X692 282 2 1319 1325 1 NR2 $T=812200 275640 0 0 $X=812200 $Y=275260
X693 282 2 1323 1315 1 NR2 $T=812820 245400 1 0 $X=812820 $Y=239980
X694 1325 2 1339 277 1 NR2 $T=820260 245400 0 180 $X=818400 $Y=239980
X695 1315 2 1338 277 1 NR2 $T=820260 255480 0 180 $X=818400 $Y=250060
X696 1281 2 1348 1329 1 NR2 $T=822740 255480 1 180 $X=820880 $Y=255100
X697 1336 2 300 1342 1 NR2 $T=823360 315960 1 0 $X=823360 $Y=310540
X698 1341 2 1343 1281 1 NR2 $T=823980 255480 1 0 $X=823980 $Y=250060
X699 1335 2 1342 1340 1 NR2 $T=828320 305880 0 0 $X=828320 $Y=305500
X700 1283 2 1354 1300 1 NR2 $T=832040 235320 0 0 $X=832040 $Y=234940
X701 1325 2 1360 1276 1 NR2 $T=838860 265560 1 0 $X=838860 $Y=260140
X702 1315 2 1380 1276 1 NR2 $T=843820 235320 1 180 $X=841960 $Y=234940
X703 1281 2 1377 1283 1 NR2 $T=846920 245400 0 0 $X=846920 $Y=245020
X704 1281 2 1378 1325 1 NR2 $T=851260 255480 0 0 $X=851260 $Y=255100
X705 1315 2 1383 1300 1 NR2 $T=855600 255480 1 0 $X=855600 $Y=250060
X706 1325 2 1390 1300 1 NR2 $T=866140 255480 0 180 $X=864280 $Y=250060
X707 1388 2 1394 1384 1 NR2 $T=868000 265560 0 180 $X=866140 $Y=260140
X708 1394 2 1391 311 1 NR2 $T=868000 275640 0 180 $X=866140 $Y=270220
X709 317 2 1395 1329 1 NR2 $T=869240 265560 1 180 $X=867380 $Y=265180
X710 317 2 1368 1424 1 NR2 $T=883500 315960 0 0 $X=883500 $Y=315580
X711 1421 2 1404 1412 1 NR2 $T=887220 315960 1 0 $X=887220 $Y=310540
X712 1433 2 1407 1341 1 NR2 $T=894040 265560 1 180 $X=892180 $Y=265180
X713 1433 2 1406 1282 1 NR2 $T=894660 285720 0 180 $X=892800 $Y=280300
X714 317 2 1432 1282 1 NR2 $T=892800 305880 1 0 $X=892800 $Y=300460
X715 317 2 1429 1283 1 NR2 $T=893420 265560 1 0 $X=893420 $Y=260140
X716 1437 2 1411 1436 1 NR2 $T=897760 265560 1 180 $X=895900 $Y=265180
X717 325 2 1428 1424 1 NR2 $T=899000 305880 0 180 $X=897140 $Y=300460
X718 1437 2 1443 1341 1 NR2 $T=898380 265560 1 0 $X=898380 $Y=260140
X719 326 2 1441 1436 1 NR2 $T=901480 275640 0 180 $X=899620 $Y=270220
X720 326 2 1435 1424 1 NR2 $T=901480 305880 0 180 $X=899620 $Y=300460
X721 1433 2 1455 1329 1 NR2 $T=903960 265560 1 0 $X=903960 $Y=260140
X722 317 2 1451 1325 1 NR2 $T=904580 275640 1 0 $X=904580 $Y=270220
X723 1446 2 1449 1445 1 NR2 $T=907060 285720 1 180 $X=905200 $Y=285340
X724 1452 2 1459 1460 1 NR2 $T=910160 265560 0 0 $X=910160 $Y=265180
X725 335 2 1468 1436 1 NR2 $T=918840 305880 0 180 $X=916980 $Y=300460
X726 1433 2 1470 339 1 NR2 $T=917600 265560 0 0 $X=917600 $Y=265180
X727 1464 2 1457 1458 1 NR2 $T=918220 285720 1 0 $X=918220 $Y=280300
X728 341 2 1466 1436 1 NR2 $T=924420 305880 0 180 $X=922560 $Y=300460
X729 342 2 1471 1424 1 NR2 $T=924420 305880 1 180 $X=922560 $Y=305500
X730 342 2 340 1436 1 NR2 $T=924420 315960 0 180 $X=922560 $Y=310540
X731 341 2 1482 1341 1 NR2 $T=923800 295800 1 0 $X=923800 $Y=290380
X732 326 2 1478 1341 1 NR2 $T=926900 265560 1 180 $X=925040 $Y=265180
X733 1437 2 1484 1329 1 NR2 $T=928140 265560 0 0 $X=928140 $Y=265180
X734 342 2 1486 288 1 NR2 $T=929380 305880 1 0 $X=929380 $Y=300460
X735 326 2 1489 339 1 NR2 $T=930620 285720 1 0 $X=930620 $Y=280300
X736 326 2 1493 321 1 NR2 $T=931240 315960 1 0 $X=931240 $Y=310540
X737 1437 2 1494 328 1 NR2 $T=935580 285720 0 180 $X=933720 $Y=280300
X738 1437 2 1496 339 1 NR2 $T=934340 265560 0 0 $X=934340 $Y=265180
X739 343 2 1498 288 1 NR2 $T=936200 295800 1 180 $X=934340 $Y=295420
X740 1437 2 1499 321 1 NR2 $T=936200 305880 0 180 $X=934340 $Y=300460
X741 341 2 1501 339 1 NR2 $T=934340 305880 0 0 $X=934340 $Y=305500
X742 335 2 1508 328 1 NR2 $T=936820 315960 1 0 $X=936820 $Y=310540
X743 1433 2 1500 328 1 NR2 $T=938060 285720 1 0 $X=938060 $Y=280300
X744 341 2 1505 1329 1 NR2 $T=939920 305880 1 0 $X=939920 $Y=300460
X745 343 2 1513 1341 1 NR2 $T=942400 295800 1 180 $X=940540 $Y=295420
X746 343 2 1504 1329 1 NR2 $T=942400 305880 1 180 $X=940540 $Y=305500
X747 1467 2 1509 1487 1 NR2 $T=949220 285720 0 0 $X=949220 $Y=285340
X748 483 481 2 1 479 OR2 $T=295120 275640 0 180 $X=292640 $Y=270220
X749 839 833 2 1 829 OR2 $T=494760 225240 1 0 $X=494760 $Y=219820
X750 1027 1024 2 1 173 OR2 $T=590240 285720 1 180 $X=587760 $Y=285340
X751 1027 1028 2 1 175 OR2 $T=590860 285720 0 180 $X=588380 $Y=280300
X752 1053 183 2 1 1059 OR2 $T=615040 285720 0 0 $X=615040 $Y=285340
X753 473 475 465 2 1 ND2S $T=289540 285720 1 180 $X=287680 $Y=285340
X754 483 485 481 2 1 ND2S $T=295120 265560 1 180 $X=293260 $Y=265180
X755 479 497 485 2 1 ND2S $T=301320 265560 1 180 $X=299460 $Y=265180
X756 55 538 535 2 1 ND2S $T=319920 315960 1 0 $X=319920 $Y=310540
X757 57 546 535 2 1 ND2S $T=327360 315960 1 180 $X=325500 $Y=315580
X758 31 559 535 2 1 ND2S $T=329220 315960 0 0 $X=329220 $Y=315580
X759 75 599 76 2 1 ND2S $T=358980 315960 1 0 $X=358980 $Y=310540
X760 33 611 76 2 1 ND2S $T=363320 315960 1 0 $X=363320 $Y=310540
X761 80 627 76 2 1 ND2S $T=373860 315960 1 0 $X=373860 $Y=310540
X762 642 653 79 2 1 ND2S $T=386880 315960 0 180 $X=385020 $Y=310540
X763 676 692 680 2 1 ND2S $T=407340 275640 0 180 $X=405480 $Y=270220
X764 691 695 680 2 1 ND2S $T=411060 255480 1 180 $X=409200 $Y=255100
X765 697 696 95 2 1 ND2S $T=412920 305880 1 0 $X=412920 $Y=300460
X766 687 700 680 2 1 ND2S $T=413540 285720 0 0 $X=413540 $Y=285340
X767 701 705 680 2 1 ND2S $T=416640 255480 1 180 $X=414780 $Y=255100
X768 731 763 105 2 1 ND2S $T=431520 315960 0 0 $X=431520 $Y=315580
X769 715 728 735 2 1 ND2S $T=435860 275640 0 0 $X=435860 $Y=275260
X770 758 113 763 2 1 ND2S $T=448880 315960 1 180 $X=447020 $Y=315580
X771 760 755 735 2 1 ND2S $T=447640 275640 0 0 $X=447640 $Y=275260
X772 115 788 763 2 1 ND2S $T=452600 315960 0 180 $X=450740 $Y=310540
X773 788 119 758 2 1 ND2S $T=458180 315960 1 180 $X=456320 $Y=315580
X774 790 781 735 2 1 ND2S $T=461900 285720 0 180 $X=460040 $Y=280300
X775 96 120 93 2 1 ND2S $T=464380 315960 1 180 $X=462520 $Y=315580
X776 792 803 735 2 1 ND2S $T=466860 285720 0 180 $X=465000 $Y=280300
X777 811 805 122 2 1 ND2S $T=470580 305880 1 180 $X=468720 $Y=305500
X778 829 808 840 2 1 ND2S $T=482980 225240 1 0 $X=482980 $Y=219820
X779 833 840 839 2 1 ND2S $T=489180 225240 1 0 $X=489180 $Y=219820
X780 811 843 94 2 1 ND2S $T=491040 315960 1 180 $X=489180 $Y=315580
X781 869 874 875 2 1 ND2S $T=500960 265560 0 0 $X=500960 $Y=265180
X782 881 882 895 2 1 ND2S $T=504060 275640 1 0 $X=504060 $Y=270220
X783 864 895 892 2 1 ND2S $T=505920 275640 1 0 $X=505920 $Y=270220
X784 895 897 877 2 1 ND2S $T=507780 275640 1 0 $X=507780 $Y=270220
X785 811 905 138 2 1 ND2S $T=510260 305880 1 180 $X=508400 $Y=305500
X786 140 909 701 2 1 ND2S $T=512740 265560 0 180 $X=510880 $Y=260140
X787 140 144 139 2 1 ND2S $T=514600 315960 1 180 $X=512740 $Y=315580
X788 140 914 790 2 1 ND2S $T=515220 285720 0 180 $X=513360 $Y=280300
X789 811 919 112 2 1 ND2S $T=516460 305880 1 180 $X=514600 $Y=305500
X790 140 913 760 2 1 ND2S $T=517700 275640 1 180 $X=515840 $Y=275260
X791 691 938 143 2 1 ND2S $T=518940 245400 0 0 $X=518940 $Y=245020
X792 140 928 715 2 1 ND2S $T=520800 275640 0 180 $X=518940 $Y=270220
X793 811 931 143 2 1 ND2S $T=522660 305880 1 180 $X=520800 $Y=305500
X794 921 975 910 2 1 ND2S $T=544980 225240 0 180 $X=543120 $Y=219820
X795 173 673 176 2 1 ND2S $T=587140 295800 0 0 $X=587140 $Y=295420
X796 1031 1030 1026 2 1 ND2S $T=591480 255480 0 180 $X=589620 $Y=250060
X797 1031 1034 1038 2 1 ND2S $T=600780 265560 0 180 $X=598920 $Y=260140
X798 186 190 182 2 1 ND2S $T=610080 315960 1 180 $X=608220 $Y=315580
X799 192 1056 194 2 1 ND2S $T=620620 315960 0 0 $X=620620 $Y=315580
X800 197 1061 195 2 1 ND2S $T=626820 305880 0 180 $X=624960 $Y=300460
X801 196 1057 1066 2 1 ND2S $T=625580 305880 0 0 $X=625580 $Y=305500
X802 212 1076 1066 2 1 ND2S $T=639220 305880 0 180 $X=637360 $Y=300460
X803 197 1097 1066 2 1 ND2S $T=651000 295800 0 180 $X=649140 $Y=290380
X804 210 1091 1066 2 1 ND2S $T=651000 295800 1 180 $X=649140 $Y=295420
X805 210 1101 194 2 1 ND2S $T=652860 315960 0 0 $X=652860 $Y=315580
X806 265 1237 268 2 1 ND2S $T=760740 315960 1 180 $X=758880 $Y=315580
X807 267 1244 262 2 1 ND2S $T=761360 315960 0 180 $X=759500 $Y=310540
X808 267 1251 268 2 1 ND2S $T=765080 315960 1 0 $X=765080 $Y=310540
X809 268 270 272 2 1 ND2S $T=770660 315960 0 0 $X=770660 $Y=315580
X810 273 275 278 2 1 ND2S $T=774380 315960 0 0 $X=774380 $Y=315580
X811 322 1405 320 2 1 ND2S $T=879780 295800 0 180 $X=877920 $Y=290380
X812 322 1412 1440 2 1 ND2S $T=892180 315960 0 0 $X=892180 $Y=315580
X813 324 1430 1440 2 1 ND2S $T=897140 315960 0 0 $X=897140 $Y=315580
X814 324 1421 1447 2 1 ND2S $T=899000 315960 1 0 $X=899000 $Y=310540
X815 331 1445 1447 2 1 ND2S $T=903340 295800 0 180 $X=901480 $Y=290380
X816 327 1434 1442 2 1 ND2S $T=901480 295800 0 0 $X=901480 $Y=295420
X817 329 1446 1440 2 1 ND2S $T=908300 295800 1 180 $X=906440 $Y=295420
X818 331 1452 1440 2 1 ND2S $T=909540 295800 0 180 $X=907680 $Y=290380
X819 336 1460 1447 2 1 ND2S $T=912020 285720 1 180 $X=910160 $Y=285340
X820 324 1467 337 2 1 ND2S $T=910160 295800 0 0 $X=910160 $Y=295420
X821 332 1458 1447 2 1 ND2S $T=912020 305880 1 180 $X=910160 $Y=305500
X822 329 1463 334 2 1 ND2S $T=910780 305880 1 0 $X=910780 $Y=300460
X823 331 330 278 2 1 ND2S $T=912640 315960 1 180 $X=910780 $Y=315580
X824 331 1476 320 2 1 ND2S $T=925660 285720 1 0 $X=925660 $Y=280300
X825 331 1481 334 2 1 ND2S $T=927520 305880 1 0 $X=927520 $Y=300460
X826 332 1487 1461 2 1 ND2S $T=930000 305880 1 180 $X=928140 $Y=305500
X827 346 1510 320 2 1 ND2S $T=947980 315960 0 180 $X=946120 $Y=310540
X828 392 12 2 1 387 9 MUX2 $T=229400 315960 1 180 $X=225060 $Y=315580
X829 401 12 2 1 389 17 MUX2 $T=242420 305880 1 180 $X=238080 $Y=305500
X830 413 420 2 1 390 398 MUX2 $T=256060 275640 1 180 $X=251720 $Y=275260
X831 421 420 2 1 410 407 MUX2 $T=260400 265560 1 180 $X=256060 $Y=265180
X832 429 432 2 1 409 421 MUX2 $T=264120 245400 0 180 $X=259780 $Y=239980
X833 440 420 2 1 431 423 MUX2 $T=270940 275640 0 180 $X=266600 $Y=270220
X834 427 420 2 1 439 413 MUX2 $T=268460 255480 0 0 $X=268460 $Y=255100
X835 458 463 2 1 450 435 MUX2 $T=282100 235320 1 180 $X=277760 $Y=234940
X836 456 432 2 1 472 453 MUX2 $T=282720 265560 1 0 $X=282720 $Y=260140
X837 476 463 2 1 467 456 MUX2 $T=289540 255480 0 180 $X=285200 $Y=250060
X838 502 490 2 1 477 458 MUX2 $T=298220 235320 0 180 $X=293880 $Y=229900
X839 529 490 2 1 504 506 MUX2 $T=311860 235320 1 180 $X=307520 $Y=234940
X840 506 490 2 1 527 514 MUX2 $T=313720 255480 1 0 $X=313720 $Y=250060
X841 566 553 2 1 536 429 MUX2 $T=327360 235320 1 180 $X=323020 $Y=234940
X842 556 553 2 1 526 502 MUX2 $T=328600 235320 0 180 $X=324260 $Y=229900
X843 565 487 2 1 547 440 MUX2 $T=333560 265560 0 180 $X=329220 $Y=260140
X844 585 553 2 1 562 529 MUX2 $T=342240 235320 0 180 $X=337900 $Y=229900
X845 584 552 2 1 571 476 MUX2 $T=344720 265560 0 180 $X=340380 $Y=260140
X846 595 552 2 1 587 427 MUX2 $T=354020 265560 0 180 $X=349680 $Y=260140
X847 612 553 2 1 589 583 MUX2 $T=357740 235320 0 180 $X=353400 $Y=229900
X848 602 605 2 1 597 541 MUX2 $T=358980 245400 1 180 $X=354640 $Y=245020
X849 619 618 2 1 607 602 MUX2 $T=366420 275640 1 180 $X=362080 $Y=275260
X850 634 605 2 1 614 612 MUX2 $T=369520 235320 0 180 $X=365180 $Y=229900
X851 631 648 2 1 625 620 MUX2 $T=374480 245400 1 180 $X=370140 $Y=245020
X852 620 552 2 1 641 637 MUX2 $T=373240 255480 0 0 $X=373240 $Y=255100
X853 657 648 2 1 635 634 MUX2 $T=381300 235320 0 180 $X=376960 $Y=229900
X854 655 618 2 1 647 619 MUX2 $T=385640 275640 0 180 $X=381300 $Y=270220
X855 652 618 2 1 645 565 MUX2 $T=386260 265560 1 180 $X=381920 $Y=265180
X856 664 648 2 1 638 631 MUX2 $T=387500 245400 1 180 $X=383160 $Y=245020
X857 775 1024 1 2 1026 AN2 $T=593960 265560 0 0 $X=593960 $Y=265180
X858 183 1047 1 2 1049 AN2 $T=608840 285720 0 0 $X=608840 $Y=285340
X859 1186 1121 1 2 1200 AN2 $T=711140 285720 0 0 $X=711140 $Y=285340
X860 1335 1340 1 2 1336 AN2 $T=823360 305880 1 180 $X=820880 $Y=305500
X861 1026 1031 1034 1 2 1048 OA12 $T=597680 255480 1 0 $X=597680 $Y=250060
X862 179 1024 775 1 2 1038 OA12 $T=602640 275640 1 180 $X=598920 $Y=275260
X863 389 7 13 2 1 397 QDFFRBS $T=228160 305880 1 0 $X=228160 $Y=300460
X864 494 411 505 2 1 518 QDFFRBS $T=299460 255480 0 0 $X=299460 $Y=255100
X865 536 411 560 2 1 566 QDFFRBS $T=325500 245400 0 0 $X=325500 $Y=245020
X866 597 411 578 2 1 606 QDFFRBS $T=355260 255480 0 0 $X=355260 $Y=255100
X867 656 70 672 2 1 79 QDFFRBS $T=396180 305880 0 0 $X=396180 $Y=305500
X868 1224 217 1223 2 1 1227 QDFFRBS $T=744000 295800 1 0 $X=744000 $Y=290380
X869 1351 217 1328 2 1 1334 QDFFRBS $T=833900 285720 0 180 $X=822120 $Y=280300
X870 393 1 2 392 BUF1CK $T=234360 315960 1 0 $X=234360 $Y=310540
X871 397 1 2 401 BUF1CK $T=240560 305880 1 0 $X=240560 $Y=300460
X872 408 1 2 398 BUF1CK $T=246760 275640 0 0 $X=246760 $Y=275260
X873 405 1 2 25 BUF1CK $T=246760 315960 0 0 $X=246760 $Y=315580
X874 404 1 2 413 BUF1CK $T=251720 265560 0 0 $X=251720 $Y=265180
X875 416 1 2 407 BUF1CK $T=256680 285720 0 0 $X=256680 $Y=285340
X876 422 1 2 427 BUF1CK $T=260400 255480 1 0 $X=260400 $Y=250060
X877 424 1 2 423 BUF1CK $T=261020 275640 0 0 $X=261020 $Y=275260
X878 425 1 2 429 BUF1CK $T=262880 235320 0 0 $X=262880 $Y=234940
X879 426 1 2 421 BUF1CK $T=262880 255480 0 0 $X=262880 $Y=255100
X880 434 1 2 435 BUF1CK $T=269080 245400 1 0 $X=269080 $Y=239980
X881 445 1 2 458 BUF1CK $T=277760 225240 0 0 $X=277760 $Y=224860
X882 452 1 2 456 BUF1CK $T=277760 255480 0 0 $X=277760 $Y=255100
X883 468 1 2 453 BUF1CK $T=289540 275640 1 0 $X=289540 $Y=270220
X884 498 1 2 502 BUF1CK $T=303180 225240 0 0 $X=303180 $Y=224860
X885 503 1 2 506 BUF1CK $T=303800 245400 0 0 $X=303800 $Y=245020
X886 499 1 2 476 BUF1CK $T=303800 255480 1 0 $X=303800 $Y=250060
X887 518 1 2 514 BUF1CK $T=310000 255480 1 0 $X=310000 $Y=250060
X888 523 1 2 529 BUF1CK $T=316820 235320 1 0 $X=316820 $Y=229900
X889 544 1 2 541 BUF1CK $T=324260 265560 1 0 $X=324260 $Y=260140
X890 551 1 2 556 BUF1CK $T=329220 225240 0 0 $X=329220 $Y=224860
X891 567 1 2 565 BUF1CK $T=337900 265560 1 0 $X=337900 $Y=260140
X892 581 1 2 585 BUF1CK $T=347820 225240 0 0 $X=347820 $Y=224860
X893 592 1 2 583 BUF1CK $T=352160 245400 0 0 $X=352160 $Y=245020
X894 596 1 2 584 BUF1CK $T=354640 265560 1 0 $X=354640 $Y=260140
X895 606 1 2 602 BUF1CK $T=360220 255480 1 0 $X=360220 $Y=250060
X896 608 1 2 612 BUF1CK $T=362080 225240 0 0 $X=362080 $Y=224860
X897 613 1 2 631 BUF1CK $T=364560 245400 1 0 $X=364560 $Y=239980
X898 621 1 2 620 BUF1CK $T=368280 255480 1 0 $X=368280 $Y=250060
X899 623 1 2 595 BUF1CK $T=372620 265560 1 0 $X=372620 $Y=260140
X900 636 1 2 634 BUF1CK $T=376960 225240 0 0 $X=376960 $Y=224860
X901 639 1 2 637 BUF1CK $T=379440 265560 0 0 $X=379440 $Y=265180
X902 646 1 2 619 BUF1CK $T=380680 285720 1 0 $X=380680 $Y=280300
X903 80 1 2 640 BUF1CK $T=381300 315960 1 0 $X=381300 $Y=310540
X904 87 1 2 650 BUF1CK $T=386260 315960 0 0 $X=386260 $Y=315580
X905 661 1 2 664 BUF1CK $T=389980 245400 1 0 $X=389980 $Y=239980
X906 665 1 2 652 BUF1CK $T=391840 265560 1 0 $X=391840 $Y=260140
X907 667 1 2 655 BUF1CK $T=394320 275640 0 0 $X=394320 $Y=275260
X908 677 1 2 657 BUF1CK $T=400520 235320 1 0 $X=400520 $Y=229900
X909 679 1 2 92 BUF1CK $T=404240 315960 0 0 $X=404240 $Y=315580
X910 694 1 2 706 BUF1CK $T=414780 305880 0 0 $X=414780 $Y=305500
X911 732 1 2 729 BUF1CK $T=431520 285720 0 0 $X=431520 $Y=285340
X912 1024 1 2 1045 BUF1CK $T=606360 285720 0 0 $X=606360 $Y=285340
X913 1050 1 2 186 BUF1CK $T=611940 305880 1 0 $X=611940 $Y=300460
X914 335 1 2 338 BUF1CK $T=913880 315960 1 0 $X=913880 $Y=310540
X915 27 417 1 2 INV6CK $T=257300 295800 0 180 $X=251720 $Y=290380
X916 417 7 1 2 INV12CK $T=270940 295800 0 180 $X=261020 $Y=290380
X917 417 411 1 2 INV12CK $T=283340 285720 0 180 $X=273420 $Y=280300
X918 218 217 1 2 INV12CK $T=654720 295800 0 0 $X=654720 $Y=295420
X919 469 475 1 484 2 OR2B1S $T=289540 285720 1 0 $X=289540 $Y=280300
X920 877 884 1 875 2 OR2B1S $T=502820 265560 0 0 $X=502820 $Y=265180
X921 966 975 1 979 2 OR2B1S $T=544980 225240 0 0 $X=544980 $Y=224860
X922 1041 1026 1 1052 2 OR2B1S $T=607600 265560 0 0 $X=607600 $Y=265180
X923 62 63 535 1 2 ND2 $T=336660 315960 1 180 $X=334800 $Y=315580
X924 811 817 98 1 2 ND2 $T=473680 305880 1 180 $X=471820 $Y=305500
X925 882 869 877 1 2 ND2 $T=504680 265560 1 0 $X=504680 $Y=260140
X926 860 881 894 1 2 ND2 $T=506540 265560 1 0 $X=506540 $Y=260140
X927 140 896 691 1 2 ND2 $T=510880 265560 0 180 $X=509020 $Y=260140
X928 155 158 159 1 2 ND2 $T=554280 315960 1 0 $X=554280 $Y=310540
X929 1032 1041 1031 1 2 ND2 $T=606360 265560 1 0 $X=606360 $Y=260140
X930 336 1464 1440 1 2 ND2 $T=915120 295800 0 180 $X=913260 $Y=290380
X931 892 864 1 897 2 898 OAI12HS $T=505920 265560 0 0 $X=505920 $Y=265180
X932 79 1 642 653 656 88 2 OAI22S $T=385020 305880 0 0 $X=385020 $Y=305500
X933 95 1 697 696 694 88 2 OAI22S $T=414780 305880 1 180 $X=411060 $Y=305500
X934 848 1 132 848 845 827 2 OAI22S $T=491660 305880 1 180 $X=487940 $Y=305500
X935 894 1 864 860 884 892 2 OAI22S $T=509640 265560 0 0 $X=509640 $Y=265180
X936 831 1 764 982 983 160 2 OAI22S $T=549320 295800 1 0 $X=549320 $Y=290380
X937 889 1 764 1016 1018 1012 2 OAI22S $T=576600 295800 0 0 $X=576600 $Y=295420
X938 1102 1 1097 1102 1099 1101 2 OAI22S $T=656580 295800 0 180 $X=652860 $Y=290380
X939 1118 1 223 1118 1122 227 2 OAI22S $T=662160 315960 0 0 $X=662160 $Y=315580
X940 1241 1 266 1241 1243 1251 2 OAI22S $T=761980 295800 0 0 $X=761980 $Y=295420
X941 1242 1 1244 1242 1239 1237 2 OAI22S $T=766320 275640 1 180 $X=762600 $Y=275260
X942 271 1 270 271 1260 275 2 OAI22S $T=770660 315960 1 0 $X=770660 $Y=310540
X943 1404 1 1412 1404 1376 1421 2 OAI22S $T=881020 315960 1 0 $X=881020 $Y=310540
X944 1459 1 1460 1459 1454 1452 2 OAI22S $T=913260 265560 0 180 $X=909540 $Y=260140
X945 1457 1 1458 1457 1453 1464 2 OAI22S $T=910160 285720 1 0 $X=910160 $Y=280300
X946 1509 1 1487 1509 1507 1467 2 OAI22S $T=947360 295800 0 180 $X=943640 $Y=290380
X947 1466 322 337 1472 1 2 1475 AO13S $T=916980 295800 0 0 $X=916980 $Y=295420
X948 481 493 480 479 1 483 2 AOI22S $T=301320 275640 0 180 $X=297600 $Y=270220
X949 839 810 844 829 1 833 2 AOI22S $T=487940 235320 0 180 $X=484220 $Y=229900
X950 188 190 1051 191 1 187 2 AOI22S $T=613180 315960 0 0 $X=613180 $Y=315580
X951 322 336 1472 1461 1 337 2 AOI22S $T=920700 315960 0 180 $X=916980 $Y=310540
X952 917 927 1 2 INV2 $T=518940 255480 0 0 $X=518940 $Y=255100
X953 288 1440 1 2 INV2 $T=904580 305880 0 0 $X=904580 $Y=305500
X954 396 398 1 396 18 391 2 MOAI1S $T=241800 285720 0 180 $X=238080 $Y=280300
X955 396 407 1 396 21 403 2 MOAI1S $T=248000 305880 0 180 $X=244280 $Y=300460
X956 23 392 1 24 26 412 2 MOAI1S $T=248620 315960 1 0 $X=248620 $Y=310540
X957 23 401 1 24 415 419 2 MOAI1S $T=252960 305880 1 0 $X=252960 $Y=300460
X958 396 423 1 396 30 433 2 MOAI1S $T=260400 285720 1 0 $X=260400 $Y=280300
X959 420 453 1 420 38 447 2 MOAI1S $T=278380 275640 0 0 $X=278380 $Y=275260
X960 463 435 1 463 42 460 2 MOAI1S $T=288300 245400 1 0 $X=288300 $Y=239980
X961 446 40 1 446 40 486 2 MOAI1S $T=290780 315960 1 0 $X=290780 $Y=310540
X962 486 451 1 486 451 44 2 MOAI1S $T=297600 315960 1 0 $X=297600 $Y=310540
X963 480 484 1 480 484 496 2 MOAI1S $T=298220 295800 1 0 $X=298220 $Y=290380
X964 493 497 1 493 497 516 2 MOAI1S $T=303800 275640 1 0 $X=303800 $Y=270220
X965 487 514 1 463 46 494 2 MOAI1S $T=310000 255480 0 180 $X=306280 $Y=250060
X966 470 509 1 470 509 531 2 MOAI1S $T=311860 265560 0 0 $X=311860 $Y=265180
X967 515 531 1 515 531 558 2 MOAI1S $T=320540 265560 0 0 $X=320540 $Y=265180
X968 487 541 1 487 56 520 2 MOAI1S $T=324880 255480 0 180 $X=321160 $Y=250060
X969 546 545 1 546 545 543 2 MOAI1S $T=327980 315960 0 180 $X=324260 $Y=310540
X970 59 538 1 59 538 548 2 MOAI1S $T=334180 305880 0 180 $X=330460 $Y=300460
X971 540 533 1 540 533 573 2 MOAI1S $T=334180 275640 1 0 $X=334180 $Y=270220
X972 568 558 1 570 61 580 2 MOAI1S $T=338520 315960 1 0 $X=338520 $Y=310540
X973 568 516 1 570 64 66 2 MOAI1S $T=338520 315960 0 0 $X=338520 $Y=315580
X974 568 577 1 570 550 586 2 MOAI1S $T=341620 305880 0 0 $X=341620 $Y=305500
X975 555 573 1 555 573 577 2 MOAI1S $T=345960 275640 0 180 $X=342240 $Y=270220
X976 67 559 1 67 559 579 2 MOAI1S $T=348440 295800 1 180 $X=344720 $Y=295420
X977 553 583 1 553 68 572 2 MOAI1S $T=349060 245400 0 180 $X=345340 $Y=239980
X978 63 69 1 63 69 65 2 MOAI1S $T=349060 315960 1 180 $X=345340 $Y=315580
X979 590 593 1 590 593 601 2 MOAI1S $T=354640 275640 1 0 $X=354640 $Y=270220
X980 594 601 1 594 601 603 2 MOAI1S $T=355880 275640 0 0 $X=355880 $Y=275260
X981 568 603 1 570 582 609 2 MOAI1S $T=359600 295800 0 0 $X=359600 $Y=295420
X982 77 599 1 77 599 604 2 MOAI1S $T=363940 295800 0 180 $X=360220 $Y=290380
X983 78 611 1 78 611 617 2 MOAI1S $T=373240 305880 1 180 $X=369520 $Y=305500
X984 629 637 1 629 81 616 2 MOAI1S $T=379440 265560 1 180 $X=375720 $Y=265180
X985 630 624 1 630 624 643 2 MOAI1S $T=376960 285720 1 0 $X=376960 $Y=280300
X986 568 644 1 570 628 633 2 MOAI1S $T=381300 295800 1 180 $X=377580 $Y=295420
X987 86 650 1 85 496 83 2 MOAI1S $T=386260 315960 1 180 $X=382540 $Y=315580
X988 632 643 1 632 643 660 2 MOAI1S $T=383780 285720 0 0 $X=383780 $Y=285340
X989 663 595 1 663 662 658 2 MOAI1S $T=393700 265560 1 180 $X=389980 $Y=265180
X990 649 660 1 651 74 669 2 MOAI1S $T=391220 285720 0 0 $X=391220 $Y=285340
X991 666 664 1 666 671 668 2 MOAI1S $T=393700 255480 1 0 $X=393700 $Y=250060
X992 670 585 1 670 674 683 2 MOAI1S $T=395560 235320 0 0 $X=395560 $Y=234940
X993 649 681 1 651 678 675 2 MOAI1S $T=405480 285720 1 180 $X=401760 $Y=285340
X994 670 556 1 670 688 685 2 MOAI1S $T=406100 245400 1 0 $X=406100 $Y=239980
X995 670 657 1 670 689 684 2 MOAI1S $T=406720 235320 1 0 $X=406720 $Y=229900
X996 91 695 1 91 695 702 2 MOAI1S $T=413540 275640 1 0 $X=413540 $Y=270220
X997 96 97 1 93 98 102 2 MOAI1S $T=416020 315960 0 0 $X=416020 $Y=315580
X998 649 711 1 651 101 716 2 MOAI1S $T=419120 295800 1 0 $X=419120 $Y=290380
X999 710 712 1 710 712 713 2 MOAI1S $T=419740 275640 0 0 $X=419740 $Y=275260
X1000 698 713 1 698 713 711 2 MOAI1S $T=419740 285720 1 0 $X=419740 $Y=280300
X1001 717 718 1 717 718 725 2 MOAI1S $T=422840 255480 0 0 $X=422840 $Y=255100
X1002 724 705 1 724 705 703 2 MOAI1S $T=427180 265560 0 180 $X=423460 $Y=260140
X1003 719 723 1 719 723 718 2 MOAI1S $T=424700 235320 0 0 $X=424700 $Y=234940
X1004 99 725 1 651 729 721 2 MOAI1S $T=424700 285720 0 0 $X=424700 $Y=285340
X1005 730 728 1 730 728 726 2 MOAI1S $T=430280 275640 1 180 $X=426560 $Y=275260
X1006 733 734 1 733 734 742 2 MOAI1S $T=431520 235320 1 0 $X=431520 $Y=229900
X1007 741 740 1 741 740 734 2 MOAI1S $T=436480 225240 0 180 $X=432760 $Y=219820
X1008 666 584 1 666 749 743 2 MOAI1S $T=435240 265560 1 0 $X=435240 $Y=260140
X1009 746 655 1 746 106 737 2 MOAI1S $T=438960 285720 0 180 $X=435240 $Y=280300
X1010 99 742 1 651 108 747 2 MOAI1S $T=435860 295800 0 0 $X=435860 $Y=295420
X1011 756 755 1 756 755 752 2 MOAI1S $T=445160 275640 1 180 $X=441440 $Y=275260
X1012 746 652 1 746 765 768 2 MOAI1S $T=445780 285720 1 0 $X=445780 $Y=280300
X1013 746 566 1 746 771 773 2 MOAI1S $T=447640 265560 1 0 $X=447640 $Y=260140
X1014 99 774 1 764 116 780 2 MOAI1S $T=450740 295800 0 0 $X=450740 $Y=295420
X1015 761 776 1 761 776 774 2 MOAI1S $T=455080 225240 0 180 $X=451360 $Y=219820
X1016 777 781 1 777 781 783 2 MOAI1S $T=453840 275640 0 0 $X=453840 $Y=275260
X1017 797 766 1 797 766 776 2 MOAI1S $T=466860 225240 0 180 $X=463140 $Y=219820
X1018 99 796 1 764 121 800 2 MOAI1S $T=463140 285720 0 0 $X=463140 $Y=285340
X1019 784 692 1 784 692 807 2 MOAI1S $T=465620 275640 0 0 $X=465620 $Y=275260
X1020 810 808 1 810 808 796 2 MOAI1S $T=473680 235320 0 180 $X=469960 $Y=229900
X1021 126 803 1 126 803 823 2 MOAI1S $T=474920 285720 1 0 $X=474920 $Y=280300
X1022 127 772 1 127 772 824 2 MOAI1S $T=476780 295800 0 0 $X=476780 $Y=295420
X1023 844 979 1 844 979 982 2 MOAI1S $T=546840 245400 1 0 $X=546840 $Y=239980
X1024 988 970 1 988 970 993 2 MOAI1S $T=553660 245400 0 0 $X=553660 $Y=245020
X1025 961 965 1 961 965 988 2 MOAI1S $T=558620 235320 1 180 $X=554900 $Y=234940
X1026 991 995 1 991 995 997 2 MOAI1S $T=559240 305880 0 0 $X=559240 $Y=305500
X1027 161 127 1 160 993 1003 2 MOAI1S $T=559860 295800 1 0 $X=559860 $Y=290380
X1028 974 997 1 974 997 165 2 MOAI1S $T=564820 315960 0 0 $X=564820 $Y=315580
X1029 985 994 1 994 985 1015 2 MOAI1S $T=567920 285720 1 0 $X=567920 $Y=280300
X1030 1006 1007 1 1006 1007 1013 2 MOAI1S $T=569160 255480 0 0 $X=569160 $Y=255100
X1031 166 1011 1 167 136 1009 2 MOAI1S $T=573500 315960 0 180 $X=569780 $Y=310540
X1032 976 1005 1 976 1005 1022 2 MOAI1S $T=571640 245400 1 0 $X=571640 $Y=239980
X1033 1002 998 1 1002 998 1020 2 MOAI1S $T=573500 275640 0 0 $X=573500 $Y=275260
X1034 1004 1008 1 1004 1008 1019 2 MOAI1S $T=574740 265560 0 0 $X=574740 $Y=265180
X1035 996 1013 1 996 1013 1016 2 MOAI1S $T=575980 265560 1 0 $X=575980 $Y=260140
X1036 166 1017 1 167 151 169 2 MOAI1S $T=579700 315960 1 180 $X=575980 $Y=315580
X1037 989 1015 1 989 1015 1017 2 MOAI1S $T=579080 285720 1 0 $X=579080 $Y=280300
X1038 161 164 1 1012 1021 1014 2 MOAI1S $T=580940 285720 0 0 $X=580940 $Y=285340
X1039 987 1020 1 987 1020 174 2 MOAI1S $T=584660 275640 0 0 $X=584660 $Y=275260
X1040 1000 1022 1 1000 1022 1021 2 MOAI1S $T=585280 235320 1 0 $X=585280 $Y=229900
X1041 990 1019 1 990 1019 1011 2 MOAI1S $T=585280 265560 0 0 $X=585280 $Y=265180
X1042 1032 1034 1 1032 1030 1029 2 MOAI1S $T=594580 245400 1 180 $X=590860 $Y=245020
X1043 182 1039 1 182 181 1037 2 MOAI1S $T=601400 315960 1 180 $X=597680 $Y=315580
X1044 1033 1052 1 1033 1052 1058 2 MOAI1S $T=615660 265560 0 0 $X=615660 $Y=265180
X1045 1057 1056 1 1057 1056 1054 2 MOAI1S $T=619380 305880 0 180 $X=615660 $Y=300460
X1046 1062 1061 1 1062 1061 1060 2 MOAI1S $T=624960 285720 1 180 $X=621240 $Y=285340
X1047 1060 1067 1 1060 1067 1075 2 MOAI1S $T=626820 275640 1 0 $X=626820 $Y=270220
X1048 1072 1076 1 1072 1076 1079 2 MOAI1S $T=637360 295800 0 0 $X=637360 $Y=295420
X1049 1090 1091 1 1090 1091 1106 2 MOAI1S $T=649140 305880 1 0 $X=649140 $Y=300460
X1050 1406 1405 1 1406 1405 1403 2 MOAI1S $T=882260 285720 0 180 $X=878540 $Y=280300
X1051 1403 1417 1 1403 1417 1423 2 MOAI1S $T=882880 285720 0 0 $X=882880 $Y=285340
X1052 1432 1430 1 1432 1430 1419 2 MOAI1S $T=895900 305880 1 180 $X=892180 $Y=305500
X1053 1435 1434 1 1435 1434 1431 2 MOAI1S $T=898380 295800 1 180 $X=894660 $Y=295420
X1054 1446 1445 1 1446 1445 1444 2 MOAI1S $T=903960 285720 0 180 $X=900240 $Y=280300
X1055 195 1065 1062 197 2 1070 1 AOI13HS $T=628060 295800 1 0 $X=628060 $Y=290380
X1056 320 1427 1406 322 2 1420 1 AOI13HS $T=889080 285720 0 180 $X=885360 $Y=280300
X1057 76 1 640 642 2 568 ND3 $T=378820 315960 1 0 $X=378820 $Y=310540
X1058 680 1 687 697 2 649 ND3 $T=406100 305880 1 0 $X=406100 $Y=300460
X1059 178 1 1027 1012 2 176 ND3 $T=596440 295800 1 180 $X=593960 $Y=295420
X1060 1072 1 1066 1071 2 212 ND3 $T=633020 305880 0 180 $X=630540 $Y=300460
X1061 1090 1 1066 1067 2 210 ND3 $T=645420 305880 0 180 $X=642940 $Y=300460
X1062 1432 1 1442 1417 2 324 ND3 $T=893420 295800 0 180 $X=890940 $Y=290380
X1063 1435 1 1442 1439 2 327 ND3 $T=899000 295800 0 0 $X=899000 $Y=295420
X1064 1181 1191 1181 1191 2 1 1211 MAOI1 $T=731600 245400 1 180 $X=726640 $Y=245020
X1065 1388 1384 1388 1384 2 1 1385 MAOI1 $T=864900 265560 1 180 $X=859940 $Y=265180
X1066 465 473 1 480 451 469 2 MOAI1 $T=290780 295800 1 0 $X=290780 $Y=290380
X1067 910 921 1 844 970 966 2 MOAI1 $T=536920 225240 0 0 $X=536920 $Y=224860
X1068 1005 1000 1 1010 1007 976 2 MOAI1 $T=574740 255480 0 180 $X=570400 $Y=250060
X1069 245 1211 1 245 1218 1211 2 MOAI1 $T=724160 305880 1 0 $X=724160 $Y=300460
X1070 311 1385 1 311 1393 1385 2 MOAI1 $T=857460 275640 1 0 $X=857460 $Y=270220
X1071 509 470 515 1 2 493 MAO222 $T=308760 265560 1 180 $X=303800 $Y=265180
X1072 533 540 555 1 2 515 MAO222 $T=329840 275640 0 180 $X=324880 $Y=270220
X1073 593 590 594 1 2 555 MAO222 $T=354020 275640 0 180 $X=349060 $Y=270220
X1074 624 630 632 1 2 594 MAO222 $T=375100 285720 0 180 $X=370140 $Y=280300
X1075 712 710 698 1 2 717 MAO222 $T=421600 275640 1 0 $X=421600 $Y=270220
X1076 723 719 717 1 2 733 MAO222 $T=422220 225240 0 0 $X=422220 $Y=224860
X1077 740 741 733 1 2 761 MAO222 $T=441440 225240 0 0 $X=441440 $Y=224860
X1078 766 797 761 1 2 810 MAO222 $T=473060 225240 1 0 $X=473060 $Y=219820
X1079 987 1002 998 1 2 994 MAO222 $T=567300 275640 1 180 $X=562340 $Y=275260
X1080 990 1004 1008 1 2 998 MAO222 $T=568540 275640 0 180 $X=563580 $Y=270220
X1081 449 1 440 2 BUF4CK $T=275900 265560 0 0 $X=275900 $Y=265180
X1082 1051 1 2 1043 DELA $T=613800 315960 1 0 $X=613800 $Y=310540
X1083 1058 1 2 1064 DELA $T=619380 265560 0 0 $X=619380 $Y=265180
X1084 451 446 1 459 39 40 2 MOAI1H $T=277140 315960 0 0 $X=277140 $Y=315580
X1085 970 961 1 999 1005 965 2 MOAI1H $T=560480 225240 0 0 $X=560480 $Y=224860
X1086 79 2 627 622 1 AN2B1S $T=373240 315960 1 180 $X=370140 $Y=315580
X1087 95 2 700 704 1 AN2B1S $T=413540 295800 0 0 $X=413540 $Y=295420
X1088 127 2 772 827 1 AN2B1S $T=476780 315960 0 0 $X=476780 $Y=315580
X1089 991 974 995 159 1 2 MAO222P $T=560480 315960 1 180 $X=554900 $Y=315580
X1090 994 989 985 995 1 2 MAO222P $T=557380 285720 0 0 $X=557380 $Y=285340
X1091 1007 1006 1001 1008 1 2 MAO222P $T=566060 265560 1 0 $X=566060 $Y=260140
X1092 132 2 827 1 848 NR2P $T=481120 315960 1 0 $X=481120 $Y=310540
X1093 159 162 1 2 INV2CK $T=560480 315960 0 0 $X=560480 $Y=315580
X1094 1029 1 1044 2 BUF6CK $T=603260 245400 1 0 $X=603260 $Y=239980
X1095 1023 156 172 182 1 2 184 DFFSBN $T=588380 305880 0 0 $X=588380 $Y=305500
X1096 1043 156 172 188 1 2 191 DFFSBN $T=602640 305880 0 0 $X=602640 $Y=305500
X1097 1044 156 1042 1032 1 2 1543 DFFSBN $T=603260 245400 0 0 $X=603260 $Y=245020
X1098 1048 156 1063 1042 2 1 1031 QDFFRSBN $T=613800 255480 1 0 $X=613800 $Y=250060
X1099 1024 2 1033 1041 179 1 NR3 $T=600160 265560 0 0 $X=600160 $Y=265180
X1100 185 1049 189 175 2 1 1055 OA22 $T=610080 285720 1 0 $X=610080 $Y=280300
X1101 1037 1023 1 2 BUF4 $T=594580 315960 1 0 $X=594580 $Y=310540
X1102 1047 1053 1 2 BUF4 $T=615040 295800 1 0 $X=615040 $Y=290380
X1103 145 1 2 916 BUF3CK $T=527620 285720 0 180 $X=523280 $Y=280300
X1104 1527 2 1 TIE0 $T=961000 235320 1 0 $X=961000 $Y=229900
X1105 1033 1031 1032 2 1 1027 OR3 $T=593340 265560 0 180 $X=589620 $Y=260140
.ENDS
***************************************
.SUBCKT ICV_10 1 8 9 10 11 12 13 14 15 16 17 18 19 20 21 22 23 24 25 26
+ 27 28 29 30 51
** N=71 EP=25 IP=58 FDC=0
X0 9 10 11 11 12 XMD $T=166780 0 0 0 $X=169630 $Y=0
X1 13 11 11 11 14 XMD $T=256060 0 0 0 $X=258910 $Y=0
X2 15 1 1 1 16 XMD $T=345340 0 0 0 $X=348190 $Y=0
X3 17 1 1 8 18 8 19 YA2GSD $T=613180 0 0 0 $X=616030 $Y=0
X4 20 8 8 8 21 22 19 YA2GSD $T=702460 0 0 0 $X=705310 $Y=0
X5 23 22 22 22 24 22 19 YA2GSD $T=791740 0 0 0 $X=794590 $Y=0
X6 25 26 26 26 27 26 19 YA2GSD $T=881020 0 0 0 $X=883870 $Y=0
X7 28 29 29 29 30 29 19 YA2GSD $T=970300 0 0 0 $X=973150 $Y=0
.ENDS
***************************************
.SUBCKT ICV_11
** N=1 EP=0 IP=0 FDC=0
.ENDS
***************************************
.SUBCKT ICV_12 1 2 3 4
** N=5 EP=4 IP=6 FDC=0
X0 2 3 3 3 1 XMD $T=0 1033260 0 270 $X=0 $Y=973490
.ENDS
***************************************
.SUBCKT ICV_13 1 2 3 4 5
** N=6 EP=5 IP=6 FDC=0
X0 1 2 2 3 4 XMD $T=0 943940 0 270 $X=0 $Y=884170
.ENDS
***************************************
.SUBCKT ICV_14 1 2 3 4
** N=5 EP=4 IP=6 FDC=0
X0 1 2 2 2 3 XMD $T=0 854630 0 270 $X=0 $Y=794860
.ENDS
***************************************
.SUBCKT ICV_15
** N=13 EP=0 IP=0 FDC=0
.ENDS
***************************************
.SUBCKT ICV_16 2 3 4 5 11
** N=12 EP=5 IP=6 FDC=0
X0 2 3 4 4 5 XMD $T=0 586700 0 270 $X=0 $Y=526930
.ENDS
***************************************
.SUBCKT ICV_17 1 2 3 4
** N=5 EP=4 IP=6 FDC=0
X0 1 2 2 2 3 XMD $T=0 497390 0 270 $X=0 $Y=437620
.ENDS
***************************************
.SUBCKT ICV_18 1 2 3 4
** N=5 EP=4 IP=6 FDC=0
X0 1 2 2 2 3 XMD $T=0 408080 0 270 $X=0 $Y=348310
.ENDS
***************************************
.SUBCKT ICV_19 1 2 3 4 5 6 7
** N=9 EP=7 IP=12 FDC=0
X0 3 2 2 2 1 XMD $T=0 229440 0 270 $X=0 $Y=169670
X1 4 5 5 2 6 XMD $T=0 318760 0 270 $X=0 $Y=258990
.ENDS
***************************************
.SUBCKT ICV_20
** N=1 EP=0 IP=0 FDC=0
.ENDS
***************************************
.SUBCKT CHIP clk rst_n a[0] a[1] a[2] a[3] a[4] GND Vout[11] VCC Vout[10] Vout[9] Vout[8] Vout[7] Vout[6] Vout[4] Vout[5] b[5] b[6] b[7]
+ valid Vout[0] Vout[1] Vout[2] Vout[3] a[5] a[6] a[7] b[0] b[1] b[2] b[4] b[3]
** N=2067 EP=33 IP=4402 FDC=0
X0 1 15 18 clk 1526 rst_n 59 a[0] 71 69 a[1] 70 a[2] 1536 a[3] 1537 a[4] 72 2067 ICV_1 $T=0 0 0 0 $X=139500 $Y=1060580
X1 GND VCC 1 1526 1567 1568 73 74 75 77 76 78 80 79 81 59 88 84 82 83
+ 1538 85 70 86 87 89 90 91 92 93 95 94 97 96 98 99 101 100 102 103
+ 104 107 1539 106 105 109 113 111 110 112 108 114 116 115 117 118 119 120 122 121
+ 123 124 125 1569 126 127 128 129 130 131 132 134 133 135 136 137 138 139 140 141
+ 142 143 144 145 146 1570 1536 71 15 148 147 1537 18 149 150 Vout[11] 783 2067
+ ICV_2 $T=0 0 0 0 $X=139500 $Y=960700
X2 GND VCC 151 153 73 154 155 156 163 157 158 159 160 161 162 164 175 75 166 165
+ 167 168 169 76 170 77 1571 171 172 173 174 177 176 1572 79 80 74 178 179 81
+ 180 1538 78 181 192 1575 182 83 84 183 85 184 69 1574 1567 185 87 186 86 1576
+ 188 190 89 187 191 1578 193 189 194 91 195 92 1577 90 1579 196 1580 93 1581 199
+ 1582 125 197 95 200 198 96 97 201 202 1539 1583 94 204 203 98 205 99 206 207
+ 1584 209 100 208 101 102 210 212 103 213 214 211 104 215 105 218 216 217 106 107
+ 1586 108 109 110 219 220 111 222 223 112 221 224 113 225 226 228 227 229 114 115
+ 116 117 118 230 119 120 231 232 121 233 235 122 123 124 234 237 1569 126 238 242
+ 236 240 239 241 127 128 132 129 130 131 243 244 245 246 248 247 1587 133 249 259
+ 251 250 134 252 254 253 704 255 256 1591 1590 1593 257 258 1589 1588 1594 262 1592 260
+ 135 261 1595 1596 263 136 265 137 138 264 1598 266 267 139 268 269 140 270 271 141
+ 335 1597 272 273 274 275 276 278 277 142 279 280 281 143 144 282 286 283 1599 145
+ 285 287 291 1602 290 288 1601 293 294 1573 289 295 301 147 1600 296 1603 298 1570 299
+ 297 502 1585 303 1604 304 1605 305 306 300 302 308 307 309 310 1607 1608 312 316 314
+ 311 148 1606 321 317 318 319 320 322 323 1541 313 292 72 1609 325 1610 326 329 328
+ 333 1612 1611 284 327 315 324 330 1613 338 332 331 334 336 337 340 339 341 342 343
+ 344 345 347 346 149 348 350 351 349 Vout[10] 150 2067
+ ICV_3 $T=0 0 0 0 $X=139500 $Y=864940
X3 GND VCC 1614 153 352 155 353 157 159 354 154 170 158 355 156 161 160 162 356 163
+ 164 358 165 166 167 168 169 1615 357 361 1616 171 360 176 1571 172 178 173 359 174
+ 175 363 364 1572 362 177 365 366 367 180 368 179 369 370 371 373 1538 374 1582 375
+ 372 1617 376 181 184 377 378 379 380 182 1583 381 383 382 384 1618 185 385 386 387
+ 388 88 187 390 389 391 188 189 190 393 392 191 193 192 394 1567 395 194 396 1619
+ 195 397 400 398 399 209 1620 402 1577 403 404 408 196 1579 401 1621 405 406 1581 409
+ 407 197 1622 1623 410 201 198 1632 199 1638 1624 412 411 200 202 413 1625 203 204 414
+ 1626 1627 205 415 1584 416 1628 206 207 1629 208 417 210 211 420 418 212 419 213 216
+ 1631 422 218 1630 421 215 214 423 217 424 1539 1634 1633 426 430 1586 519 486 240 428
+ 220 219 425 221 228 1652 1649 223 222 1635 427 431 224 429 432 225 226 227 1637 1636
+ 433 434 230 231 229 436 437 438 435 439 440 1639 441 233 772 232 442 443 1569 444
+ 234 238 235 445 236 446 237 447 448 449 450 451 239 452 453 241 1587 1642 461 242
+ 454 455 456 1592 457 1641 458 459 462 460 250 248 243 244 464 463 1643 1588 465 466
+ 468 467 274 1647 247 953 245 252 469 249 246 470 1644 471 284 251 1589 253 472 254
+ 473 1590 474 258 1645 257 475 1591 476 256 1646 1593 477 1594 478 260 1596 259 261 262
+ 263 479 481 1595 1597 480 265 267 482 268 270 483 269 484 266 255 271 485 264 487
+ 335 488 272 273 704 292 489 275 490 276 1648 1654 278 1650 277 281 492 279 491 493
+ 1651 280 282 494 283 1598 495 285 286 294 496 1640 1599 498 499 1600 287 288 289 500
+ 290 497 501 504 1601 291 510 293 1653 1655 295 503 505 1602 296 307 506 297 507 298
+ 299 512 300 508 301 509 302 303 511 1656 513 304 306 514 305 1540 515 516 308 309
+ 310 311 518 312 313 315 316 517 520 522 318 1570 1580 1659 1657 319 322 521 342 320
+ 523 321 524 343 1609 323 525 1660 1658 324 527 325 1611 1610 526 528 328 326 1612 327
+ 529 329 530 1661 330 1665 531 334 532 332 331 1664 1666 534 1670 333 535 533 1668 1662
+ 336 537 538 1667 1613 536 1669 540 337 340 539 541 338 339 542 341 543 1663 545 344
+ 547 549 544 546 345 348 548 550 346 347 1671 150 551 351 350 552 554 1672 555 Vout[9]
+ 553 2067
+ ICV_4 $T=0 0 0 0 $X=139500 $Y=779260
X4 GND VCC 1673 1614 352 556 1542 20 152 353 557 354 560 558 559 368 168 160 154 1616
+ 356 561 563 355 562 1615 357 1571 565 564 358 359 360 363 362 361 567 367 366 566
+ 364 568 365 369 570 371 375 569 372 571 370 572 373 573 574 575 374 1676 1674 1618
+ 1617 376 1675 1701 377 379 378 582 381 1683 380 577 578 576 1690 579 382 584 580 581
+ 383 384 583 385 1679 386 589 585 586 387 637 1677 588 587 1678 388 1575 186 1687 391
+ 390 591 1680 392 393 592 1682 389 593 594 590 596 595 394 401 395 597 598 397 599
+ 1696 1619 1620 402 600 606 1576 601 400 602 398 403 603 404 1686 405 604 613 1621 1578
+ 1702 406 88 409 1684 407 607 408 1622 608 1689 611 1703 605 609 399 1727 410 1681 648
+ 634 1623 411 612 610 1697 1693 614 412 615 624 617 618 1625 1624 619 1626 414 1627 415
+ 416 1685 616 1691 649 620 1694 1628 621 1695 623 622 417 1692 644 1629 630 626 1688 625
+ 627 419 629 420 421 1630 628 1699 1704 1631 633 1698 422 632 1700 1633 423 631 1632 635
+ 1634 425 636 418 424 638 427 428 429 426 430 641 642 640 643 639 645 646 647 431
+ 650 432 651 652 653 1705 1636 683 681 1706 1708 1711 433 1637 434 657 1707 655 1638 435
+ 436 656 437 438 658 654 440 659 441 1713 442 661 660 1712 662 443 663 665 444 666
+ 667 668 670 445 446 669 664 679 1709 671 674 672 447 673 448 450 451 449 675 413
+ 677 676 458 678 1715 1717 680 452 1714 690 1718 506 504 456 1726 468 682 492 453 454
+ 1720 455 1721 462 684 1640 1719 686 1668 685 496 457 691 687 459 1716 1710 688 689 1642
+ 460 461 1722 464 463 692 1723 1645 1543 466 488 465 1725 1724 500 467 1728 693 1729 694
+ 1730 1653 473 469 696 1731 699 471 521 697 470 695 1736 1732 700 1734 1447 698 487 1733
+ 472 1735 474 1737 476 701 1650 475 702 1741 477 478 479 482 703 481 480 1738 483 1739
+ 484 1648 1662 705 495 1570 485 486 1740 707 489 708 490 706 1651 491 709 494 710 712
+ 1742 493 713 1743 1744 497 1544 715 498 716 499 717 1772 720 1670 714 501 719 718 502
+ 721 1655 503 722 723 1746 724 725 510 1748 726 1745 1654 1747 727 1660 729 507 1656 508
+ 1604 728 1749 509 1605 1603 730 511 512 1613 513 732 1635 1606 514 733 734 731 515 1667
+ 1607 516 1757 1758 742 736 1649 1652 1755 737 505 738 517 735 1608 1751 1760 1759 1754 1753
+ 750 739 740 1756 518 743 741 519 314 744 317 523 1764 1765 520 745 1752 746 1767 747
+ 1658 1665 748 1768 749 522 1657 751 1761 1766 1763 545 753 524 1545 525 752 1671 754 758
+ 526 1769 527 1770 756 757 528 755 759 1750 760 529 530 1663 761 762 763 764 531 1659
+ 532 533 765 1762 766 534 1664 767 1666 768 769 770 771 536 537 772 538 773 774 535
+ 775 1669 777 1771 776 539 540 541 778 779 542 543 544 547 551 546 711 782 548 549
+ 780 781 552 550 783 554 2067
+ ICV_5 $T=0 0 0 0 $X=139500 $Y=643180
X5 GND VCC 151 1547 1022 785 786 556 558 557 789 559 790 796 787 791 560 1585 561 794
+ 795 1774 562 1775 788 563 1780 564 1777 1781 565 797 1791 793 798 1573 1783 800 799 566
+ 801 802 1779 1778 803 1058 792 1793 1776 1673 804 146 805 1787 1782 567 806 568 807 82
+ 808 571 809 810 811 1784 570 1785 822 819 569 812 572 575 814 573 815 813 826 816
+ 817 574 1786 818 839 820 1675 821 1788 1789 1292 825 835 823 824 580 827 581 576 837
+ 828 183 1790 829 577 830 831 832 834 867 583 842 1574 836 88 578 588 838 585 584
+ 840 833 587 841 589 1792 586 1556 590 1794 591 1856 579 844 594 843 593 1796 1682 592
+ 845 1795 596 595 846 597 1678 847 1557 598 599 1801 582 848 600 849 603 601 602 1802
+ 850 851 852 604 605 853 1803 1808 855 606 1804 854 1806 1860 607 857 608 862 1810 609
+ 865 858 1805 1677 1807 860 859 1683 610 1812 856 634 861 613 611 1811 1809 1813 863 624
+ 612 1684 616 615 617 614 618 1798 866 1685 1859 1833 1820 649 1688 619 1858 680 869 1687
+ 1816 621 1681 1817 1840 1692 1686 880 620 887 1831 651 622 1674 1689 1825 870 1699 1691 875
+ 1693 871 1694 623 1690 1680 873 625 1695 1815 626 627 1797 1705 1819 876 1818 1696 683 629
+ 488 1828 879 1827 1823 630 878 1846 1841 1830 1676 864 868 1707 882 1814 881 1845 1799 1800
+ 631 628 1864 1697 1848 1829 883 890 1698 632 1715 1821 1700 872 648 1826 633 885 1836 886
+ 653 884 1640 1838 1832 1702 888 1835 877 889 635 636 504 1837 891 637 1839 1842 1159 892
+ 893 909 638 894 895 1824 643 661 639 1706 1850 874 1552 897 896 640 641 1843 642 1844
+ 1847 644 898 902 1704 1703 899 1857 905 645 1822 901 900 646 650 923 647 1853 1851 1849
+ 1834 1852 903 904 652 1708 1714 1861 906 918 685 907 908 654 1854 910 1855 681 1863 655
+ 911 912 1710 913 690 656 914 1712 657 1862 658 1709 915 916 917 659 660 1719 919 671
+ 665 663 920 664 666 667 921 668 669 662 670 922 1725 1716 928 672 924 673 925 926
+ 674 953 1865 676 677 964 929 927 1866 678 679 930 1711 1717 931 1729 1875 932 1209 933
+ 682 1867 934 974 1720 1592 935 684 1191 691 936 686 937 687 940 1643 688 938 939 1721
+ 941 1731 943 1726 942 1723 944 692 1735 1724 1722 945 697 1868 1734 946 695 1543 1737 693
+ 1728 694 689 521 699 1730 696 1732 947 948 698 1644 1733 1869 675 1870 700 949 950 1871
+ 1661 951 701 1591 952 1646 1873 1872 703 954 704 955 1874 956 702 705 1727 706 1740 1580
+ 958 959 707 957 708 963 960 1876 961 709 962 1742 711 712 710 1744 713 1762 965 966
+ 714 967 717 718 1548 721 715 968 716 981 1877 969 975 1743 1893 1761 971 1879 1752 719
+ 970 720 977 1764 979 976 1750 1880 781 723 1745 1746 1883 1882 973 978 972 1747 1544 1899
+ 1881 724 725 726 727 1887 729 728 1766 980 1749 1891 1748 1878 982 722 730 983 1885 1897
+ 984 1886 985 1889 1895 731 986 1890 1884 1754 1751 732 1888 987 1753 733 734 736 735 1755
+ 988 990 738 1758 741 991 1894 1757 1759 992 993 1892 1767 1756 737 1760 989 740 1896 743
+ 739 742 750 1898 995 1763 994 744 747 746 1765 996 749 748 998 999 1768 1017 997 751
+ 752 753 763 1004 745 755 756 1770 758 1000 754 767 759 757 760 1002 1001 1003 1520 1518
+ 761 768 1769 762 1005 764 766 1545 765 1006 773 769 770 771 775 772 1900 1901 1007 1009
+ 774 1008 1010 1771 777 776 1011 778 779 1522 439 1012 782 1639 780 1013 349 1015 553 1903
+ 1014 1772 1016 1018 1019 1902 783 1524 555 1020 Vout[8] 1672 2067
+ ICV_6 $T=0 0 0 0 $X=139500 $Y=502060
X6 GND VCC 1021 1549 1904 1022 786 558 1905 1023 791 1775 1024 1025 1774 1026 1776 1782 787 788
+ 789 1027 1906 1028 1032 559 1030 790 792 1031 794 793 1029 1785 1793 1035 1033 1034 795 803
+ 796 1036 1043 802 797 1038 1037 1039 1041 799 1040 800 1779 807 811 804 1042 805 806 815
+ 1047 808 1784 1908 809 810 1045 1046 1909 812 1044 798 813 1048 814 816 826 818 819 820
+ 821 1049 1787 822 1050 1051 1788 823 1780 1910 1053 1907 1052 1054 824 1055 825 1056 817 827
+ 1057 828 829 867 843 830 1058 831 1059 833 1062 1060 832 834 838 835 1061 1911 836 837
+ 1063 1791 801 1064 839 840 1826 1912 1792 841 1065 844 1066 845 1072 842 1068 1086 1067 1071
+ 1798 1069 1070 1913 1319 1836 1550 1073 846 847 1075 1914 1916 1074 848 1076 849 854 1551 1077
+ 851 1917 1795 1555 1078 1918 1796 1797 850 1919 1920 1804 852 1079 1799 1800 853 888 1803 862
+ 857 856 1082 855 858 1085 1096 1081 1807 1084 1923 1926 1924 1083 1093 1801 1931 859 1806 1679
+ 1080 1930 1925 863 1087 1927 860 1968 1805 861 1929 1928 1922 1095 1823 1915 1809 1921 1089 1934
+ 1932 1090 1815 1811 1091 1810 1092 864 1094 866 1933 1337 865 1935 1088 1832 1936 884 868 1937
+ 1814 1827 1099 1098 1818 869 1820 1834 1940 1938 1100 1819 1824 1822 1103 1101 870 1102 1821 872
+ 893 1817 1939 1097 1941 1943 874 875 1952 1104 1105 1953 1813 1942 876 877 878 1106 879 1829
+ 892 1721 881 1835 1945 882 1110 885 1967 883 1830 900 1107 886 1108 1843 1948 1701 1802 1831
+ 1944 1838 1837 871 1109 579 887 1848 1833 1946 889 1825 584 1839 890 1947 1159 1111 1842 1840
+ 1949 1112 1113 894 906 1841 895 1114 1950 896 1118 897 1115 1844 891 1116 1552 1119 1846 899
+ 1125 898 1704 1117 1857 1845 1853 903 907 901 1120 1849 1847 1955 1854 902 908 1123 1863 1133
+ 1951 904 913 1851 1956 1127 1954 905 1121 1855 909 1126 1122 912 1128 910 1124 1856 1852 1960
+ 1957 916 1858 1859 1958 914 1130 1959 1129 1865 927 917 915 1862 1962 1861 929 1131 1866 920
+ 1850 1138 923 918 1965 1961 1963 919 930 911 921 1964 1713 1164 1864 1132 1136 922 1134 924
+ 935 1641 1135 1137 925 1200 926 1718 1191 1647 952 1140 468 1736 1142 1141 1143 1969 1690 1977
+ 1144 931 1139 928 1966 1145 1970 932 1147 1867 933 1828 1972 1146 1971 934 948 496 1149 1148
+ 1739 1738 1974 1711 937 1973 2013 936 938 1151 939 1152 940 941 942 1172 1153 943 1975 944
+ 1154 1155 1157 1156 945 1868 1979 1158 946 1976 1995 1175 1163 1978 1166 1178 1160 1161 1150 1196
+ 947 1162 1168 1165 1986 949 950 1702 1167 1983 1980 951 1182 1180 1981 1174 1170 1875 1171 1176
+ 1173 954 1177 1984 1179 1985 1189 1181 957 1183 958 1982 959 1184 1185 960 1186 961 962 1187
+ 1188 963 1741 1169 965 1192 1987 1989 1194 1193 1899 1877 970 971 1988 1447 1195 972 1992 973
+ 1879 1880 975 1878 1197 1881 976 1991 1203 974 1882 1996 969 1998 1883 505 1884 978 1211 1198
+ 977 979 1199 1993 2001 1201 953 1202 964 1990 1251 1999 1432 981 1208 1886 1204 1885 1210 2000
+ 1205 1206 982 1887 984 1889 1994 985 1890 1209 1207 1888 1222 986 980 983 993 1463 1212 1214
+ 1892 1213 1997 2003 2004 1215 989 966 2005 2008 2002 991 1216 1893 1217 1220 1238 2007 992 1219
+ 1894 1218 1190 1221 967 1223 2006 994 995 1898 996 1224 1225 1226 1896 1891 1548 1227 1229 997
+ 1228 998 1231 1876 1230 1017 999 2009 1895 2010 1232 1233 968 1897 1234 1004 1235 1000 2011 1236
+ 1001 1002 1237 1003 1239 1240 1241 2012 990 2014 1242 1005 1243 1244 987 1245 1006 1247 988 1248
+ 1246 1249 1010 1008 1007 1250 1009 1252 1011 1255 1254 1256 1253 1258 1257 1012 1013 1014 1260 1553
+ 1015 1261 1016 1259 1262 1263 1264 1265 1266 1020 Vout[7] 1019 1672 2067
+ ICV_7 $T=0 0 0 0 $X=139500 $Y=411300
X7 GND VCC 785 1267 1554 1022 1270 1024 1023 1268 1269 1025 1031 1026 1027 1271 1272 1028 1047 1029
+ 1030 1275 1274 1032 1281 1276 1273 793 1036 2017 1277 1033 1034 1035 1037 794 798 1042 1298 1282
+ 1280 1039 1279 1040 1038 1778 2015 1283 1780 1286 1284 1041 1299 1278 1285 1907 2016 1043 1783 1044
+ 815 1781 1054 1287 1045 1046 1288 1908 1309 1291 1290 1050 1292 1048 1052 1293 1294 1295 1296 1297
+ 1049 1910 1789 1051 1053 1304 1300 1058 1055 1338 1786 1056 1301 1310 1790 1302 1057 1303 1931 1305
+ 1062 1306 1308 1307 1060 1911 1059 1061 1354 1316 1063 1333 1064 1069 1351 1065 2018 1342 1314 1311
+ 1312 1326 1095 1066 1313 1323 1320 1067 1794 1315 1068 1289 1915 1318 1071 1317 1936 1913 1072 1319
+ 1079 1070 1344 1921 1550 2019 1073 1930 1926 1321 2020 1074 1076 1916 1322 1077 1555 1078 1324 1325
+ 1082 1083 1088 1922 1087 1080 1328 1081 1327 1925 1329 1084 1330 1085 1924 1331 1086 1090 1551 1923
+ 1556 1929 1332 1955 1808 1089 1335 1336 1341 1927 1933 1337 1093 1092 1094 1339 1935 1103 1359 1346
+ 1812 1340 1934 869 1098 1938 1343 1117 1097 1557 1939 1932 1345 2021 1099 1101 1102 1940 1347 2022
+ 1348 1816 1116 2023 1941 1357 1334 1349 1105 1350 1942 1106 1107 1100 1352 1104 1353 2027 873 1355
+ 1944 1108 1109 1356 1110 1943 1960 1945 1111 1946 1130 1112 1947 1951 1114 1360 1948 1949 1115 1113
+ 1358 1950 1361 1121 1362 1363 1118 1119 1120 912 1364 1365 2026 2024 1366 1368 1367 2025 1956 1954
+ 1953 1952 1958 1123 1369 1124 1122 1126 1959 1125 1371 1129 1128 1957 1127 1372 1370 1373 1131 1961
+ 1375 1374 1966 1132 2028 1376 1133 1385 1860 1379 1377 1378 1380 1096 1381 1382 1134 1135 1136 1384
+ 1383 579 1138 584 1386 1387 1388 1389 1967 1139 1152 1901 1968 1964 1141 1390 1142 1143 1394 1145
+ 1391 1144 2032 1392 1393 1970 1146 1147 1969 1148 1976 1971 1972 1828 1395 1403 1149 1397 2029 1398
+ 1973 1150 1396 1399 2033 1153 1151 1137 1169 1401 2031 1402 1164 1400 2030 1154 1975 1155 1156 1405
+ 1404 1140 1406 1979 1157 1690 2034 1965 1408 1407 1963 1158 2035 1409 1410 1411 1160 1412 1171 2036
+ 1161 1869 1413 1415 1417 1414 1871 1416 956 1165 1872 1985 1870 1978 1166 1418 1980 1874 1419 1167
+ 1873 1422 1977 1420 1159 1982 1174 1219 1981 1421 1168 1176 1170 1200 1983 1438 1424 1425 955 1423
+ 1441 1172 1173 1197 1178 1175 2037 1177 1426 1427 1179 1984 1428 1429 1180 1430 1181 1182 2038 1183
+ 1433 1184 468 1436 1185 1434 1460 1431 1186 1435 1187 1188 1437 1190 1439 1440 952 1191 1445 1990
+ 1442 2039 1443 1192 1444 1447 1194 1464 1994 1195 1991 1163 1448 1995 1193 1992 1449 1196 1451 1446
+ 1453 1454 1198 1199 1450 1998 1455 1456 1452 1974 1457 2040 1201 1458 2045 1459 1461 1203 1202 1462
+ 1204 2000 1205 1206 1214 1209 1207 2004 1208 1210 1986 2041 1466 1211 1212 1213 1465 2001 2007 1215
+ 1467 1468 2003 1216 1222 1469 1217 1220 1470 1218 1221 1471 1223 1472 1224 1473 1225 1474 1226 1228
+ 1229 1475 1230 1476 2009 1477 2010 1502 2042 1231 1478 1239 1233 1234 1232 2011 1236 1479 1481 1237
+ 1500 1480 1238 2044 2043 1240 1241 1486 1482 1189 1483 1243 1244 1489 1488 1242 1496 1484 1485 1245
+ 1487 1251 1247 1246 1250 1490 1491 1492 1249 1493 1248 1252 2046 1494 1498 1253 1495 1497 1256 2013
+ 1254 1255 1235 1258 1257 2014 1499 1259 1260 1501 2012 1503 1504 1262 1263 1261 1264 1506 1265 1505
+ 1553 1266 Vout[6] 1018 1672 2067
+ ICV_8 $T=0 0 0 0 $X=139500 $Y=320600
X8 GND VCC 1507 1267 1021 31 1022 1904 1268 1905 1508 1269 1270 30 1906 1271 1272 1273 1558 1276
+ 1035 1510 1274 1277 1275 1280 1568 1278 1777 794 1279 1282 1309 1281 2015 1283 1509 2016 1284 1285
+ 1287 1908 1286 1289 1290 1909 1292 1293 1294 1295 1291 1296 1297 1789 1298 1787 1299 1300 1920 32
+ 1919 1301 1302 1303 1304 1305 1918 1788 1306 1910 1310 1307 1308 1917 2017 1312 1914 1075 1916 1311
+ 1912 2018 1313 1314 1315 1319 1316 1913 1317 1320 1083 1318 1322 1323 1082 1324 1325 1326 1329 1321
+ 1081 1327 1328 1330 1331 1352 1332 1090 1928 1333 1334 1335 2019 1336 1091 1337 1339 1340 1341 1342
+ 1937 2020 1343 1938 2024 1344 1345 1346 2021 1347 1349 1350 2022 1348 1351 1353 1356 2023 1355 1354
+ 1358 1357 1360 1359 1362 1361 2027 1363 1364 1367 1955 1366 1368 1369 2026 2025 1365 1126 1370 1371
+ 1372 1125 1373 1962 1375 1376 1377 1374 2028 1378 1131 1380 1379 1381 1382 1383 1900 1384 1565 1387
+ 1386 1388 1385 1389 1390 1142 1392 1393 1394 1144 2029 1391 1150 2030 1395 1396 39 1397 2032 1398
+ 1399 1400 1401 2031 1402 1163 1403 1406 2034 1977 2038 1866 1404 1405 2033 1149 1407 2035 1408 1410
+ 1409 1171 2036 1412 1415 1413 1411 1416 1414 1417 1418 1421 1420 1422 1423 1419 1424 1425 1429 1426
+ 1427 2037 1428 1987 1519 1430 1435 1988 1431 1432 1989 1434 1993 1433 1436 952 1997 1437 1438 1440
+ 1441 1189 2039 1443 1444 1439 1445 1454 1442 1446 2040 1447 1449 1448 1736 1455 1450 1451 1452 1453
+ 1996 1456 1457 1458 1460 1462 1461 1459 2041 1999 1463 1464 1465 1466 1521 1467 2005 1468 2002 1470
+ 1469 1472 2008 2006 1471 1227 1473 1475 2042 1476 1480 1477 1203 1474 1494 1479 1995 1481 2044 1483
+ 2043 1496 1482 1484 1485 2045 1517 1192 1495 1489 1486 1488 2046 1490 1491 1493 1497 1478 1499 1498
+ 1500 1487 1501 1492 1502 1503 1523 1504 1672 1505 1506 Vout[4] 1902 Vout[5] 1903 2067
+ ICV_9 $T=0 0 0 0 $X=139500 $Y=139500
X9 32 39 b[5] 31 1508 1507 b[6] 1509 b[7] 1510 valid 1565 1517 Vout[0] 1518 1519 Vout[1] 1520 Vout[2] 1521
+ 1522 Vout[3] 1523 1524 2067
+ ICV_10 $T=0 0 0 0 $X=139500 $Y=-56920
X11 20 a[5] 73 2067 ICV_12 $T=0 0 0 0 $X=-56920 $Y=961500
X12 a[6] 73 151 152 2067 ICV_13 $T=0 0 0 0 $X=-56920 $Y=865700
X13 a[7] 151 1542 2067 ICV_14 $T=0 0 0 0 $X=-56920 $Y=780000
X15 b[0] 151 785 1547 2067 ICV_16 $T=0 0 0 0 $X=-56920 $Y=502800
X16 b[1] 785 1549 2067 ICV_17 $T=0 0 0 0 $X=-56920 $Y=411300
X17 b[2] 1267 1554 2067 ICV_18 $T=0 0 0 0 $X=-56920 $Y=320600
X18 30 31 b[4] b[3] 1267 1558 2067 ICV_19 $T=0 0 0 0 $X=-56920 $Y=139500
.ENDS
***************************************
