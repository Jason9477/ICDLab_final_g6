$ Spice netlist generated by v2lvs
$ v2022.3_33.19    Tue Sep 6 12:09:54 PDT 2022
.INCLUDE "core.spi"
.INCLUDE "umc18_io_lvs.spi"
*.BUSDELIMITER [

.SUBCKT LOD_W2_43 in[1] in[0] pos[0] valid
*.CONNECT valid in[0]
.ENDS

.SUBCKT LOD_W2_42 in[1] in[0] pos[0] valid
*.CONNECT pos[0] in[1]
XU2 INV1S $PINS O=n1 I=in[0]
XU3 OR2B1S $PINS O=valid I1=in[1] B1=n1
.ENDS

.SUBCKT LOD_W4_21 in[3] in[2] in[1] in[0] pos[1] pos[0] valid
*.CONNECT pos[1] recursive_case.left_valid
XU2 OR2 $PINS O=valid I1=recursive_case.left_valid
+ I2=recursive_case.right_valid
XU3 AN2B1S $PINS O=pos[0] I1=recursive_case.right_pos[0]
+ B1=recursive_case.left_valid
Xrecursive_case.LOD_left LOD_W2_43 $PINS in[1]=n2 in[0]=in[2]
+ valid=recursive_case.left_valid
Xrecursive_case.LOD_right LOD_W2_42 $PINS in[1]=in[1] in[0]=in[0]
+ pos[0]=recursive_case.right_pos[0] valid=recursive_case.right_valid
.ENDS

.SUBCKT LOD_W2_41 in[1] in[0] pos[0] valid
*.CONNECT pos[0] in[1]
XU2 OR2 $PINS O=valid I1=in[1] I2=in[0]
.ENDS

.SUBCKT LOD_W2_40 in[1] in[0] pos[0] valid
*.CONNECT pos[0] in[1]
XU2 OR2 $PINS O=valid I1=in[1] I2=in[0]
.ENDS

.SUBCKT LOD_W4_20 in[3] in[2] in[1] in[0] pos[1] pos[0] valid
*.CONNECT pos[1] recursive_case.left_valid
XU1 OR2 $PINS O=valid I1=recursive_case.left_valid
+ I2=recursive_case.right_valid
XU2 MUX2 $PINS O=pos[0] S=recursive_case.left_valid
+ A=recursive_case.right_pos[0] B=recursive_case.left_pos[0]
Xrecursive_case.LOD_left LOD_W2_41 $PINS in[1]=in[3] in[0]=in[2]
+ pos[0]=recursive_case.left_pos[0] valid=recursive_case.left_valid
Xrecursive_case.LOD_right LOD_W2_40 $PINS in[1]=in[1] in[0]=in[0]
+ pos[0]=recursive_case.right_pos[0] valid=recursive_case.right_valid
.ENDS

.SUBCKT LOD_W8_10 in[7] in[6] in[5] in[4] in[3] in[2] in[1] in[0] pos[2] pos[1]
+ pos[0] valid
*.CONNECT pos[2] recursive_case.left_valid
XU1 OR2 $PINS O=valid I1=recursive_case.left_valid
+ I2=recursive_case.right_valid
XU3 MUX2 $PINS O=pos[0] S=recursive_case.left_valid
+ A=recursive_case.right_pos[0] B=recursive_case.left_pos[0]
XU4 MUX2 $PINS O=pos[1] S=recursive_case.left_valid
+ A=recursive_case.right_pos[1] B=recursive_case.left_pos[1]
Xrecursive_case.LOD_left LOD_W4_21 $PINS in[3]=n2 in[2]=in[6] in[1]=in[5]
+ in[0]=in[4] pos[1]=recursive_case.left_pos[1] pos[0]=recursive_case.left_pos[0]
+ valid=recursive_case.left_valid
Xrecursive_case.LOD_right LOD_W4_20 $PINS in[3]=in[3] in[2]=in[2] in[1]=in[1]
+ in[0]=in[0] pos[1]=recursive_case.right_pos[1]
+ pos[0]=recursive_case.right_pos[0] valid=recursive_case.right_valid
.ENDS

.SUBCKT LOD_W16_5 in[15] in[14] in[13] in[12] in[11] in[10] in[9] in[8] in[7]
+ in[6] in[5] in[4] in[3] in[2] in[1] in[0] pos[3] pos[2] pos[1] pos[0] valid
*.CONNECT pos[2] recursive_case.right_pos[2]
*.CONNECT pos[1] recursive_case.right_pos[1]
*.CONNECT pos[0] recursive_case.right_pos[0]
*.CONNECT valid recursive_case.right_valid
Xrecursive_case.LOD_right LOD_W8_10 $PINS in[7]=n14 in[6]=in[6] in[5]=in[5]
+ in[4]=in[4] in[3]=in[3] in[2]=in[2] in[1]=in[1] in[0]=in[0]
+ pos[2]=recursive_case.right_pos[2] pos[1]=recursive_case.right_pos[1]
+ pos[0]=recursive_case.right_pos[0] valid=recursive_case.right_valid
.ENDS

.SUBCKT LOD_W2_39 in[1] in[0] pos[0] valid
*.CONNECT pos[0] in[1]
XU2 OR2 $PINS O=valid I1=in[1] I2=in[0]
.ENDS

.SUBCKT LOD_W2_38 in[1] in[0] pos[0] valid
*.CONNECT pos[0] in[1]
XU2 OR2 $PINS O=valid I1=in[1] I2=in[0]
.ENDS

.SUBCKT LOD_W4_19 in[3] in[2] in[1] in[0] pos[1] pos[0] valid
*.CONNECT pos[1] recursive_case.left_valid
XU1 OR2 $PINS O=valid I1=recursive_case.left_valid
+ I2=recursive_case.right_valid
XU2 MUX2 $PINS O=pos[0] S=recursive_case.left_valid
+ A=recursive_case.right_pos[0] B=recursive_case.left_pos[0]
Xrecursive_case.LOD_left LOD_W2_39 $PINS in[1]=in[3] in[0]=in[2]
+ pos[0]=recursive_case.left_pos[0] valid=recursive_case.left_valid
Xrecursive_case.LOD_right LOD_W2_38 $PINS in[1]=in[1] in[0]=in[0]
+ pos[0]=recursive_case.right_pos[0] valid=recursive_case.right_valid
.ENDS

.SUBCKT LOD_W2_37 in[1] in[0] pos[0] valid
*.CONNECT pos[0] in[1]
XU2 OR2 $PINS O=valid I1=in[1] I2=in[0]
.ENDS

.SUBCKT LOD_W2_36 in[1] in[0] pos[0] valid
*.CONNECT pos[0] in[1]
XU2 OR2 $PINS O=valid I1=in[1] I2=in[0]
.ENDS

.SUBCKT LOD_W4_18 in[3] in[2] in[1] in[0] pos[1] pos[0] valid
*.CONNECT pos[1] recursive_case.left_valid
XU1 OR2 $PINS O=valid I1=recursive_case.left_valid
+ I2=recursive_case.right_valid
XU2 MUX2 $PINS O=pos[0] S=recursive_case.left_valid
+ A=recursive_case.right_pos[0] B=recursive_case.left_pos[0]
Xrecursive_case.LOD_left LOD_W2_37 $PINS in[1]=in[3] in[0]=in[2]
+ pos[0]=recursive_case.left_pos[0] valid=recursive_case.left_valid
Xrecursive_case.LOD_right LOD_W2_36 $PINS in[1]=in[1] in[0]=in[0]
+ pos[0]=recursive_case.right_pos[0] valid=recursive_case.right_valid
.ENDS

.SUBCKT LOD_W8_9 in[7] in[6] in[5] in[4] in[3] in[2] in[1] in[0] pos[2] pos[1]
+ pos[0] valid
*.CONNECT pos[2] recursive_case.left_valid
XU1 OR2 $PINS O=valid I1=recursive_case.left_valid
+ I2=recursive_case.right_valid
XU2 MUX2 $PINS O=pos[0] S=recursive_case.left_valid
+ A=recursive_case.right_pos[0] B=recursive_case.left_pos[0]
XU3 MUX2 $PINS O=pos[1] S=recursive_case.left_valid
+ A=recursive_case.right_pos[1] B=recursive_case.left_pos[1]
Xrecursive_case.LOD_left LOD_W4_19 $PINS in[3]=in[7] in[2]=in[6] in[1]=in[5]
+ in[0]=in[4] pos[1]=recursive_case.left_pos[1] pos[0]=recursive_case.left_pos[0]
+ valid=recursive_case.left_valid
Xrecursive_case.LOD_right LOD_W4_18 $PINS in[3]=in[3] in[2]=in[2] in[1]=in[1]
+ in[0]=in[0] pos[1]=recursive_case.right_pos[1]
+ pos[0]=recursive_case.right_pos[0] valid=recursive_case.right_valid
.ENDS

.SUBCKT LOD_W2_35 in[1] in[0] pos[0] valid
*.CONNECT pos[0] in[1]
XU2 OR2 $PINS O=valid I1=in[1] I2=in[0]
.ENDS

.SUBCKT LOD_W2_34 in[1] in[0] pos[0] valid
*.CONNECT pos[0] in[1]
XU2 OR2 $PINS O=valid I1=in[1] I2=in[0]
.ENDS

.SUBCKT LOD_W4_17 in[3] in[2] in[1] in[0] pos[1] pos[0] valid
*.CONNECT pos[1] recursive_case.left_valid
XU1 OR2 $PINS O=valid I1=recursive_case.left_valid
+ I2=recursive_case.right_valid
XU2 MUX2 $PINS O=pos[0] S=recursive_case.left_valid
+ A=recursive_case.right_pos[0] B=recursive_case.left_pos[0]
Xrecursive_case.LOD_left LOD_W2_35 $PINS in[1]=in[3] in[0]=in[2]
+ pos[0]=recursive_case.left_pos[0] valid=recursive_case.left_valid
Xrecursive_case.LOD_right LOD_W2_34 $PINS in[1]=in[1] in[0]=in[0]
+ pos[0]=recursive_case.right_pos[0] valid=recursive_case.right_valid
.ENDS

.SUBCKT LOD_W2_33 in[1] in[0] pos[0] valid
*.CONNECT pos[0] in[1]
XU2 OR2 $PINS O=valid I1=in[1] I2=in[0]
.ENDS

.SUBCKT LOD_W2_32 in[1] in[0] pos[0] valid
*.CONNECT pos[0] in[1]
XU2 OR2 $PINS O=valid I1=in[1] I2=in[0]
.ENDS

.SUBCKT LOD_W4_16 in[3] in[2] in[1] in[0] pos[1] pos[0] valid
*.CONNECT pos[1] recursive_case.left_valid
XU1 OR2 $PINS O=valid I1=recursive_case.left_valid
+ I2=recursive_case.right_valid
XU2 MUX2 $PINS O=pos[0] S=recursive_case.left_valid
+ A=recursive_case.right_pos[0] B=recursive_case.left_pos[0]
Xrecursive_case.LOD_left LOD_W2_33 $PINS in[1]=in[3] in[0]=in[2]
+ pos[0]=recursive_case.left_pos[0] valid=recursive_case.left_valid
Xrecursive_case.LOD_right LOD_W2_32 $PINS in[1]=in[1] in[0]=in[0]
+ pos[0]=recursive_case.right_pos[0] valid=recursive_case.right_valid
.ENDS

.SUBCKT LOD_W8_8 in[7] in[6] in[5] in[4] in[3] in[2] in[1] in[0] pos[2] pos[1]
+ pos[0] valid
*.CONNECT pos[2] recursive_case.left_valid
XU1 OR2 $PINS O=valid I1=recursive_case.left_valid
+ I2=recursive_case.right_valid
XU2 MUX2 $PINS O=pos[0] S=recursive_case.left_valid
+ A=recursive_case.right_pos[0] B=recursive_case.left_pos[0]
XU3 MUX2 $PINS O=pos[1] S=recursive_case.left_valid
+ A=recursive_case.right_pos[1] B=recursive_case.left_pos[1]
Xrecursive_case.LOD_left LOD_W4_17 $PINS in[3]=in[7] in[2]=in[6] in[1]=in[5]
+ in[0]=in[4] pos[1]=recursive_case.left_pos[1] pos[0]=recursive_case.left_pos[0]
+ valid=recursive_case.left_valid
Xrecursive_case.LOD_right LOD_W4_16 $PINS in[3]=in[3] in[2]=in[2] in[1]=in[1]
+ in[0]=in[0] pos[1]=recursive_case.right_pos[1]
+ pos[0]=recursive_case.right_pos[0] valid=recursive_case.right_valid
.ENDS

.SUBCKT LOD_W16_4 in[15] in[14] in[13] in[12] in[11] in[10] in[9] in[8] in[7]
+ in[6] in[5] in[4] in[3] in[2] in[1] in[0] pos[3] pos[2] pos[1] pos[0] valid
*.CONNECT pos[3] recursive_case.left_valid
XU1 OR2 $PINS O=valid I1=recursive_case.left_valid
+ I2=recursive_case.right_valid
XU2 MUX2 $PINS O=pos[0] S=recursive_case.left_valid
+ A=recursive_case.right_pos[0] B=recursive_case.left_pos[0]
XU3 MUX2 $PINS O=pos[1] S=recursive_case.left_valid
+ A=recursive_case.right_pos[1] B=recursive_case.left_pos[1]
XU4 MUX2 $PINS O=pos[2] S=recursive_case.left_valid
+ A=recursive_case.right_pos[2] B=recursive_case.left_pos[2]
Xrecursive_case.LOD_left LOD_W8_9 $PINS in[7]=in[15] in[6]=in[14] in[5]=in[13]
+ in[4]=in[12] in[3]=in[11] in[2]=in[10] in[1]=in[9] in[0]=in[8]
+ pos[2]=recursive_case.left_pos[2] pos[1]=recursive_case.left_pos[1]
+ pos[0]=recursive_case.left_pos[0] valid=recursive_case.left_valid
Xrecursive_case.LOD_right LOD_W8_8 $PINS in[7]=in[7] in[6]=in[6] in[5]=in[5]
+ in[4]=in[4] in[3]=in[3] in[2]=in[2] in[1]=in[1] in[0]=in[0]
+ pos[2]=recursive_case.right_pos[2] pos[1]=recursive_case.right_pos[1]
+ pos[0]=recursive_case.right_pos[0] valid=recursive_case.right_valid
.ENDS

.SUBCKT LOD_W23 in[22] in[21] in[20] in[19] in[18] in[17] in[16] in[15] in[14]
+ in[13] in[12] in[11] in[10] in[9] in[8] in[7] in[6] in[5] in[4] in[3] in[2]
+ in[1] in[0] pos[4] pos[3] pos[2] pos[1] pos[0] valid
*.CONNECT pos[4] recursive_case.left_valid
XFE_OFC529_mul_pos_4 BUF1 $PINS O=recursive_case.left_valid
+ I=FE_OFN531_mul_pos_4
XU3 OR2 $PINS O=valid I1=recursive_case.left_valid
+ I2=recursive_case.right_valid
XU4 MUX2 $PINS O=pos[0] S=recursive_case.left_valid
+ A=recursive_case.right_pos[0] B=recursive_case.left_pos[0]
XU5 MUX2 $PINS O=pos[1] S=FE_OFN531_mul_pos_4 A=recursive_case.right_pos[1]
+ B=recursive_case.left_pos[1]
XU6 MUX2 $PINS O=pos[2] S=FE_OFN531_mul_pos_4 A=recursive_case.right_pos[2]
+ B=recursive_case.left_pos[2]
XU7 AN2B1S $PINS O=pos[3] I1=recursive_case.right_pos[3]
+ B1=recursive_case.left_valid
Xrecursive_case.LOD_left LOD_W16_5 $PINS in[15]=*Logic0* in[14]=*Logic0*
+ in[13]=*Logic0* in[12]=*Logic0* in[11]=*Logic0* in[10]=*Logic0* in[9]=*Logic0*
+ in[8]=*Logic0* in[7]=*Logic0* in[6]=in[22] in[5]=in[21] in[4]=in[20]
+ in[3]=in[19] in[2]=in[18] in[1]=in[17] in[0]=in[16]
+ pos[3]=SYNOPSYS_UNCONNECTED__0 pos[2]=recursive_case.left_pos[2]
+ pos[1]=recursive_case.left_pos[1] pos[0]=recursive_case.left_pos[0]
+ valid=FE_OFN531_mul_pos_4
Xrecursive_case.LOD_right LOD_W16_4 $PINS in[15]=in[15] in[14]=in[14]
+ in[13]=in[13] in[12]=in[12] in[11]=in[11] in[10]=in[10] in[9]=in[9] in[8]=in[8]
+ in[7]=in[7] in[6]=in[6] in[5]=in[5] in[4]=in[4] in[3]=in[3] in[2]=in[2]
+ in[1]=in[1] in[0]=in[0] pos[3]=recursive_case.right_pos[3]
+ pos[2]=recursive_case.right_pos[2] pos[1]=recursive_case.right_pos[1]
+ pos[0]=recursive_case.right_pos[0] valid=recursive_case.right_valid
.ENDS

.SUBCKT mult_pipe_5 rst_n A[15] A[14] A[13] A[12] A[11] A[10] A[9] A[8] A[7]
+ A[6] A[5] A[4] A[3] A[2] A[1] A[0] B[15] B[14] B[13] B[12] B[11] B[10] B[9]
+ B[8] B[7] B[6] B[5] B[4] B[3] B[2] B[1] B[0] result[31] result[30] result[29]
+ result[28] result[27] result[26] result[25] result[24] result[23] result[22]
+ result[21] result[20] result[19] result[18] result[17] result[16] result[15]
+ result[14] result[13] result[12] result[11] result[10] result[9] result[8]
+ result[7] result[6] result[5] result[4] result[3] result[2] result[1]
+ result[0] Iy2_shift_15 Iy2_shift_14 IxIt_shift_7 n1438 n1437 n4486 n4487
+ FE_OFN114_i_reset_n_i FE_OFN111_i_reset_n_i FE_OFN107_i_reset_n_i
+ FE_OFN103_i_reset_n_i FE_OFN101_i_reset_n_i FE_OFN99_i_reset_n_i
+ FE_OFN92_i_reset_n_i FE_OFN90_i_reset_n_i FE_OFN87_i_reset_n_i
+ FE_OFN85_i_reset_n_i FE_OFN83_i_reset_n_i FE_OFN73_i_reset_n_i
+ FE_OFN72_i_reset_n_i FE_OFN66_i_reset_n_i FE_OFN64_i_reset_n_i
+ FE_OFN62_i_reset_n_i FE_OFN50_i_reset_n_i FE_OFN43_i_reset_n_i
+ FE_OFN42_i_reset_n_i FE_OFN39_i_reset_n_i FE_OFN23_i_reset_n_i
+ FE_OFN135_IxIt_shift_1 FE_OFN134_IxIt_shift_1 FE_OFN133_IxIt_shift_1
+ FE_OFN137_IxIt_shift_0 FE_OFN150_IxIt_shift_15 FE_OFN149_IxIt_shift_15
+ FE_OFN151_IxIt_shift_14 FE_OFN153_IxIt_shift_13 FE_OFN152_IxIt_shift_13
+ FE_OFN177_n1437 FE_OFN186_n4487 FE_OFN225_IxIt_shift_12
+ FE_OFN224_IxIt_shift_12 FE_OFN226_IxIt_shift_11 FE_OFN227_IxIt_shift_10
+ FE_OFN230_IxIt_shift_8 FE_OFN229_IxIt_shift_8 FE_OFN228_IxIt_shift_8
+ FE_OFN232_IxIt_shift_7 FE_OFN231_IxIt_shift_7 FE_OFN234_IxIt_shift_3
+ FE_OFN240_FE_DBTN39_n1437 FE_OFN261_IxIt_shift_6 FE_OFN199_i_reset_n_i
+ FE_OFN1194_FE_DBTN12_Iy2_shift_15 FE_OFN1306_Iy2_shift_9 clk_clone3
+ clk_clone2 clk_clone1 clk
XFE_PHC3301_N76 BUF1S $PINS O=FE_PHN3301_N76 I=FE_PHN3202_N76
XFE_PHC3202_N76 BUF1S $PINS O=FE_PHN3202_N76 I=N76
XFE_PHC3133_N74 DELB $PINS O=FE_PHN3133_N74 I=N74
XFE_PHC3130_N75 DELB $PINS O=N75 I=FE_PHN3130_N75
XFE_PHC3124_N68 DELB $PINS O=FE_PHN3124_N68 I=N68
XFE_PHC3112_N70 DELB $PINS O=N70 I=FE_PHN3112_N70
XFE_PHC3109_N73 DELB $PINS O=FE_PHN3109_N73 I=N73
XFE_PHC3107_N71 DELB $PINS O=N71 I=FE_PHN3107_N71
XFE_PHC3105_N69 DELB $PINS O=FE_PHN3105_N69 I=N69
XFE_PHC3102_N72 DELB $PINS O=N72 I=FE_PHN3102_N72
XFE_OFC2936_Iy2_shift_9 BUF1 $PINS O=FE_OFN4371_n I=FE_OFN2741_Iy2_shift_9
XFE_OFC2741_Iy2_shift_9 BUF2 $PINS O=FE_OFN2741_Iy2_shift_9
+ I=FE_OFN1306_Iy2_shift_9
XFE_OFC2925_n410 BUF1 $PINS O=FE_OFN4360_n I=FE_OFN1512_n410
XFE_OFC2901_Iy2_shift_8 BUF1 $PINS O=FE_OFN4336_Iy2_shift_8
+ I=FE_OFN4335_Iy2_shift_8
XFE_OFC2900_Iy2_shift_8 BUF1 $PINS O=FE_OFN4335_Iy2_shift_8 I=A[8]
XFE_OFC2859_FE_DBTN136_Iy2_shift_9 BUF1 $PINS
+ O=FE_OFN4294_FE_DBTN136_Iy2_shift_9 I=FE_OFN4293_FE_DBTN136_Iy2_shift_9
XFE_OFC2858_FE_DBTN136_Iy2_shift_9 INV1S $PINS
+ O=FE_OFN4293_FE_DBTN136_Iy2_shift_9 I=FE_OFN4291_FE_DBTN136_Iy2_shift_9
XFE_OFC2857_FE_DBTN136_Iy2_shift_9 BUF1 $PINS
+ O=FE_OFN4292_FE_DBTN136_Iy2_shift_9 I=FE_DBTN136_Iy2_shift_9
XFE_OFC2856_FE_DBTN136_Iy2_shift_9 INV1S $PINS
+ O=FE_OFN4291_FE_DBTN136_Iy2_shift_9 I=FE_DBTN136_Iy2_shift_9
XFE_OFC2851_Iy2_shift_11 INV1S $PINS O=FE_OFN4286_n I=FE_OFN4283_n
XFE_OFC2850_Iy2_shift_11 INV1S $PINS O=FE_OFN4285_n I=FE_OFN4283_n
XFE_OFC2849_Iy2_shift_11 INV1S $PINS O=FE_OFN4284_n I=FE_OFN4283_n
XFE_OFC2848_Iy2_shift_11 INV1S $PINS O=FE_OFN4283_n I=FE_OFN1298_Iy2_shift_11
XFE_OFC2826_FE_OFN1361_IxIt_shift_8 BUF1 $PINS
+ O=FE_OFN4261_FE_OFN1361_IxIt_shift_8 I=FE_OFN228_IxIt_shift_8
XFE_OFC2821_FE_OFN1092_Iy2_shift_15 BUF1 $PINS
+ O=FE_OFN4256_FE_OFN1092_Iy2_shift_15 I=FE_OFN1092_Iy2_shift_15
XFE_OFC2787_FE_OFN1293_Iy2_shift_11 BUF1 $PINS
+ O=FE_OFN4222_FE_OFN1293_Iy2_shift_11 I=FE_OFN4221_FE_OFN1293_Iy2_shift_11
XFE_OFC2786_FE_OFN1293_Iy2_shift_11 BUF1 $PINS
+ O=FE_OFN4221_FE_OFN1293_Iy2_shift_11 I=FE_OFN1293_Iy2_shift_11
XFE_OFC2735_FE_OFN1011_FE_DBTN138_Iy2_shift_13 BUF1 $PINS
+ O=FE_OFN4170_FE_OFN1011_FE_DBTN138_Iy2_shift_13
+ I=FE_OFN4169_FE_OFN1011_FE_DBTN138_Iy2_shift_13
XFE_OFC2734_FE_OFN1011_FE_DBTN138_Iy2_shift_13 INV1S $PINS
+ O=FE_OFN4169_FE_OFN1011_FE_DBTN138_Iy2_shift_13
+ I=FE_OFN4168_FE_OFN1011_FE_DBTN138_Iy2_shift_13
XFE_OFC2733_FE_OFN1011_FE_DBTN138_Iy2_shift_13 INV1S $PINS
+ O=FE_OFN4168_FE_OFN1011_FE_DBTN138_Iy2_shift_13
+ I=FE_OFN1011_FE_DBTN138_Iy2_shift_13
XFE_OFC2732_FE_OFN1011_FE_DBTN138_Iy2_shift_13 BUF1 $PINS
+ O=FE_OFN4167_FE_OFN1011_FE_DBTN138_Iy2_shift_13
+ I=FE_OFN1011_FE_DBTN138_Iy2_shift_13
XFE_RC_1_0 XOR2HS $PINS O=n371 I1=FE_OFN230_IxIt_shift_8
+ I2=FE_OFN4256_FE_OFN1092_Iy2_shift_15
XFE_RC_0_0 XOR2HS $PINS O=n340 I1=B[11] I2=FE_OFN1092_Iy2_shift_15
XFE_OFC2615_IxIt_shift_1 INV1S $PINS O=FE_OFN4132_IxIt_shift_1
+ I=FE_OFN133_IxIt_shift_1
XFE_OFC2614_IxIt_shift_1 INV1S $PINS O=FE_OFN4131_IxIt_shift_1
+ I=FE_OFN133_IxIt_shift_1
XFE_OFC2613_IxIt_shift_1 INV1S $PINS O=FE_OFN4130_IxIt_shift_1
+ I=FE_OFN133_IxIt_shift_1
XFE_OFC2607_Iy2_shift_0 BUF1 $PINS O=FE_OFN4128_Iy2_shift_0 I=A[0]
XFE_OFC2546_Iy2_shift_1 BUF1 $PINS O=FE_OFN4116_Iy2_shift_1 I=A[1]
XFE_OFC2494_IxIt_shift_5 BUF1 $PINS O=FE_OFN291_FE_DBTN105_IxIt_shift_5
+ I=FE_DBTN105_IxIt_shift_5
XFE_OFC2492_IxIt_shift_5 BUF1 $PINS O=FE_DBTN105_IxIt_shift_5
+ I=FE_OFN290_FE_DBTN105_IxIt_shift_5
XFE_OFC2490_IxIt_shift_5 INV1S $PINS O=FE_OFN290_FE_DBTN105_IxIt_shift_5 I=B[5]
XFE_OFC2455_n431 BUF1 $PINS O=FE_OFN1745_n431 I=FE_OFN1535_n431
XFE_OFC2454_n431 BUF1 $PINS O=FE_OFN1535_n431 I=n431
XFE_OFC2442_IxIt_shift_15 BUF1 $PINS O=FE_OFN1142_n318 I=FE_RN_7
XFE_OFC2441_IxIt_shift_15 INV1S $PINS O=n318 I=FE_RN_7
XFE_OFC2439_IxIt_shift_15 INV1S $PINS O=FE_RN_7 I=FE_OFN150_IxIt_shift_15
XFE_OFC2438_IxIt_shift_6 BUF1 $PINS O=FE_OFN1738_IxIt_shift_6
+ I=FE_OFN1737_IxIt_shift_6
XFE_OFC2437_IxIt_shift_6 BUF1 $PINS O=FE_OFN1737_IxIt_shift_6
+ I=FE_OFN287_FE_DBTN107_IxIt_shift_6
XFE_OFC2435_IxIt_shift_6 BUF1 $PINS O=FE_OFN287_FE_DBTN107_IxIt_shift_6
+ I=FE_OFN286_FE_DBTN107_IxIt_shift_6
XFE_OFC2432_IxIt_shift_6 INV1S $PINS O=FE_OFN286_FE_DBTN107_IxIt_shift_6 I=B[6]
XFE_OFC2417_IxIt_shift_11 INV1S $PINS O=FE_OFN1728_IxIt_shift_11 I=n435
XFE_OFC2416_IxIt_shift_11 INV1S $PINS O=FE_OFN1727_IxIt_shift_11 I=B[11]
XFE_OFC2412_IxIt_shift_11 INV1S $PINS O=n435 I=B[11]
XFE_OFC2406_IxIt_shift_12 BUF1 $PINS O=FE_OFN1513_n433
+ I=FE_OFN225_IxIt_shift_12
XFE_OFC2403_IxIt_shift_12 BUF1 $PINS O=FE_OFN1348_IxIt_shift_12 I=B[12]
XFE_OFC2379_Iy2_shift_14 BUF1 $PINS O=FE_RN_5
+ I=FE_OFN1182_FE_DBTN27_Iy2_shift_14
XFE_OFC2376_Iy2_shift_14 BUF1 $PINS O=FE_OFN1182_FE_DBTN27_Iy2_shift_14
+ I=Iy2_shift_14
XFE_OFC2374_Iy2_shift_14 INV1S $PINS O=FE_OFN1095_Iy2_shift_14 I=Iy2_shift_14
XFE_OFC2360_IxIt_shift_13 INV1S $PINS O=n262 I=FE_OFN987_IxIt_shift_13
XFE_OFC2358_IxIt_shift_13 BUF1 $PINS O=FE_OFN987_IxIt_shift_13
+ I=FE_OFN152_IxIt_shift_13
XFE_OFC2192_FE_DBTN131_Iy2_shift_4 BUF1 $PINS
+ O=FE_OFN280_FE_DBTN131_Iy2_shift_4 I=FE_DBTN131_Iy2_shift_4
XFE_OFC2170_n348 BUF1 $PINS O=FE_OFN1657_n348 I=FE_DBTN90_n348
XFE_OFC2169_n348 INV1S $PINS O=FE_OFN1481_FE_DBTN90_n348 I=FE_DBTN90_n348
XFE_OFC2168_n348 INV1S $PINS O=FE_DBTN90_n348 I=n348
XFE_OFC2092_Iy2_shift_15 BUF1 $PINS O=FE_OFN1093_Iy2_shift_15
+ I=FE_OFN4256_FE_OFN1092_Iy2_shift_15
XFE_OFC2089_Iy2_shift_15 BUF1 $PINS O=FE_OFN1092_Iy2_shift_15 I=A[15]
XFE_OFC2047_n4486 BUF1 $PINS O=FE_OFN1633_n4486 I=FE_OFN1244_n4486
XFE_OFC2046_n4486 BUF1 $PINS O=FE_OFN1247_n4486 I=n4486
XFE_OFC2044_n4486 BUF1 $PINS O=FE_OFN1244_n4486 I=A[5]
XFE_OFC2029_IxIt_shift_9 BUF1 $PINS O=FE_OFN1461_FE_DBTN111_IxIt_shift_9
+ I=FE_DBTN111_IxIt_shift_9
XFE_OFC2028_IxIt_shift_9 INV2 $PINS O=FE_DBTN111_IxIt_shift_9
+ I=FE_OFN1359_IxIt_shift_9
XFE_OFC2027_IxIt_shift_9 BUF1 $PINS O=FE_OFN1359_IxIt_shift_9 I=B[9]
XFE_OFC2025_Iy2_shift_10 BUF1 $PINS O=FE_OFN1510_n231 I=FE_OFN1300_Iy2_shift_10
XFE_OFC2024_Iy2_shift_10 INV1S $PINS O=n231 I=FE_OFN1300_Iy2_shift_10
XFE_OFC2020_Iy2_shift_10 INV1S $PINS O=FE_OFN1300_Iy2_shift_10 I=A[10]
XFE_OFC1965_n1438 BUF1 $PINS O=FE_OFN1488_FE_DBTN38_n1438 I=FE_OFN1201_n1438
XFE_OFC1964_n1438 BUF1 $PINS O=FE_OFN1203_n1438 I=FE_OFN1490_FE_DBTN38_n1438
XFE_OFC1961_n1438 BUF1 $PINS O=FE_OFN1201_n1438 I=FE_OFN1207_n1438
XFE_OFC1959_n1438 BUF1 $PINS O=FE_OFN1490_FE_DBTN38_n1438 I=A[3]
XFE_OFC1957_n1438 BUF1 $PINS O=FE_OFN1207_n1438 I=n1438
XFE_OFC1936_Iy2_shift_2 BUF1 $PINS O=FE_OFN1605_Iy2_shift_2
+ I=FE_OFN1451_FE_DBTN129_Iy2_shift_2
XFE_OFC1935_Iy2_shift_2 BUF1 $PINS O=FE_OFN1450_FE_DBTN129_Iy2_shift_2
+ I=FE_OFN1451_FE_DBTN129_Iy2_shift_2
XFE_OFC1931_Iy2_shift_2 BUF1 $PINS O=FE_OFN1451_FE_DBTN129_Iy2_shift_2
+ I=FE_DBTN129_Iy2_shift_2
XFE_OFC1930_Iy2_shift_2 INV1S $PINS O=FE_OFN1449_FE_DBTN129_Iy2_shift_2
+ I=FE_DBTN129_Iy2_shift_2
XFE_OFC1926_Iy2_shift_2 BUF1 $PINS O=FE_DBTN129_Iy2_shift_2 I=A[2]
XFE_OFC1905_n1437 BUF1 $PINS O=FE_OFN1598_n1437 I=B[2]
XFE_OFC1904_n1437 BUF1 $PINS O=FE_OFN1597_n1437 I=B[2]
XFE_OFC1899_n1437 BUF1 $PINS O=FE_OFN1198_n1437 I=FE_OFN177_n1437
XFE_OFC1799_Iy2_shift_13 BUF1CK $PINS O=FE_OFN1011_FE_DBTN138_Iy2_shift_13
+ I=FE_OFN1012_FE_DBTN138_Iy2_shift_13
XFE_OFC1795_Iy2_shift_13 INV1S $PINS O=FE_OFN1012_FE_DBTN138_Iy2_shift_13
+ I=FE_OFN964_Iy2_shift_13
XFE_OFC1793_Iy2_shift_13 BUF1 $PINS O=FE_OFN964_Iy2_shift_13
+ I=FE_OFN962_Iy2_shift_13
XFE_OFC1791_Iy2_shift_13 BUF1 $PINS O=FE_OFN962_Iy2_shift_13 I=A[13]
XFE_OFC1763_Iy2_shift_11 BUF1 $PINS O=FE_OFN1436_FE_DBTN137_Iy2_shift_11
+ I=FE_OFN4284_n
XFE_OFC1762_Iy2_shift_11 INV1S $PINS O=FE_OFN1296_Iy2_shift_11 I=FE_OFN4284_n
XFE_OFC1761_Iy2_shift_11 INV1S $PINS O=FE_OFN1298_Iy2_shift_11
+ I=FE_OFN4221_FE_OFN1293_Iy2_shift_11
XFE_OFC1758_Iy2_shift_11 INV1S $PINS O=FE_OFN1293_Iy2_shift_11 I=A[11]
XFE_OFC1757_Iy2_shift_11 INV1S $PINS O=FE_OFN1438_FE_DBTN137_Iy2_shift_11
+ I=A[11]
XFE_OFC1671_Iy2_shift_8 BUF1 $PINS O=FE_OFN1309_Iy2_shift_8
+ I=FE_OFN4335_Iy2_shift_8
XFE_OFC1670_Iy2_shift_8 INV1S $PINS O=FE_OFN1512_n410 I=FE_OFN4335_Iy2_shift_8
XFE_OFC1644_IxIt_shift_8 INV1S $PINS O=FE_DBTN109_IxIt_shift_8
+ I=FE_OFN228_IxIt_shift_8
XFE_OFC1643_IxIt_shift_8 INV1S $PINS O=FE_OFN1466_FE_DBTN109_IxIt_shift_8
+ I=FE_OFN4261_FE_OFN1361_IxIt_shift_8
XFE_OFC1641_IxIt_shift_8 BUF1 $PINS O=FE_OFN1362_IxIt_shift_8
+ I=FE_OFN228_IxIt_shift_8
XFE_OFC1598_Iy2_shift_9 INV1S $PINS O=FE_DBTN136_Iy2_shift_9
+ I=FE_OFN1308_Iy2_shift_9
XFE_OFC1597_Iy2_shift_9 BUF1 $PINS O=FE_OFN1308_Iy2_shift_9
+ I=FE_OFN2741_Iy2_shift_9
XFE_OFC1534_n444 BUF1 $PINS O=FE_OFN1536_n444 I=n444
XFE_OFC1532_n424 BUF1 $PINS O=FE_OFN1534_n424 I=n424
XFE_OFC1513_n458 BUF1 $PINS O=FE_OFN1515_n458 I=n458
XFE_OFC1512_n457 BUF1 $PINS O=FE_OFN1514_n457 I=n457
XFE_OFC1509_n307 BUF1 $PINS O=FE_OFN1511_n307 I=n307
XFE_OFC1498_FE_DBTN28_IxIt_shift_7 BUF1 $PINS
+ O=FE_OFN1500_FE_DBTN28_IxIt_shift_7 I=B[7]
XFE_OFC1468_FE_DBTN103_IxIt_shift_3 BUF1 $PINS
+ O=FE_OFN1470_FE_DBTN103_IxIt_shift_3 I=FE_DBTN103_IxIt_shift_3
XFE_OFC1467_FE_DBTN103_IxIt_shift_3 BUF1 $PINS
+ O=FE_OFN1469_FE_DBTN103_IxIt_shift_3 I=FE_DBTN103_IxIt_shift_3
XFE_OFC1458_FE_DBTN112_IxIt_shift_10 BUF1 $PINS
+ O=FE_OFN1460_FE_DBTN112_IxIt_shift_10 I=FE_DBTN112_IxIt_shift_10
XFE_OFC1444_FE_DBTN132_Iy2_shift_6 BUF1 $PINS
+ O=FE_OFN1446_FE_DBTN132_Iy2_shift_6 I=FE_DBTN132_Iy2_shift_6
XFE_OFC1315_Iy2_shift_6 BUF1 $PINS O=FE_OFN1317_Iy2_shift_6 I=A[6]
XFE_OFC1249_n4487 BUF1 $PINS O=FE_OFN1251_n4487 I=FE_OFN1249_n4487
XFE_OFC1247_n4487 BUF1 $PINS O=FE_OFN1249_n4487 I=FE_OFN186_n4487
XFE_OFC1213_n1667 BUF1 $PINS O=FE_OFN1215_n1667 I=A[12]
XFE_OFC1206_n1622 BUF1 $PINS O=FE_OFN1208_n1622 I=A[7]
XFE_OFC1193_FE_DBTN12_Iy2_shift_15 BUF1 $PINS
+ O=FE_OFN1195_FE_DBTN12_Iy2_shift_15 I=FE_OFN1194_FE_DBTN12_Iy2_shift_15
XFE_OFC1017_FE_DBTN115_IxIt_shift_14 INV1S $PINS
+ O=FE_OFN1019_FE_DBTN115_IxIt_shift_14 I=FE_OFN1017_FE_DBTN115_IxIt_shift_14
XFE_OFC1016_FE_DBTN115_IxIt_shift_14 INV1S $PINS
+ O=FE_OFN1018_FE_DBTN115_IxIt_shift_14 I=FE_OFN1017_FE_DBTN115_IxIt_shift_14
XFE_OFC1015_FE_DBTN115_IxIt_shift_14 INV1S $PINS
+ O=FE_OFN1017_FE_DBTN115_IxIt_shift_14 I=FE_DBTN115_IxIt_shift_14
XFE_OFC993_n143 BUF1 $PINS O=FE_OFN995_n143 I=n143
XFE_OFC882_FE_DBTN128_Iy2_shift_0 BUF1 $PINS O=FE_OFN884_FE_DBTN128_Iy2_shift_0
+ I=FE_DBTN128_Iy2_shift_0
XFE_OFC863_IxIt_shift_0 BUF1 $PINS O=FE_OFN865_IxIt_shift_0 I=B[0]
XFE_OFC838_Iy2_shift_0 BUF1 $PINS O=FE_OFN840_Iy2_shift_0
+ I=FE_OFN4128_Iy2_shift_0
XFE_OFC836_Iy2_shift_1 BUF1 $PINS O=FE_OFN838_Iy2_shift_1
+ I=FE_OFN835_Iy2_shift_1
XFE_OFC833_Iy2_shift_1 BUF1 $PINS O=FE_OFN835_Iy2_shift_1
+ I=FE_OFN4116_Iy2_shift_1
XFE_OFC257_i_reset_n_i BUF1 $PINS O=FE_OFN259_i_reset_n_i
+ I=FE_OFN101_i_reset_n_i
XFE_OFC231_i_reset_n_i BUF1 $PINS O=FE_OFN233_i_reset_n_i
+ I=FE_OFN200_i_reset_n_i
XFE_OFC230_i_reset_n_i BUF1 $PINS O=FE_OFN232_i_reset_n_i
+ I=FE_OFN200_i_reset_n_i
XFE_OFC228_i_reset_n_i BUF1 $PINS O=FE_OFN230_i_reset_n_i
+ I=FE_OFN92_i_reset_n_i
XFE_OFC198_i_reset_n_i BUF1 $PINS O=FE_OFN200_i_reset_n_i
+ I=FE_OFN73_i_reset_n_i
XFE_OFC182_i_reset_n_i BUF1 $PINS O=FE_OFN184_i_reset_n_i
+ I=FE_OFN64_i_reset_n_i
XFE_DBTC132_Iy2_shift_6 INV1S $PINS O=FE_DBTN132_Iy2_shift_6
+ I=FE_OFN1317_Iy2_shift_6
XFE_DBTC131_Iy2_shift_4 INV1S $PINS O=FE_DBTN131_Iy2_shift_4 I=A[4]
XFE_DBTC128_Iy2_shift_0 INV2 $PINS O=FE_DBTN128_Iy2_shift_0
+ I=FE_OFN840_Iy2_shift_0
XFE_DBTC115_IxIt_shift_14 INV1S $PINS O=FE_DBTN115_IxIt_shift_14
+ I=FE_OFN151_IxIt_shift_14
XFE_DBTC112_IxIt_shift_10 INV1S $PINS O=FE_DBTN112_IxIt_shift_10
+ I=FE_OFN227_IxIt_shift_10
XFE_DBTC103_IxIt_shift_3 INV1S $PINS O=FE_DBTN103_IxIt_shift_3
+ I=FE_OFN234_IxIt_shift_3
Xs1_P0_reg[9] QDFFRBN $PINS Q=s1_P0[9] D=N10 CK=clk RB=FE_OFN199_i_reset_n_i
Xs1_P0_reg[7] QDFFRBN $PINS Q=FE_PHN3130_N75 D=N8 CK=clk_clone1
+ RB=FE_OFN92_i_reset_n_i
Xs1_P0_reg[6] QDFFRBN $PINS Q=N74 D=N7 CK=clk_clone1 RB=FE_OFN92_i_reset_n_i
Xs1_P0_reg[5] QDFFRBN $PINS Q=N73 D=N6 CK=clk_clone1 RB=FE_OFN72_i_reset_n_i
Xs1_P0_reg[4] QDFFRBN $PINS Q=FE_PHN3102_N72 D=N5 CK=clk_clone1
+ RB=FE_OFN72_i_reset_n_i
Xs1_P0_reg[3] QDFFRBN $PINS Q=FE_PHN3107_N71 D=N4 CK=clk_clone1
+ RB=FE_OFN72_i_reset_n_i
Xs1_P0_reg[2] QDFFRBN $PINS Q=FE_PHN3112_N70 D=N3 CK=clk_clone1
+ RB=FE_OFN92_i_reset_n_i
Xs1_P0_reg[1] QDFFRBN $PINS Q=N69 D=N2 CK=clk_clone1 RB=FE_OFN230_i_reset_n_i
Xs1_P0_reg[0] QDFFRBN $PINS Q=N68 D=N1 CK=clk_clone1 RB=FE_OFN259_i_reset_n_i
Xs1_P1_reg[15] QDFFRBN $PINS Q=s1_P1[15] D=N33 CK=clk_clone1
+ RB=FE_OFN230_i_reset_n_i
Xs1_P1_reg[1] QDFFRBN $PINS Q=s1_P1[1] D=N19 CK=clk RB=FE_OFN200_i_reset_n_i
Xs1_P2_reg[15] QDFFRBN $PINS Q=s1_P2[15] D=N50 CK=clk_clone1
+ RB=FE_OFN230_i_reset_n_i
Xs1_P2_reg[1] QDFFRBN $PINS Q=s1_P2[1] D=N36 CK=clk RB=FE_OFN199_i_reset_n_i
Xs1_P3_reg[14] QDFFRBN $PINS Q=s1_P3[14] D=N66 CK=clk_clone1
+ RB=FE_OFN50_i_reset_n_i
Xs1_P3_reg[13] QDFFRBN $PINS Q=s1_P3[13] D=N65 CK=clk_clone1
+ RB=FE_OFN50_i_reset_n_i
Xs1_P3_reg[12] QDFFRBN $PINS Q=s1_P3[12] D=N64 CK=clk_clone1
+ RB=FE_OFN50_i_reset_n_i
Xs1_P3_reg[11] QDFFRBN $PINS Q=s1_P3[11] D=N63 CK=clk_clone1
+ RB=FE_OFN90_i_reset_n_i
Xs1_P3_reg[10] QDFFRBN $PINS Q=s1_P3[10] D=N62 CK=clk_clone1
+ RB=FE_OFN107_i_reset_n_i
Xs1_P3_reg[9] QDFFRBN $PINS Q=s1_P3[9] D=N61 CK=clk_clone1
+ RB=FE_OFN107_i_reset_n_i
Xs1_P3_reg[8] QDFFRBN $PINS Q=s1_P3[8] D=N60 CK=clk_clone1
+ RB=FE_OFN230_i_reset_n_i
Xs1_P3_reg[7] QDFFRBN $PINS Q=s1_P3[7] D=N59 CK=clk_clone1
+ RB=FE_OFN230_i_reset_n_i
Xs2_result_reg[31] QDFFRBN $PINS Q=result[31] D=N99 CK=clk_clone3
+ RB=FE_OFN23_i_reset_n_i
Xs2_result_reg[30] QDFFRBN $PINS Q=result[30] D=N98 CK=clk_clone3
+ RB=FE_OFN42_i_reset_n_i
Xs2_result_reg[29] QDFFRBN $PINS Q=result[29] D=N97 CK=clk_clone3
+ RB=FE_OFN42_i_reset_n_i
Xs2_result_reg[28] QDFFRBN $PINS Q=result[28] D=N96 CK=clk_clone1
+ RB=FE_OFN64_i_reset_n_i
Xs2_result_reg[27] QDFFRBN $PINS Q=result[27] D=N95 CK=clk_clone3
+ RB=FE_OFN62_i_reset_n_i
Xs2_result_reg[26] QDFFRBN $PINS Q=result[26] D=N94 CK=clk_clone3
+ RB=FE_OFN42_i_reset_n_i
Xs2_result_reg[24] QDFFRBN $PINS Q=result[24] D=N92 CK=clk_clone1
+ RB=FE_OFN64_i_reset_n_i
Xs2_result_reg[23] QDFFRBN $PINS Q=result[23] D=N91 CK=clk_clone1
+ RB=FE_OFN64_i_reset_n_i
Xs2_result_reg[22] QDFFRBN $PINS Q=result[22] D=N90 CK=clk_clone3
+ RB=FE_OFN23_i_reset_n_i
Xs2_result_reg[21] QDFFRBN $PINS Q=result[21] D=N89 CK=clk_clone3
+ RB=FE_OFN184_i_reset_n_i
Xs2_result_reg[20] QDFFRBN $PINS Q=result[20] D=N88 CK=clk_clone3
+ RB=FE_OFN184_i_reset_n_i
Xs2_result_reg[19] QDFFRBN $PINS Q=result[19] D=N87 CK=clk_clone2
+ RB=FE_OFN39_i_reset_n_i
Xs2_result_reg[18] QDFFRBN $PINS Q=result[18] D=N86 CK=clk_clone2
+ RB=FE_OFN39_i_reset_n_i
Xs2_result_reg[17] QDFFRBN $PINS Q=result[17] D=N85 CK=clk_clone2
+ RB=FE_OFN99_i_reset_n_i
Xs2_result_reg[16] QDFFRBN $PINS Q=result[16] D=N84 CK=clk_clone2
+ RB=FE_OFN85_i_reset_n_i
Xs2_result_reg[15] QDFFRBN $PINS Q=result[15] D=N83 CK=clk_clone2
+ RB=FE_OFN66_i_reset_n_i
Xs2_result_reg[14] QDFFRBN $PINS Q=result[14] D=N82 CK=clk_clone2
+ RB=FE_OFN43_i_reset_n_i
Xs2_result_reg[13] QDFFRBN $PINS Q=result[13] D=N81 CK=clk_clone2
+ RB=FE_OFN99_i_reset_n_i
Xs2_result_reg[12] QDFFRBN $PINS Q=result[12] D=N80 CK=clk_clone2
+ RB=FE_OFN43_i_reset_n_i
Xs2_result_reg[11] QDFFRBN $PINS Q=result[11] D=N79 CK=clk_clone1 RB=rst_n
Xs2_result_reg[9] QDFFRBN $PINS Q=result[9] D=N77 CK=clk_clone1 RB=rst_n
Xs2_result_reg[8] QDFFRBN $PINS Q=result[8] D=FE_PHN3301_N76 CK=clk_clone3
+ RB=FE_OFN114_i_reset_n_i
Xs2_result_reg[7] QDFFRBN $PINS Q=result[7] D=N75 CK=clk_clone3
+ RB=FE_OFN111_i_reset_n_i
Xs2_result_reg[6] QDFFRBN $PINS Q=result[6] D=FE_PHN3133_N74 CK=clk_clone3
+ RB=FE_OFN111_i_reset_n_i
Xs2_result_reg[5] QDFFRBN $PINS Q=result[5] D=FE_PHN3109_N73 CK=clk_clone1
+ RB=FE_OFN83_i_reset_n_i
Xs2_result_reg[4] QDFFRBN $PINS Q=result[4] D=N72 CK=clk_clone1
+ RB=FE_OFN83_i_reset_n_i
Xs2_result_reg[3] QDFFRBN $PINS Q=result[3] D=N71 CK=clk_clone1
+ RB=FE_OFN90_i_reset_n_i
Xs2_result_reg[2] QDFFRBN $PINS Q=result[2] D=N70 CK=clk_clone1
+ RB=FE_OFN90_i_reset_n_i
Xs2_result_reg[1] QDFFRBN $PINS Q=result[1] D=FE_PHN3105_N69 CK=clk_clone1
+ RB=FE_OFN107_i_reset_n_i
Xs2_result_reg[0] QDFFRBN $PINS Q=result[0] D=FE_PHN3124_N68 CK=clk_clone1
+ RB=FE_OFN107_i_reset_n_i
Xintadd_39/U14 FA1S $PINS S=N20 CO=intadd_39/n13 A=intadd_39/B[0]
+ B=intadd_39/A[0] CI=intadd_39/CI
Xintadd_39/U13 FA1 $PINS S=N21 CO=intadd_39/n12 A=intadd_39/B[1]
+ B=intadd_39/A[1] CI=intadd_39/n13
Xintadd_39/U12 FA1 $PINS S=N22 CO=intadd_39/n11 A=intadd_39/B[2]
+ B=intadd_39/A[2] CI=intadd_39/n12
Xintadd_39/U11 FA1 $PINS S=N23 CO=intadd_39/n10 A=intadd_39/B[3]
+ B=intadd_39/A[3] CI=intadd_39/n11
Xintadd_39/U10 FA1 $PINS S=N24 CO=intadd_39/n9 A=intadd_39/B[4]
+ B=intadd_39/A[4] CI=intadd_39/n10
Xintadd_39/U9 FA1 $PINS S=N25 CO=intadd_39/n8 A=intadd_39/B[5] B=intadd_39/A[5]
+ CI=intadd_39/n9
Xintadd_39/U8 FA1 $PINS S=N26 CO=intadd_39/n7 A=intadd_56/n1 B=intadd_39/A[6]
+ CI=intadd_39/n8
Xintadd_39/U3 FA1 $PINS S=N31 CO=intadd_39/n2 A=intadd_39/B[11] B=intadd_54/n1
+ CI=intadd_39/n3
Xintadd_39/U2 FA1 $PINS S=N32 CO=intadd_39/n1 A=intadd_39/B[12]
+ B=intadd_39/A[12] CI=intadd_39/n2
Xintadd_42/U5 FA1S $PINS S=intadd_42/SUM[0] CO=intadd_42/n4 A=intadd_42/B[0]
+ B=intadd_42/A[0] CI=intadd_42/CI
Xintadd_42/U4 FA1S $PINS S=intadd_42/SUM[1] CO=intadd_42/n3 A=intadd_42/B[1]
+ B=intadd_42/A[1] CI=intadd_42/n4
Xintadd_42/U3 FA1S $PINS S=intadd_42/SUM[2] CO=intadd_42/n2 A=intadd_42/B[2]
+ B=intadd_42/A[2] CI=intadd_42/n3
Xintadd_42/U2 FA1S $PINS S=intadd_42/SUM[3] CO=intadd_42/n1 A=intadd_42/B[3]
+ B=intadd_42/A[3] CI=intadd_42/n2
Xintadd_43/U5 FA1S $PINS S=intadd_43/SUM[0] CO=intadd_43/n4 A=intadd_43/B[0]
+ B=intadd_43/A[0] CI=intadd_43/CI
Xintadd_43/U4 FA1S $PINS S=intadd_43/SUM[1] CO=intadd_43/n3 A=intadd_43/B[1]
+ B=intadd_43/A[1] CI=intadd_43/n4
Xintadd_43/U3 FA1S $PINS S=intadd_43/SUM[2] CO=intadd_43/n2 A=intadd_43/B[2]
+ B=intadd_43/A[2] CI=intadd_43/n3
Xintadd_43/U2 FA1S $PINS S=intadd_43/SUM[3] CO=intadd_43/n1 A=intadd_43/B[3]
+ B=intadd_42/SUM[2] CI=intadd_43/n2
Xintadd_44/U5 FA1S $PINS S=intadd_44/SUM[0] CO=intadd_44/n4 A=intadd_44/B[0]
+ B=intadd_44/A[0] CI=intadd_44/CI
Xintadd_44/U4 FA1S $PINS S=intadd_44/SUM[1] CO=intadd_44/n3 A=intadd_44/B[1]
+ B=intadd_44/A[1] CI=intadd_44/n4
Xintadd_44/U3 FA1S $PINS S=intadd_44/SUM[2] CO=intadd_44/n2 A=intadd_42/SUM[0]
+ B=intadd_44/A[2] CI=intadd_44/n3
Xintadd_44/U2 FA1S $PINS S=intadd_44/SUM[3] CO=intadd_44/n1 A=intadd_42/SUM[1]
+ B=intadd_43/SUM[2] CI=intadd_44/n2
Xintadd_45/U5 FA1S $PINS S=intadd_45/SUM[0] CO=intadd_45/n4 A=intadd_45/B[0]
+ B=intadd_45/A[0] CI=intadd_45/CI
Xintadd_45/U4 FA1S $PINS S=intadd_45/SUM[1] CO=intadd_45/n3 A=intadd_45/B[1]
+ B=intadd_45/A[1] CI=intadd_45/n4
Xintadd_45/U3 FA1S $PINS S=intadd_45/SUM[2] CO=intadd_45/n2 A=intadd_45/B[2]
+ B=intadd_45/A[2] CI=intadd_45/n3
Xintadd_45/U2 FA1S $PINS S=intadd_39/A[9] CO=intadd_45/n1 A=intadd_45/B[3]
+ B=intadd_45/A[3] CI=intadd_45/n2
Xintadd_46/U5 FA1S $PINS S=intadd_46/SUM[0] CO=intadd_46/n4 A=intadd_46/B[0]
+ B=intadd_46/A[0] CI=intadd_46/CI
Xintadd_46/U4 FA1S $PINS S=intadd_46/SUM[1] CO=intadd_46/n3 A=intadd_46/B[1]
+ B=intadd_46/A[1] CI=intadd_46/n4
Xintadd_46/U3 FA1S $PINS S=intadd_46/SUM[2] CO=intadd_46/n2 A=intadd_46/B[2]
+ B=intadd_46/A[2] CI=intadd_46/n3
Xintadd_46/U2 FA1S $PINS S=intadd_39/A[8] CO=intadd_46/n1 A=intadd_46/B[3]
+ B=intadd_45/SUM[2] CI=intadd_46/n2
Xintadd_47/U5 FA1S $PINS S=intadd_47/SUM[0] CO=intadd_47/n4 A=intadd_47/B[0]
+ B=intadd_47/A[0] CI=intadd_47/CI
Xintadd_47/U4 FA1S $PINS S=intadd_47/SUM[1] CO=intadd_47/n3 A=intadd_47/B[1]
+ B=intadd_47/A[1] CI=intadd_47/n4
Xintadd_47/U3 FA1S $PINS S=intadd_47/SUM[2] CO=intadd_47/n2 A=intadd_45/SUM[0]
+ B=intadd_47/A[2] CI=intadd_47/n3
Xintadd_47/U2 FA1S $PINS S=intadd_39/A[7] CO=intadd_47/n1 A=intadd_46/SUM[2]
+ B=intadd_45/SUM[1] CI=intadd_47/n2
Xintadd_48/U5 FA1S $PINS S=intadd_48/SUM[0] CO=intadd_48/n4 A=intadd_48/B[0]
+ B=intadd_48/A[0] CI=intadd_48/CI
Xintadd_48/U4 FA1S $PINS S=intadd_48/SUM[1] CO=intadd_48/n3 A=intadd_48/B[1]
+ B=intadd_48/A[1] CI=intadd_48/n4
Xintadd_48/U3 FA1S $PINS S=intadd_48/SUM[2] CO=intadd_48/n2 A=intadd_48/B[2]
+ B=intadd_48/A[2] CI=intadd_48/n3
Xintadd_48/U2 FA1S $PINS S=intadd_48/SUM[3] CO=intadd_48/n1 A=intadd_48/B[3]
+ B=intadd_48/A[3] CI=intadd_48/n2
Xintadd_49/U5 FA1S $PINS S=intadd_49/SUM[0] CO=intadd_49/n4 A=intadd_49/B[0]
+ B=intadd_49/A[0] CI=intadd_49/CI
Xintadd_49/U4 FA1S $PINS S=intadd_49/SUM[1] CO=intadd_49/n3 A=intadd_49/B[1]
+ B=intadd_49/A[1] CI=intadd_49/n4
Xintadd_49/U3 FA1S $PINS S=intadd_49/SUM[2] CO=intadd_49/n2 A=intadd_49/B[2]
+ B=intadd_49/A[2] CI=intadd_49/n3
Xintadd_49/U2 FA1S $PINS S=intadd_49/SUM[3] CO=intadd_49/n1 A=intadd_49/B[3]
+ B=intadd_48/SUM[2] CI=intadd_49/n2
Xintadd_50/U5 FA1S $PINS S=intadd_50/SUM[0] CO=intadd_50/n4 A=intadd_50/B[0]
+ B=intadd_50/A[0] CI=intadd_50/CI
Xintadd_50/U4 FA1S $PINS S=intadd_50/SUM[1] CO=intadd_50/n3 A=intadd_50/B[1]
+ B=intadd_50/A[1] CI=intadd_50/n4
Xintadd_50/U3 FA1S $PINS S=intadd_50/SUM[2] CO=intadd_50/n2 A=intadd_48/SUM[0]
+ B=intadd_50/A[2] CI=intadd_50/n3
Xintadd_50/U2 FA1S $PINS S=intadd_50/SUM[3] CO=intadd_50/n1 A=intadd_49/SUM[2]
+ B=intadd_48/SUM[1] CI=intadd_50/n2
Xintadd_51/U4 FA1S $PINS S=intadd_42/A[2] CO=intadd_51/n3 A=intadd_51/B[0]
+ B=intadd_51/A[0] CI=intadd_51/CI
Xintadd_51/U3 FA1S $PINS S=intadd_42/A[3] CO=intadd_51/n2 A=intadd_51/B[1]
+ B=intadd_51/A[1] CI=intadd_51/n3
Xintadd_51/U2 FA1S $PINS S=intadd_51/SUM[2] CO=intadd_51/n1 A=intadd_51/B[2]
+ B=intadd_51/A[2] CI=intadd_51/n2
Xintadd_52/U4 FA1S $PINS S=intadd_52/SUM[0] CO=intadd_52/n3 A=intadd_52/B[0]
+ B=intadd_52/A[0] CI=intadd_52/CI
Xintadd_52/U3 FA1S $PINS S=intadd_52/SUM[1] CO=intadd_52/n2 A=intadd_43/SUM[0]
+ B=intadd_52/A[1] CI=intadd_52/n3
Xintadd_52/U2 FA1S $PINS S=intadd_52/SUM[2] CO=intadd_52/n1 A=intadd_43/SUM[1]
+ B=intadd_44/SUM[2] CI=intadd_52/n2
Xintadd_53/U4 FA1S $PINS S=intadd_53/SUM[0] CO=intadd_53/n3 A=intadd_53/B[0]
+ B=intadd_53/A[0] CI=intadd_53/CI
Xintadd_53/U3 FA1S $PINS S=intadd_53/SUM[1] CO=intadd_53/n2 A=intadd_53/B[1]
+ B=intadd_44/SUM[0] CI=intadd_53/n3
Xintadd_53/U2 FA1S $PINS S=intadd_53/SUM[2] CO=intadd_53/n1 A=intadd_44/SUM[1]
+ B=intadd_52/SUM[1] CI=intadd_53/n2
Xintadd_54/U4 FA1S $PINS S=intadd_45/B[2] CO=intadd_54/n3 A=intadd_54/B[0]
+ B=intadd_54/A[0] CI=intadd_54/CI
Xintadd_54/U3 FA1S $PINS S=intadd_45/A[3] CO=intadd_54/n2 A=intadd_54/B[1]
+ B=intadd_54/A[1] CI=intadd_54/n3
Xintadd_54/U2 FA1S $PINS S=intadd_39/A[10] CO=intadd_54/n1 A=intadd_54/B[2]
+ B=intadd_54/A[2] CI=intadd_54/n2
Xintadd_55/U4 FA1S $PINS S=intadd_55/SUM[0] CO=intadd_55/n3 A=intadd_55/B[0]
+ B=intadd_55/A[0] CI=intadd_55/CI
Xintadd_55/U3 FA1S $PINS S=intadd_55/SUM[1] CO=intadd_55/n2 A=intadd_46/SUM[0]
+ B=intadd_55/A[1] CI=intadd_55/n3
Xintadd_55/U2 FA1S $PINS S=intadd_39/A[6] CO=intadd_55/n1 A=intadd_47/SUM[2]
+ B=intadd_46/SUM[1] CI=intadd_55/n2
Xintadd_56/U4 FA1S $PINS S=intadd_56/SUM[0] CO=intadd_56/n3 A=intadd_56/B[0]
+ B=intadd_56/A[0] CI=intadd_56/CI
Xintadd_56/U3 FA1S $PINS S=intadd_56/SUM[1] CO=intadd_56/n2 A=intadd_47/SUM[0]
+ B=intadd_56/A[1] CI=intadd_56/n3
Xintadd_56/U2 FA1S $PINS S=intadd_39/A[5] CO=intadd_56/n1 A=intadd_47/SUM[1]
+ B=intadd_55/SUM[1] CI=intadd_56/n2
Xintadd_57/U4 FA1S $PINS S=intadd_48/B[2] CO=intadd_57/n3 A=intadd_57/B[0]
+ B=intadd_57/A[0] CI=intadd_57/CI
Xintadd_57/U3 FA1S $PINS S=intadd_48/A[3] CO=intadd_57/n2 A=intadd_57/B[1]
+ B=intadd_57/A[1] CI=intadd_57/n3
Xintadd_57/U2 FA1S $PINS S=intadd_57/SUM[2] CO=intadd_57/n1 A=intadd_57/B[2]
+ B=intadd_57/A[2] CI=intadd_57/n2
Xintadd_58/U4 FA1S $PINS S=intadd_58/SUM[0] CO=intadd_58/n3 A=intadd_58/B[0]
+ B=intadd_58/A[0] CI=intadd_58/CI
Xintadd_58/U3 FA1S $PINS S=intadd_58/SUM[1] CO=intadd_58/n2 A=intadd_49/SUM[0]
+ B=intadd_58/A[1] CI=intadd_58/n3
Xintadd_58/U2 FA1S $PINS S=intadd_58/SUM[2] CO=intadd_58/n1 A=intadd_50/SUM[2]
+ B=intadd_49/SUM[1] CI=intadd_58/n2
Xintadd_59/U4 FA1S $PINS S=intadd_59/SUM[0] CO=intadd_59/n3 A=intadd_59/B[0]
+ B=intadd_59/A[0] CI=intadd_59/CI
Xintadd_59/U3 FA1S $PINS S=intadd_59/SUM[1] CO=intadd_59/n2 A=intadd_50/SUM[0]
+ B=intadd_59/A[1] CI=intadd_59/n3
Xintadd_59/U2 FA1S $PINS S=intadd_59/SUM[2] CO=intadd_59/n1 A=intadd_50/SUM[1]
+ B=intadd_58/SUM[1] CI=intadd_59/n2
Xintadd_37/U24 FA1S $PINS S=n478 CO=n479 A=N9 B=N18 CI=N35
Xintadd_37/U4 FA1 $PINS S=N96 CO=intadd_37/n3 A=intadd_37/B[20] B=s1_P3[11]
+ CI=intadd_37/n4
Xintadd_37/U3 FA1 $PINS S=N97 CO=intadd_37/n2 A=intadd_37/B[21] B=s1_P3[12]
+ CI=intadd_37/n3
Xintadd_38/U14 FA1S $PINS S=N37 CO=intadd_38/n13 A=intadd_38/B[0]
+ B=intadd_38/A[0] CI=intadd_38/CI
Xintadd_38/U13 FA1S $PINS S=N38 CO=intadd_38/n12 A=intadd_38/B[1]
+ B=intadd_38/A[1] CI=intadd_38/n13
Xintadd_38/U12 FA1 $PINS S=N39 CO=intadd_38/n11 A=intadd_38/B[2]
+ B=intadd_38/A[2] CI=intadd_38/n12
Xintadd_38/U11 FA1 $PINS S=N40 CO=intadd_38/n10 A=intadd_38/B[3]
+ B=intadd_38/A[3] CI=intadd_38/n11
Xintadd_38/U10 FA1 $PINS S=N41 CO=intadd_38/n9 A=intadd_38/B[4]
+ B=intadd_38/A[4] CI=intadd_38/n10
Xintadd_38/U9 FA1 $PINS S=N42 CO=intadd_38/n8 A=intadd_38/B[5]
+ B=intadd_59/SUM[2] CI=intadd_38/n9
Xintadd_38/U8 FA1 $PINS S=N43 CO=intadd_38/n7 A=intadd_59/n1 B=intadd_58/SUM[2]
+ CI=intadd_38/n8
Xintadd_38/U3 FA1 $PINS S=N48 CO=intadd_38/n2 A=intadd_38/B[11] B=intadd_57/n1
+ CI=intadd_38/n3
Xintadd_38/U2 FA1 $PINS S=N49 CO=intadd_38/n1 A=intadd_38/B[12]
+ B=intadd_38/A[12] CI=intadd_38/n2
Xintadd_40/U13 FA1 $PINS S=N55 CO=intadd_40/n12 A=intadd_40/B[0]
+ B=intadd_40/A[0] CI=intadd_40/CI
Xintadd_40/U12 FA1 $PINS S=N56 CO=intadd_40/n11 A=intadd_40/B[1]
+ B=intadd_40/A[1] CI=intadd_40/n12
Xintadd_40/U10 FA1 $PINS S=N58 CO=intadd_40/n9 A=intadd_40/B[3]
+ B=intadd_40/A[3] CI=intadd_40/n10
Xintadd_40/U8 FA1 $PINS S=N60 CO=intadd_40/n7 A=intadd_40/B[5] B=intadd_40/A[5]
+ CI=intadd_40/n8
Xintadd_40/U6 FA1 $PINS S=N62 CO=intadd_40/n5 A=intadd_40/B[7] B=intadd_40/A[7]
+ CI=intadd_40/n6
Xintadd_41/U13 FA1S $PINS S=N3 CO=intadd_41/n12 A=intadd_41/B[0]
+ B=intadd_41/A[0] CI=intadd_41/CI
Xintadd_41/U12 FA1 $PINS S=N4 CO=intadd_41/n11 A=intadd_41/B[1]
+ B=intadd_41/A[1] CI=intadd_41/n12
Xintadd_41/U11 FA1 $PINS S=N5 CO=intadd_41/n10 A=intadd_41/B[2]
+ B=intadd_41/A[2] CI=intadd_41/n11
XR_0 QDFFRBN $PINS Q=intadd_37/A[15] D=n505 CK=clk_clone1
+ RB=FE_OFN259_i_reset_n_i
XR_1 QDFFRBN $PINS Q=intadd_37/B[14] D=n504 CK=clk_clone1
+ RB=FE_OFN259_i_reset_n_i
XR_2 QDFFRBN $PINS Q=intadd_37/A[14] D=n503 CK=clk_clone1
+ RB=FE_OFN259_i_reset_n_i
XR_3 QDFFRBN $PINS Q=intadd_37/B[13] D=n502 CK=clk_clone1
+ RB=FE_OFN259_i_reset_n_i
XR_5 QDFFRBN $PINS Q=intadd_37/B[12] D=n500 CK=clk_clone1
+ RB=FE_OFN101_i_reset_n_i
XR_6 QDFFRBN $PINS Q=intadd_37/A[12] D=n499 CK=clk_clone1
+ RB=FE_OFN101_i_reset_n_i
XR_7 QDFFRBN $PINS Q=intadd_37/B[11] D=n498 CK=clk_clone2
+ RB=FE_OFN87_i_reset_n_i
XR_8 QDFFRBN $PINS Q=intadd_37/A[11] D=n497 CK=clk_clone2
+ RB=FE_OFN87_i_reset_n_i
XR_9 QDFFRBN $PINS Q=intadd_37/B[10] D=n496 CK=clk_clone2
+ RB=FE_OFN87_i_reset_n_i
XR_10 QDFFRBN $PINS Q=intadd_37/A[10] D=n495 CK=clk RB=FE_OFN87_i_reset_n_i
XR_11 QDFFRBN $PINS Q=intadd_37/B[9] D=n494 CK=clk RB=FE_OFN103_i_reset_n_i
XR_12 QDFFRBN $PINS Q=intadd_37/A[9] D=n493 CK=clk RB=FE_OFN103_i_reset_n_i
XR_13 QDFFRBN $PINS Q=intadd_37/B[8] D=n492 CK=clk RB=FE_OFN103_i_reset_n_i
XR_14 QDFFRBN $PINS Q=intadd_37/A[8] D=n491 CK=clk RB=FE_OFN103_i_reset_n_i
XR_15 QDFFRBN $PINS Q=intadd_37/B[7] D=n490 CK=clk RB=FE_OFN232_i_reset_n_i
XR_16 QDFFRBN $PINS Q=intadd_37/A[7] D=n489 CK=clk RB=FE_OFN103_i_reset_n_i
XR_17 QDFFRBN $PINS Q=intadd_37/B[6] D=n488 CK=clk RB=FE_OFN232_i_reset_n_i
XR_18 QDFFRBN $PINS Q=intadd_37/A[6] D=n487 CK=clk RB=FE_OFN233_i_reset_n_i
XR_20 QDFFRBN $PINS Q=intadd_37/A[5] D=n485 CK=clk RB=FE_OFN233_i_reset_n_i
XR_21 QDFFRBN $PINS Q=intadd_37/B[4] D=n484 CK=clk RB=FE_OFN233_i_reset_n_i
XR_22 QDFFRBN $PINS Q=intadd_37/A[4] D=n483 CK=clk RB=FE_OFN233_i_reset_n_i
XR_23 QDFFRBN $PINS Q=intadd_37/B[3] D=n482 CK=clk RB=FE_OFN233_i_reset_n_i
XR_24 QDFFRBN $PINS Q=intadd_37/A[3] D=n481 CK=clk RB=FE_OFN200_i_reset_n_i
XR_25 QDFFRBN $PINS Q=intadd_37/B[2] D=n480 CK=clk RB=FE_OFN200_i_reset_n_i
XR_26 QDFFRBN $PINS Q=intadd_37/n23 D=n479 CK=clk RB=FE_OFN200_i_reset_n_i
XR_27 QDFFRBN $PINS Q=N76 D=n478 CK=clk_clone1 RB=FE_OFN92_i_reset_n_i
Xintadd_37/U6 FA1 $PINS S=N94 CO=intadd_37/n5 A=intadd_37/B[18] B=s1_P3[9]
+ CI=intadd_37/n6
Xintadd_37/U8 FA1 $PINS S=N92 CO=intadd_37/n7 A=intadd_37/B[16]
+ B=intadd_37/A[16] CI=intadd_37/n8
Xintadd_37/U13 FA1 $PINS S=N87 CO=intadd_37/n12 A=intadd_37/B[11]
+ B=intadd_37/A[11] CI=intadd_37/n13
Xintadd_37/U15 FA1 $PINS S=N85 CO=intadd_37/n14 A=intadd_37/B[9]
+ B=intadd_37/A[9] CI=intadd_37/n15
Xintadd_37/U17 FA1 $PINS S=N83 CO=intadd_37/n16 A=intadd_37/B[7]
+ B=intadd_37/A[7] CI=intadd_37/n17
Xintadd_37/U19 FA1 $PINS S=N81 CO=intadd_37/n18 A=intadd_37/B[5]
+ B=intadd_37/A[5] CI=intadd_37/n19
Xintadd_37/U21 FA1S $PINS S=N79 CO=intadd_37/n20 A=intadd_37/B[3]
+ B=intadd_37/A[3] CI=intadd_37/n21
Xintadd_37/U22 FA1S $PINS S=N78 CO=intadd_37/n21 A=intadd_37/B[2]
+ B=intadd_37/A[2] CI=intadd_37/n22
Xintadd_39/U4 FA1 $PINS S=N30 CO=intadd_39/n3 A=intadd_45/n1 B=intadd_39/A[10]
+ CI=intadd_39/n4
Xintadd_41/U2 FA1 $PINS S=N14 CO=intadd_41/n1 A=intadd_51/n1 B=intadd_41/A[11]
+ CI=intadd_41/n2
Xintadd_38/U4 FA1S $PINS S=N47 CO=intadd_38/n3 A=intadd_48/n1
+ B=intadd_57/SUM[2] CI=intadd_38/n4
Xintadd_41/U3 FA1 $PINS S=N13 CO=intadd_41/n2 A=intadd_42/n1 B=intadd_51/SUM[2]
+ CI=intadd_41/n3
Xintadd_39/U5 FA1 $PINS S=N29 CO=intadd_39/n4 A=intadd_46/n1 B=intadd_39/A[9]
+ CI=intadd_39/n5
Xintadd_38/U5 FA1 $PINS S=N46 CO=intadd_38/n4 A=intadd_49/n1 B=intadd_48/SUM[3]
+ CI=intadd_38/n5
Xintadd_41/U4 FA1 $PINS S=N12 CO=intadd_41/n3 A=intadd_43/n1 B=intadd_42/SUM[3]
+ CI=intadd_41/n4
Xintadd_39/U6 FA1 $PINS S=N28 CO=intadd_39/n5 A=intadd_47/n1 B=intadd_39/A[8]
+ CI=intadd_39/n6
Xintadd_38/U6 FA1 $PINS S=N45 CO=intadd_38/n5 A=intadd_50/n1 B=intadd_49/SUM[3]
+ CI=intadd_38/n6
Xintadd_41/U5 FA1 $PINS S=N11 CO=intadd_41/n4 A=intadd_44/n1 B=intadd_43/SUM[3]
+ CI=intadd_41/n5
Xintadd_39/U7 FA1 $PINS S=N27 CO=intadd_39/n6 A=intadd_55/n1 B=intadd_39/A[7]
+ CI=intadd_39/n7
Xintadd_38/U7 FA1 $PINS S=N44 CO=intadd_38/n6 A=intadd_58/n1 B=intadd_50/SUM[3]
+ CI=intadd_38/n7
Xintadd_41/U7 FA1 $PINS S=N9 CO=intadd_41/n6 A=intadd_53/n1 B=intadd_52/SUM[2]
+ CI=intadd_41/n7
Xintadd_41/U6 FA1 $PINS S=N10 CO=intadd_41/n5 A=intadd_52/n1 B=intadd_44/SUM[3]
+ CI=intadd_41/n6
Xintadd_41/U8 FA1 $PINS S=N8 CO=intadd_41/n7 A=intadd_41/B[5]
+ B=intadd_53/SUM[2] CI=intadd_41/n8
Xintadd_41/U9 FA1 $PINS S=N7 CO=intadd_41/n8 A=intadd_41/B[4] B=intadd_41/A[4]
+ CI=intadd_41/n9
Xintadd_41/U10 FA1 $PINS S=N6 CO=intadd_41/n9 A=intadd_41/B[3] B=intadd_41/A[3]
+ CI=intadd_41/n10
Xintadd_37/U5 FA1 $PINS S=N95 CO=intadd_37/n4 A=intadd_37/B[19] B=s1_P3[10]
+ CI=intadd_37/n5
Xintadd_37/U7 FA1 $PINS S=N93 CO=intadd_37/n6 A=intadd_37/B[17]
+ B=intadd_37/A[17] CI=intadd_37/n7
Xintadd_37/U2 FA1 $PINS S=N98 CO=intadd_37/n1 A=s1_P3[13] B=intadd_37/A[22]
+ CI=intadd_37/n2
Xintadd_37/U16 FA1 $PINS S=N84 CO=intadd_37/n15 A=intadd_37/B[8]
+ B=intadd_37/A[8] CI=intadd_37/n16
Xintadd_37/U23 FA1S $PINS S=N77 CO=intadd_37/n22 A=intadd_37/B[1] B=s1_P1[1]
+ CI=intadd_37/n23
Xintadd_40/U11 FA1 $PINS S=N57 CO=intadd_40/n10 A=intadd_40/B[2]
+ B=intadd_40/A[2] CI=intadd_40/n11
Xintadd_37/U20 FA1 $PINS S=N80 CO=intadd_37/n19 A=intadd_37/B[4]
+ B=intadd_37/A[4] CI=intadd_37/n20
Xintadd_37/U18 FA1 $PINS S=N82 CO=intadd_37/n17 A=intadd_37/B[6]
+ B=intadd_37/A[6] CI=intadd_37/n18
Xintadd_37/U14 FA1 $PINS S=N86 CO=intadd_37/n13 A=intadd_37/B[10]
+ B=intadd_37/A[10] CI=intadd_37/n14
Xintadd_40/U9 FA1 $PINS S=N59 CO=intadd_40/n8 A=intadd_40/B[4] B=intadd_40/A[4]
+ CI=intadd_40/n9
Xintadd_40/U7 FA1 $PINS S=N61 CO=intadd_40/n6 A=intadd_40/B[6] B=intadd_40/A[6]
+ CI=intadd_40/n7
Xintadd_40/U5 FA1S $PINS S=N63 CO=intadd_40/n4 A=intadd_40/B[8]
+ B=intadd_40/A[8] CI=intadd_40/n5
Xintadd_37/U12 FA1 $PINS S=N88 CO=intadd_37/n11 A=intadd_37/B[12]
+ B=intadd_37/A[12] CI=intadd_37/n12
XU5 INV1S $PINS O=n143 I=FE_OFN835_Iy2_shift_1
XU35 MOAI1S $PINS O=n100 A1=n169 A2=n168 B1=n169 B2=n168
XU36 NR2 $PINS O=intadd_52/A[0] I1=n157 I2=n156
XU37 ND2S $PINS O=n121 I1=FE_OFN4128_Iy2_shift_0 I2=FE_OFN1597_n1437
XU38 ND2S $PINS O=n107 I1=FE_OFN1362_IxIt_shift_8 I2=FE_OFN838_Iy2_shift_1
XU39 ND2S $PINS O=n109 I1=FE_OFN151_IxIt_shift_14 I2=FE_OFN840_Iy2_shift_0
XU41 ND2S $PINS O=n130 I1=FE_OFN4116_Iy2_shift_1 I2=B[0]
XU42 MOAI1S $PINS O=n348 A1=FE_OFN2741_Iy2_shift_9 A2=A[10]
+ B1=FE_OFN2741_Iy2_shift_9 B2=A[10]
XU45 MOAI1S $PINS O=N99 A1=intadd_37/A[22] A2=n98 B1=intadd_37/A[22] B2=n98
XU46 ND2S $PINS O=n375 I1=n384 I2=n383
XU47 ND2S $PINS O=n412 I1=n417 I2=n416
XU48 ND2S $PINS O=n461 I1=FE_OFN1208_n1622 I2=B[7]
XU49 ND2S $PINS O=n127 I1=FE_OFN1598_n1437 I2=FE_OFN1317_Iy2_shift_6
XU50 ND2S $PINS O=n118 I1=FE_RN_5 I2=FE_OFN1597_n1437
XU51 ND3 $PINS O=n174 I1=FE_OFN1490_FE_DBTN38_n1438 I2=B[0] I3=n178
XU52 ND2S $PINS O=intadd_39/A[12] I1=FE_OFN1195_FE_DBTN12_Iy2_shift_15
+ I2=FE_OFN1500_FE_DBTN28_IxIt_shift_7
XU53 ND2S $PINS O=n402 I1=FE_OFN228_IxIt_shift_8 I2=n458
XU56 ND2S $PINS O=n110 I1=FE_OFN987_IxIt_shift_13 I2=FE_OFN835_Iy2_shift_1
XU57 ND2S $PINS O=n276 I1=FE_OFN1348_IxIt_shift_12 I2=FE_OFN1203_n1438
XU58 ND2S $PINS O=n267 I1=n318 I2=FE_OFN1490_FE_DBTN38_n1438
XU59 ND2S $PINS O=n305 I1=B[13] I2=A[7]
XU60 NR2 $PINS O=intadd_44/B[1] I1=n123 I2=n122
XU63 ND3 $PINS O=n225 I1=FE_OFN1309_Iy2_shift_8 I2=FE_OFN1598_n1437 I3=n93
XU64 ND3 $PINS O=n232 I1=n231 I2=FE_OFN135_IxIt_shift_1 I3=n228
XU65 ND3 $PINS O=n471 I1=n97 I2=FE_OFN1308_Iy2_shift_9
+ I3=FE_OFN1466_FE_DBTN109_IxIt_shift_8
XU66 ND2S $PINS O=n450 I1=FE_OFN4261_FE_OFN1361_IxIt_shift_8 I2=n431
XU67 ND2S $PINS O=n447 I1=FE_OFN4222_FE_OFN1293_Iy2_shift_11 I2=FE_DBTN90_n348
XU69 ND2S $PINS O=n114 I1=FE_OFN1308_Iy2_shift_9 I2=FE_OFN137_IxIt_shift_0
XU70 ND2S $PINS O=n245 I1=FE_RN_5 I2=FE_OFN1500_FE_DBTN28_IxIt_shift_7
XU71 ND2S $PINS O=n223 I1=FE_OFN1215_n1667 I2=FE_OFN137_IxIt_shift_0
XU72 ND2S $PINS O=n177 I1=FE_OFN1490_FE_DBTN38_n1438 I2=B[0]
XU73 ND2S $PINS O=n95 I1=n231 I2=FE_OFN135_IxIt_shift_1
XU74 ND2S $PINS O=n87 I1=FE_OFN1359_IxIt_shift_9 I2=FE_OFN838_Iy2_shift_1
XU75 ND2S $PINS O=n119 I1=FE_OFN1308_Iy2_shift_9
+ I2=FE_OFN1500_FE_DBTN28_IxIt_shift_7
XU76 ND2S $PINS O=n198 I1=FE_OFN1195_FE_DBTN12_Iy2_shift_15
+ I2=FE_OFN234_IxIt_shift_3
XU78 ND2S $PINS O=n116 I1=FE_RN_5 I2=FE_OFN137_IxIt_shift_0
XU79 ND2S $PINS O=n117 I1=FE_OFN964_Iy2_shift_13 I2=FE_OFN134_IxIt_shift_1
XU80 ND2S $PINS O=n156 I1=FE_OFN865_IxIt_shift_0 I2=FE_OFN1247_n4486
XU81 ND2S $PINS O=n240 I1=FE_OFN964_Iy2_shift_13
+ I2=FE_OFN1500_FE_DBTN28_IxIt_shift_7
XU82 ND2S $PINS O=n207 I1=FE_OFN1215_n1667 I2=FE_OFN234_IxIt_shift_3
XU83 ND2S $PINS O=intadd_54/A[1] I1=FE_OFN1195_FE_DBTN12_Iy2_shift_15 I2=B[4]
XU84 ND2S $PINS O=n210 I1=FE_OFN964_Iy2_shift_13 I2=FE_OFN137_IxIt_shift_0
XU85 ND2S $PINS O=n123 I1=FE_OFN4131_IxIt_shift_1 I2=FE_OFN1247_n4486
XU86 ND2S $PINS O=n122 I1=FE_OFN1317_Iy2_shift_6 I2=FE_OFN865_IxIt_shift_0
XU87 ND2S $PINS O=n290 I1=n435 I2=FE_OFN838_Iy2_shift_1
XU88 ND2S $PINS O=n256 I1=FE_OFN1348_IxIt_shift_12 I2=n4486
XU89 ND2S $PINS O=intadd_38/A[12] I1=FE_OFN149_IxIt_shift_15 I2=A[7]
XU90 ND2S $PINS O=n280 I1=FE_OFN1348_IxIt_shift_12 I2=FE_OFN835_Iy2_shift_1
XU91 ND2S $PINS O=n311 I1=FE_OFN151_IxIt_shift_14 I2=A[7]
XU93 ND2S $PINS O=n126 I1=FE_OFN4131_IxIt_shift_1 I2=FE_OFN1208_n1622
XU94 ND2S $PINS O=n97 I1=B[9] I2=A[8]
XU95 ND2S $PINS O=n88 I1=FE_OFN227_IxIt_shift_10 I2=FE_OFN838_Iy2_shift_1
XU96 ND2S $PINS O=n112 I1=FE_OFN1359_IxIt_shift_9 I2=FE_OFN1208_n1622
XU97 ND2S $PINS O=n89 I1=FE_OFN1362_IxIt_shift_8 I2=FE_OFN1203_n1438
XU98 ND2S $PINS O=n124 I1=FE_OFN1208_n1622 I2=FE_OFN865_IxIt_shift_0
XU99 ND3 $PINS O=n297 I1=FE_OFN227_IxIt_shift_10 I2=FE_OFN838_Iy2_shift_1
+ I3=n294
XU100 ND2S $PINS O=n111 I1=FE_OFN151_IxIt_shift_14
+ I2=FE_OFN1449_FE_DBTN129_Iy2_shift_2
XU103 ND2S $PINS O=n304 I1=FE_OFN151_IxIt_shift_14 I2=FE_OFN1317_Iy2_shift_6
XU106 ND2S $PINS O=n254 I1=n435 I2=FE_OFN1317_Iy2_shift_6
XU108 ND2S $PINS O=intadd_57/A[1] I1=n318 I2=A[4]
XU110 ND2S $PINS O=n272 I1=FE_OFN1348_IxIt_shift_12 I2=A[4]
XU113 ND2S $PINS O=n125 I1=FE_OFN4131_IxIt_shift_1 I2=FE_OFN1317_Iy2_shift_6
XU116 ND2S $PINS O=n239 I1=FE_RN_5 I2=FE_OFN261_IxIt_shift_6
XU117 ND2S $PINS O=n203 I1=FE_OFN1215_n1667 I2=B[4]
XU118 ND2S $PINS O=n205 I1=FE_OFN1296_Iy2_shift_11 I2=B[4]
XU119 ND2S $PINS O=n187 I1=FE_OFN1296_Iy2_shift_11 I2=FE_OFN261_IxIt_shift_6
XU121 ND2S $PINS O=n189 I1=FE_OFN1215_n1667 I2=B[5]
XU129 ND2S $PINS O=n274 I1=n435 I2=A[4]
XU140 ND2S $PINS O=intadd_37/B[17] I1=n104 I2=n103
XU141 ND2S $PINS O=intadd_37/A[16] I1=n101 I2=n102
XU142 ND2S $PINS O=n101 I1=s1_P3[7] I2=n103
XU143 ND2S $PINS O=n99 I1=n103 I2=n102
XU144 ND2S $PINS O=n102 I1=s1_P1[15] I2=s1_P2[15]
XU150 MOAI1S $PINS O=n431 A1=A[12] A2=FE_OFN4286_n B1=A[12] B2=FE_OFN4286_n
XU152 INV1S $PINS O=n307 I=FE_OFN1208_n1622
XU186 NR2 $PINS O=n444 I1=FE_OFN1657_n348 I2=n336
XU187 MOAI1 $PINS O=n458 A1=FE_OFN1182_FE_DBTN27_Iy2_shift_14
+ A2=FE_OFN4169_FE_OFN1011_FE_DBTN138_Iy2_shift_13
+ B1=FE_OFN1182_FE_DBTN27_Iy2_shift_14
+ B2=FE_OFN4169_FE_OFN1011_FE_DBTN138_Iy2_shift_13
XU191 INV1S $PINS O=n94 I=FE_OFN134_IxIt_shift_1
XU193 NR2 $PINS O=n152 I1=n125 I2=n124
XU196 INV1S $PINS O=n115 I=FE_OFN137_IxIt_shift_0
XU197 MOAI1 $PINS O=n84 A1=n461 A2=n83 B1=n461 B2=n83
XU198 MOAI1 $PINS O=n98 A1=s1_P3[15] A2=intadd_37/n1 B1=s1_P3[15]
+ B2=intadd_37/n1
XU204 MOAI1S $PINS O=n81 A1=FE_OFN226_IxIt_shift_11
+ A2=FE_OFN4293_FE_DBTN136_Iy2_shift_9 B1=FE_OFN226_IxIt_shift_11
+ B2=FE_OFN4293_FE_DBTN136_Iy2_shift_9
XU206 NR2 $PINS O=n436 I1=FE_OFN4336_Iy2_shift_8
+ I2=FE_OFN4293_FE_DBTN136_Iy2_shift_9
XU207 AOI22S $PINS O=n105 A1=A[8] A2=n81 B1=n436
+ B2=FE_OFN1460_FE_DBTN112_IxIt_shift_10
XU209 MOAI1S $PINS O=n439 A1=FE_OFN4222_FE_OFN1293_Iy2_shift_11
+ A2=FE_OFN1461_FE_DBTN111_IxIt_shift_9 B1=FE_OFN4222_FE_OFN1293_Iy2_shift_11
+ B2=FE_OFN1461_FE_DBTN111_IxIt_shift_9
XU210 MOAI1S $PINS O=n336 A1=A[10] A2=FE_OFN1293_Iy2_shift_11 B1=A[10]
+ B2=FE_OFN1438_FE_DBTN137_Iy2_shift_11
XU212 MOAI1S $PINS O=n82 A1=FE_OFN4221_FE_OFN1293_Iy2_shift_11
+ A2=FE_OFN1466_FE_DBTN109_IxIt_shift_8 B1=FE_OFN4221_FE_OFN1293_Iy2_shift_11
+ B2=FE_OFN1466_FE_DBTN109_IxIt_shift_8
XU213 AOI22S $PINS O=n106 A1=FE_DBTN90_n348 A2=n439 B1=FE_OFN1536_n444 B2=n82
XU214 NR2P $PINS O=intadd_40/A[1] I1=n105 I2=n106
XU215 NR2 $PINS O=n136 I1=FE_OFN1446_FE_DBTN132_Iy2_shift_6
+ I2=FE_OFN1738_IxIt_shift_6
XU216 NR2 $PINS O=n135 I1=FE_OFN232_IxIt_shift_7 I2=FE_OFN1633_n4486
XU217 NR2 $PINS O=n134 I1=FE_OFN1511_n307 I2=FE_OFN291_FE_DBTN105_IxIt_shift_5
XU218 NR2 $PINS O=n132 I1=FE_OFN232_IxIt_shift_7
+ I2=FE_OFN1446_FE_DBTN132_Iy2_shift_6
XU219 NR2 $PINS O=n131 I1=FE_OFN1511_n307 I2=FE_OFN1738_IxIt_shift_6
XU220 MAOI1 $PINS O=n83 A1=n460 A2=intadd_41/n1 B1=n460 B2=intadd_41/n1
XU221 FA1 $PINS S=n488 CO=n489 A=N41 B=N24 CI=n84
XU225 NR2 $PINS O=n227 I1=FE_OFN4292_FE_DBTN136_Iy2_shift_9 I2=FE_OFN177_n1437
XU227 MOAI1S $PINS O=n86 A1=n227 A2=n85 B1=n227 B2=n85
XU228 NR2 $PINS O=n93 I1=FE_OFN4292_FE_DBTN136_Iy2_shift_9 I2=n94
XU229 MOAI1S $PINS O=intadd_39/B[1] A1=n86 A2=n225 B1=n86 B2=n225
XU230 OR2 $PINS O=n103 I1=s1_P1[15] I2=s1_P2[15]
XU231 MOAI1S $PINS O=intadd_37/B[15] A1=s1_P3[7] A2=n99 B1=s1_P3[7] B2=n99
XU233 NR2 $PINS O=n90 I1=FE_DBTN109_IxIt_shift_8 I2=FE_OFN1605_Iy2_shift_2
XU235 MOAI1S $PINS O=intadd_38/A[0] A1=n90 A2=n87 B1=n90 B2=n87
XU237 NR2 $PINS O=n294 I1=FE_OFN1728_IxIt_shift_11 I2=FE_DBTN128_Iy2_shift_0
XU238 MOAI1S $PINS O=intadd_38/A[1] A1=n294 A2=n88 B1=n294 B2=n88
XU239 NR2 $PINS O=n293 I1=FE_DBTN111_IxIt_shift_9 I2=FE_OFN1605_Iy2_shift_2
XU240 MOAI1S $PINS O=n91 A1=n293 A2=n89 B1=n293 B2=n89
XU241 ND3 $PINS O=n291 I1=FE_OFN1359_IxIt_shift_9 I2=FE_OFN838_Iy2_shift_1
+ I3=n90
XU242 MOAI1S $PINS O=intadd_38/B[1] A1=n91 A2=n291 B1=n91 B2=n291
XU244 MOAI1S $PINS O=intadd_39/A[0] A1=n93 A2=n92 B1=n93 B2=n92
XU246 NR2 $PINS O=n228 I1=FE_OFN1436_FE_DBTN137_Iy2_shift_11 I2=n115
XU248 MOAI1S $PINS O=intadd_39/A[1] A1=n228 A2=n95 B1=n228 B2=n95
XU262 MOAI1S $PINS O=n96 A1=FE_OFN227_IxIt_shift_10
+ A2=FE_OFN4294_FE_DBTN136_Iy2_shift_9 B1=FE_OFN227_IxIt_shift_10
+ B2=FE_OFN4294_FE_DBTN136_Iy2_shift_9
XU263 AOI22S $PINS O=n475 A1=FE_OFN4336_Iy2_shift_8 A2=n96 B1=n436
+ B2=FE_OFN1461_FE_DBTN111_IxIt_shift_9
XU264 OA12 $PINS O=n476 A1=n471 B1=FE_OFN1466_FE_DBTN109_IxIt_shift_8 B2=n348
XU265 NR2 $PINS O=intadd_40/B[0] I1=n475 I2=n476
XU266 INV1S $PINS O=intadd_37/A[22] I=s1_P3[14]
XU267 MOAI1S $PINS O=intadd_37/B[16] A1=s1_P3[8] A2=n99 B1=s1_P3[8] B2=n99
XU269 ND2 $PINS O=n120 I1=FE_OFN835_Iy2_shift_1 I2=FE_OFN4130_IxIt_shift_1
XU270 NR2 $PINS O=n171 I1=n121 I2=n120
XU271 ND2 $PINS O=n169 I1=FE_OFN1597_n1437 I2=FE_OFN835_Iy2_shift_1
XU272 ND2 $PINS O=n168 I1=FE_OFN840_Iy2_shift_0 I2=B[3]
XU273 MOAI1S $PINS O=intadd_41/A[1] A1=n171 A2=n100 B1=n171 B2=n100
XU275 NR2 $PINS O=intadd_38/B[0] I1=n108 I2=n107
XU277 ND2 $PINS O=n113 I1=FE_OFN1309_Iy2_shift_8 I2=FE_OFN135_IxIt_shift_1
XU278 NR2 $PINS O=intadd_39/B[0] I1=n114 I2=n113
XU279 AN2 $PINS O=intadd_37/A[2] I1=s1_P0[9] I2=s1_P2[1]
XU280 ND2S $PINS O=n104 I1=s1_P3[8] I2=n102
XU281 OAI22S $PINS O=intadd_40/A[0] A1=n106 A2=intadd_40/A[1] B1=n105
+ B2=intadd_40/A[1]
XU282 OAI22S $PINS O=N36 A1=n108 A2=intadd_38/B[0] B1=n107 B2=intadd_38/B[0]
XU285 ND2 $PINS O=n279 I1=FE_OFN987_IxIt_shift_13 I2=FE_OFN840_Iy2_shift_0
XU286 NR2 $PINS O=intadd_58/B[0] I1=n280 I2=n279
XU287 NR2 $PINS O=intadd_50/A[1] I1=n110 I2=n109
XU288 OAI22S $PINS O=intadd_59/A[1] A1=n110 A2=intadd_50/A[1] B1=n109
+ B2=intadd_50/A[1]
XU289 NR2 $PINS O=intadd_48/A[1] I1=n112 I2=n111
XU290 OAI22S $PINS O=intadd_49/A[1] A1=n112 A2=intadd_48/A[1] B1=n111
+ B2=intadd_48/A[1]
XU291 OAI22S $PINS O=N19 A1=n114 A2=intadd_39/B[0] B1=n113 B2=intadd_39/B[0]
XU292 ND2 $PINS O=n211 I1=FE_OFN1215_n1667 I2=FE_OFN134_IxIt_shift_1
XU293 NR2 $PINS O=intadd_55/B[0] I1=n211 I2=n210
XU294 NR2 $PINS O=intadd_47/A[1] I1=n117 I2=n116
XU295 OAI22S $PINS O=intadd_56/A[1] A1=n117 A2=intadd_47/A[1] B1=n116
+ B2=intadd_47/A[1]
XU296 NR2 $PINS O=intadd_45/A[1] I1=n119 I2=n118
XU297 OAI22S $PINS O=intadd_46/A[1] A1=n119 A2=intadd_45/A[1] B1=n118
+ B2=intadd_45/A[1]
XU298 OAI22S $PINS O=intadd_41/A[0] A1=n121 A2=n171 B1=n120 B2=n171
XU299 OAI22S $PINS O=intadd_53/B[1] A1=n123 A2=intadd_44/B[1] B1=n122
+ B2=intadd_44/B[1]
XU300 OAI22S $PINS O=intadd_44/A[1] A1=n125 A2=n152 B1=n124 B2=n152
XU301 NR2 $PINS O=intadd_42/B[1] I1=n127 I2=n126
XU302 OAI22S $PINS O=intadd_43/A[1] A1=n127 A2=intadd_42/B[1] B1=n126
+ B2=intadd_42/B[1]
XU303 NR2 $PINS O=N1 I1=n115 I2=FE_OFN884_FE_DBTN128_Iy2_shift_0
XU304 ND2 $PINS O=n129 I1=FE_OFN4128_Iy2_shift_0 I2=B[1]
XU305 NR2 $PINS O=intadd_41/CI I1=n130 I2=n129
XU306 AOI12HS $PINS O=N2 A1=intadd_41/CI B1=n130 B2=n129
XU307 FA1S $PINS S=intadd_41/A[11] CO=n460 A=n133 B=n132 CI=n131
XU308 FA1S $PINS S=intadd_51/A[2] CO=n133 A=n136 B=n135 CI=n134
XU309 NR2 $PINS O=n139 I1=FE_OFN1446_FE_DBTN132_Iy2_shift_6
+ I2=FE_OFN291_FE_DBTN105_IxIt_shift_5
XU310 NR2 $PINS O=n138 I1=FE_OFN232_IxIt_shift_7
+ I2=FE_OFN280_FE_DBTN131_Iy2_shift_4
XU311 NR2 $PINS O=n137 I1=FE_OFN1511_n307 I2=FE_OFN1251_n4487
XU312 FA1S $PINS S=intadd_51/A[1] CO=intadd_51/B[2] A=n139 B=n138 CI=n137
XU313 NR2 $PINS O=intadd_51/B[1] I1=FE_OFN1633_n4486 I2=FE_OFN1738_IxIt_shift_6
XU314 NR2 $PINS O=intadd_51/A[0] I1=FE_OFN1446_FE_DBTN132_Iy2_shift_6
+ I2=FE_OFN1251_n4487
XU315 NR2 $PINS O=intadd_51/B[0] I1=FE_OFN1488_FE_DBTN38_n1438
+ I2=FE_OFN232_IxIt_shift_7
XU316 NR2 $PINS O=intadd_51/CI I1=FE_OFN1470_FE_DBTN103_IxIt_shift_3
+ I2=FE_OFN1511_n307
XU317 NR2 $PINS O=intadd_42/A[0] I1=n143 I2=IxIt_shift_7
XU318 NR2 $PINS O=intadd_42/B[0] I1=FE_OFN280_FE_DBTN131_Iy2_shift_4
+ I2=FE_OFN1251_n4487
XU319 NR2 $PINS O=intadd_42/CI I1=FE_OFN1470_FE_DBTN103_IxIt_shift_3
+ I2=FE_OFN1633_n4486
XU320 NR2 $PINS O=n142 I1=FE_OFN280_FE_DBTN131_Iy2_shift_4
+ I2=FE_OFN291_FE_DBTN105_IxIt_shift_5
XU321 NR2 $PINS O=n141 I1=FE_OFN1488_FE_DBTN38_n1438 I2=FE_OFN1738_IxIt_shift_6
XU322 NR2 $PINS O=n140 I1=FE_OFN1633_n4486 I2=FE_OFN1251_n4487
XU323 FA1S $PINS S=intadd_43/A[2] CO=intadd_42/B[2] A=n142 B=n141 CI=n140
XU324 NR2 $PINS O=intadd_43/A[0] I1=n143 I2=FE_OFN1737_IxIt_shift_6
XU325 NR2 $PINS O=intadd_43/B[0] I1=FE_DBTN128_Iy2_shift_0 I2=IxIt_shift_7
XU326 NR2 $PINS O=intadd_43/CI I1=FE_OFN1198_n1437 I2=FE_OFN1633_n4486
XU327 NR2 $PINS O=n146 I1=FE_OFN1470_FE_DBTN103_IxIt_shift_3
+ I2=FE_OFN1446_FE_DBTN132_Iy2_shift_6
XU328 NR2 $PINS O=n145 I1=FE_OFN1605_Iy2_shift_2 I2=IxIt_shift_7
XU329 NR2 $PINS O=n144 I1=FE_OFN1198_n1437 I2=FE_OFN1511_n307
XU330 FA1S $PINS S=intadd_43/B[2] CO=n149 A=n146 B=n145 CI=n144
XU331 NR2 $PINS O=n148 I1=FE_OFN280_FE_DBTN131_Iy2_shift_4
+ I2=FE_OFN1738_IxIt_shift_6
XU332 NR2 $PINS O=n147 I1=FE_OFN1633_n4486 I2=FE_OFN291_FE_DBTN105_IxIt_shift_5
XU333 FA1S $PINS S=intadd_43/B[3] CO=intadd_42/B[3] A=n149 B=n148 CI=n147
XU334 NR2 $PINS O=n151 I1=FE_OFN1605_Iy2_shift_2 I2=FE_OFN1737_IxIt_shift_6
XU335 NR2 $PINS O=n150 I1=FE_OFN1488_FE_DBTN38_n1438
+ I2=FE_OFN291_FE_DBTN105_IxIt_shift_5
XU336 FA1S $PINS S=intadd_44/A[2] CO=intadd_42/A[1] A=n152 B=n151 CI=n150
XU337 NR2 $PINS O=intadd_44/A[0] I1=n143 I2=FE_DBTN105_IxIt_shift_5
XU338 NR2 $PINS O=intadd_44/B[0] I1=FE_OFN884_FE_DBTN128_Iy2_shift_0
+ I2=FE_OFN287_FE_DBTN107_IxIt_shift_6
XU339 NR2 $PINS O=intadd_44/CI I1=FE_OFN1198_n1437
+ I2=FE_OFN280_FE_DBTN131_Iy2_shift_4
XU340 NR2 $PINS O=n155 I1=FE_OFN1605_Iy2_shift_2
+ I2=FE_OFN291_FE_DBTN105_IxIt_shift_5
XU341 NR2 $PINS O=n154 I1=FE_OFN1470_FE_DBTN103_IxIt_shift_3
+ I2=FE_OFN280_FE_DBTN131_Iy2_shift_4
XU342 NR2 $PINS O=n153 I1=FE_OFN1201_n1438 I2=FE_OFN1251_n4487
XU343 FA1S $PINS S=intadd_52/A[1] CO=intadd_43/B[1] A=n155 B=n154 CI=n153
XU344 NR2 $PINS O=intadd_52/B[0] I1=FE_OFN1451_FE_DBTN129_Iy2_shift_2
+ I2=FE_OFN1251_n4487
XU345 NR2 $PINS O=intadd_52/CI I1=FE_OFN1470_FE_DBTN103_IxIt_shift_3
+ I2=FE_OFN1207_n1438
XU346 NR2 $PINS O=intadd_53/A[0] I1=FE_OFN1470_FE_DBTN103_IxIt_shift_3
+ I2=FE_OFN1450_FE_DBTN129_Iy2_shift_2
XU347 NR2 $PINS O=intadd_53/B[0] I1=FE_OFN884_FE_DBTN128_Iy2_shift_0
+ I2=FE_DBTN105_IxIt_shift_5
XU348 NR2 $PINS O=intadd_53/CI I1=FE_OFN1198_n1437 I2=FE_OFN1207_n1438
XU349 OAI22S $PINS O=n163 A1=n157 A2=intadd_52/A[0] B1=n156 B2=intadd_52/A[0]
XU350 NR2 $PINS O=n162 I1=FE_OFN995_n143 I2=FE_OFN1249_n4487
XU351 ND2 $PINS O=n167 I1=FE_OFN4132_IxIt_shift_1 I2=FE_OFN1490_FE_DBTN38_n1438
XU353 NR2 $PINS O=n161 I1=n167 I2=n166
XU354 FA1S $PINS S=intadd_41/A[4] CO=intadd_41/B[5] A=intadd_53/SUM[1] B=n160
+ CI=intadd_52/SUM[0]
XU355 FA1S $PINS S=n165 CO=n160 A=n163 B=n162 CI=n161
XU356 NR2 $PINS O=n181 I1=FE_OFN995_n143 I2=FE_DBTN103_IxIt_shift_3
XU357 NR2 $PINS O=n180 I1=FE_OFN884_FE_DBTN128_Iy2_shift_0 I2=FE_OFN1249_n4487
XU358 NR2 $PINS O=n179 I1=FE_OFN1198_n1437 I2=FE_OFN1450_FE_DBTN129_Iy2_shift_2
XU359 FA1S $PINS S=intadd_41/A[3] CO=intadd_41/B[4] A=n165 B=n164
+ CI=intadd_53/SUM[0]
XU360 MOAI1S $PINS O=n175 A1=n167 A2=n166 B1=n167 B2=n166
XU361 NR2 $PINS O=n178 I1=n94 I2=FE_OFN1450_FE_DBTN129_Iy2_shift_2
XU362 NR2 $PINS O=n170 I1=n169 I2=n168
XU363 NR2 $PINS O=n173 I1=n171 I2=n170
XU364 INV1S $PINS O=intadd_41/B[3] I=n172
XU365 FA1S $PINS S=n176 CO=n172 A=n175 B=n174 CI=n173
XU366 INV1S $PINS O=intadd_41/A[2] I=n176
XU367 NR2 $PINS O=intadd_41/B[0] I1=FE_OFN1450_FE_DBTN129_Iy2_shift_2 I2=n115
XU368 MOAI1S $PINS O=intadd_41/B[1] A1=n178 A2=n177 B1=n178 B2=n177
XU369 FA1S $PINS S=intadd_41/B[2] CO=n164 A=n181 B=n180 CI=n179
XU370 NR2 $PINS O=n241 I1=FE_OFN1093_Iy2_shift_15
+ I2=FE_OFN290_FE_DBTN105_IxIt_shift_5
XU371 INV1S $PINS O=intadd_54/A[2] I=n182
XU372 NR2 $PINS O=intadd_54/A[0] I1=FE_OFN4284_n I2=FE_OFN231_IxIt_shift_7
XU374 NR2 $PINS O=intadd_54/B[0]
+ I1=FE_OFN4167_FE_OFN1011_FE_DBTN138_Iy2_shift_13
+ I2=FE_OFN290_FE_DBTN105_IxIt_shift_5
XU376 NR2 $PINS O=intadd_54/CI I1=FE_OFN1095_Iy2_shift_14 I2=n4487
XU377 INV1S $PINS O=n404 I=FE_OFN1215_n1667
XU378 NR2 $PINS O=n185 I1=n404 I2=IxIt_shift_7
XU379 NR2 $PINS O=n184 I1=FE_OFN4167_FE_OFN1011_FE_DBTN138_Iy2_shift_13
+ I2=FE_OFN286_FE_DBTN107_IxIt_shift_6
XU380 NR2 $PINS O=n183 I1=FE_OFN1095_Iy2_shift_14
+ I2=FE_OFN290_FE_DBTN105_IxIt_shift_5
XU381 FA1S $PINS S=intadd_54/B[1] CO=intadd_54/B[2] A=n185 B=n184 CI=n183
XU382 NR2 $PINS O=n188 I1=FE_OFN1093_Iy2_shift_15 I2=FE_OFN240_FE_DBTN39_n1437
XU383 INV1S $PINS O=intadd_45/A[2] I=n186
XU384 NR2 $PINS O=intadd_45/A[0]
+ I1=FE_OFN4167_FE_OFN1011_FE_DBTN138_Iy2_shift_13
+ I2=FE_OFN1469_FE_DBTN103_IxIt_shift_3
XU385 NR2 $PINS O=intadd_45/B[0] I1=FE_OFN1436_FE_DBTN137_Iy2_shift_11
+ I2=FE_OFN290_FE_DBTN105_IxIt_shift_5
XU386 NR2 $PINS O=intadd_45/CI I1=FE_OFN1510_n231
+ I2=FE_OFN287_FE_DBTN107_IxIt_shift_6
XU387 FA1S $PINS S=n190 CO=n186 A=n189 B=n188 CI=n187
XU388 INV1S $PINS O=intadd_46/A[2] I=n190
XU389 NR2 $PINS O=n202 I1=FE_OFN1093_Iy2_shift_15 I2=n94
XU390 AOI22S $PINS O=n201 A1=FE_OFN4335_Iy2_shift_8
+ A2=FE_OFN1500_FE_DBTN28_IxIt_shift_7 B1=FE_OFN964_Iy2_shift_13
+ B2=FE_OFN1597_n1437
XU391 INV1S $PINS O=intadd_46/B[2] I=n191
XU392 NR2 $PINS O=intadd_46/A[0] I1=FE_OFN4292_FE_DBTN136_Iy2_shift_9
+ I2=FE_OFN287_FE_DBTN107_IxIt_shift_6
XU393 NR2 $PINS O=intadd_46/B[0] I1=FE_OFN1510_n231 I2=FE_DBTN105_IxIt_shift_5
XU394 NR2 $PINS O=intadd_46/CI I1=FE_OFN1095_Iy2_shift_14 I2=n94
XU395 NR2 $PINS O=n206 I1=FE_OFN1093_Iy2_shift_15 I2=n115
XU396 INV1S $PINS O=intadd_46/B[1] I=n192
XU397 NR2 $PINS O=n196 I1=FE_OFN1510_n231 I2=FE_OFN231_IxIt_shift_7
XU398 NR2 $PINS O=n195 I1=FE_OFN4167_FE_OFN1011_FE_DBTN138_Iy2_shift_13
+ I2=FE_OFN186_n4487
XU399 NR2 $PINS O=n194 I1=FE_OFN1095_Iy2_shift_14
+ I2=FE_OFN1469_FE_DBTN103_IxIt_shift_3
XU400 NR2 $PINS O=n199 I1=n404 I2=FE_OFN286_FE_DBTN107_IxIt_shift_6
XU401 FA1S $PINS S=intadd_45/B[1] CO=n197 A=n196 B=n195 CI=n194
XU402 FA1S $PINS S=intadd_46/B[3] CO=intadd_45/B[3] A=n199 B=n198 CI=n197
XU403 NR2 $PINS O=n200 I1=FE_OFN4167_FE_OFN1011_FE_DBTN138_Iy2_shift_13
+ I2=FE_OFN177_n1437
XU404 AO13S $PINS O=intadd_47/B[1] A1=n201 B1=B[7] B2=FE_OFN4335_Iy2_shift_8
+ B3=n200
XU405 NR2 $PINS O=intadd_47/A[0] I1=FE_OFN4360_n
+ I2=FE_OFN287_FE_DBTN107_IxIt_shift_6
XU406 NR2 $PINS O=intadd_47/B[0] I1=FE_OFN4292_FE_DBTN136_Iy2_shift_9
+ I2=FE_DBTN105_IxIt_shift_5
XU407 NR2 $PINS O=intadd_47/CI I1=n404 I2=FE_OFN240_FE_DBTN39_n1437
XU408 FA1S $PINS S=n204 CO=n191 A=n203 B=n202 CI=n201
XU409 INV1S $PINS O=intadd_47/A[2] I=n204
XU410 NR2 $PINS O=intadd_55/A[0] I1=FE_OFN1300_Iy2_shift_10 I2=FE_OFN1249_n4487
XU411 NR2 $PINS O=intadd_55/CI I1=FE_OFN1436_FE_DBTN137_Iy2_shift_11
+ I2=FE_OFN1469_FE_DBTN103_IxIt_shift_3
XU412 FA1S $PINS S=n208 CO=n192 A=n207 B=n206 CI=n205
XU413 INV1S $PINS O=intadd_55/A[1] I=n208
XU414 NR2 $PINS O=intadd_56/A[0] I1=FE_OFN4360_n I2=FE_DBTN105_IxIt_shift_5
XU415 NR2 $PINS O=intadd_56/B[0] I1=FE_OFN1300_Iy2_shift_10
+ I2=FE_OFN1469_FE_DBTN103_IxIt_shift_3
XU416 NR2 $PINS O=intadd_56/CI I1=FE_OFN1436_FE_DBTN137_Iy2_shift_11
+ I2=FE_OFN177_n1437
XU417 OAI22S $PINS O=n220 A1=n211 A2=intadd_55/B[0] B1=n210 B2=intadd_55/B[0]
XU419 NR2 $PINS O=n219 I1=n224 I2=n223
XU420 NR2 $PINS O=n218 I1=FE_OFN4292_FE_DBTN136_Iy2_shift_9 I2=FE_OFN1249_n4487
XU421 FA1S $PINS S=intadd_39/A[4] CO=intadd_39/B[5] A=n213 B=intadd_56/SUM[1]
+ CI=intadd_55/SUM[0]
XU422 NR2 $PINS O=n238 I1=FE_OFN4360_n I2=FE_OFN1249_n4487
XU423 NR2 $PINS O=n237 I1=FE_OFN4292_FE_DBTN136_Iy2_shift_9
+ I2=FE_OFN1469_FE_DBTN103_IxIt_shift_3
XU424 NR2 $PINS O=n236 I1=FE_OFN1300_Iy2_shift_10 I2=FE_OFN177_n1437
XU425 FA1S $PINS S=n221 CO=n213 A=n220 B=n219 CI=n218
XU426 FA1S $PINS S=intadd_39/A[3] CO=intadd_39/B[4] A=n222 B=n221
+ CI=intadd_56/SUM[0]
XU427 MOAI1S $PINS O=n234 A1=n224 A2=n223 B1=n224 B2=n223
XU428 INV1S $PINS O=n226 I=n225
XU429 AOI13HS $PINS O=n233 A1=n226 B1=FE_OFN234_IxIt_shift_3
+ B2=FE_OFN1309_Iy2_shift_8 B3=n227
XU430 INV1S $PINS O=intadd_39/B[3] I=n230
XU431 NR2 $PINS O=intadd_39/CI I1=FE_OFN1300_Iy2_shift_10 I2=n115
XU432 FA1S $PINS S=n235 CO=n230 A=n234 B=n233 CI=n232
XU433 INV1S $PINS O=intadd_39/A[2] I=n235
XU434 FA1S $PINS S=intadd_39/B[2] CO=n222 A=n238 B=n237 CI=n236
XU435 FA1S $PINS S=n182 CO=n246 A=n241 B=n240 CI=n239
XU436 NR2 $PINS O=n244 I1=FE_OFN1093_Iy2_shift_15
+ I2=FE_OFN286_FE_DBTN107_IxIt_shift_6
XU437 INV1S $PINS O=intadd_39/B[11] I=n243
XU438 FA1S $PINS S=n243 CO=n247 A=n246 B=n245 CI=n244
XU439 INV1S $PINS O=intadd_39/B[12] I=n247
XU440 NR2 $PINS O=N18 I1=FE_OFN4360_n I2=n115
XU441 INV1S $PINS O=N33 I=intadd_39/n1
XU443 NR2 $PINS O=n306 I1=FE_OFN1142_n318 I2=A[5]
XU444 INV1S $PINS O=intadd_57/A[2] I=n249
XU445 NR2 $PINS O=intadd_57/A[0] I1=FE_OFN1728_IxIt_shift_11 I2=n307
XU446 NR2 $PINS O=intadd_57/B[0] I1=n262 I2=FE_OFN1244_n4486
XU447 NR2 $PINS O=intadd_57/CI I1=FE_OFN1019_FE_DBTN115_IxIt_shift_14
+ I2=FE_DBTN131_Iy2_shift_4
XU449 NR2 $PINS O=n252 I1=FE_OFN225_IxIt_shift_12 I2=n307
XU450 NR2 $PINS O=n251 I1=n262 I2=FE_DBTN132_Iy2_shift_6
XU451 NR2 $PINS O=n250 I1=FE_OFN1019_FE_DBTN115_IxIt_shift_14 I2=A[5]
XU452 FA1S $PINS S=intadd_57/B[1] CO=intadd_57/B[2] A=n252 B=n251 CI=n250
XU453 NR2 $PINS O=n255 I1=FE_OFN1142_n318 I2=FE_DBTN129_Iy2_shift_2
XU454 INV1S $PINS O=intadd_48/A[2] I=n253
XU455 NR2 $PINS O=intadd_48/A[0] I1=n262 I2=FE_OFN1207_n1438
XU456 NR2 $PINS O=intadd_48/B[0] I1=FE_OFN1728_IxIt_shift_11
+ I2=FE_OFN1244_n4486
XU457 NR2 $PINS O=intadd_48/CI I1=FE_OFN1460_FE_DBTN112_IxIt_shift_10
+ I2=FE_DBTN132_Iy2_shift_6
XU458 FA1S $PINS S=n257 CO=n253 A=n256 B=n255 CI=n254
XU459 INV1S $PINS O=intadd_49/A[2] I=n257
XU460 NR2 $PINS O=n271 I1=FE_OFN1142_n318 I2=FE_OFN995_n143
XU461 AOI22S $PINS O=n270 A1=FE_OFN1362_IxIt_shift_8 A2=A[7]
+ B1=FE_OFN987_IxIt_shift_13 B2=FE_OFN1449_FE_DBTN129_Iy2_shift_2
XU462 INV1S $PINS O=intadd_49/B[2] I=n258
XU463 NR2 $PINS O=intadd_49/A[0] I1=FE_DBTN111_IxIt_shift_9
+ I2=FE_DBTN132_Iy2_shift_6
XU464 NR2 $PINS O=intadd_49/B[0] I1=FE_OFN1460_FE_DBTN112_IxIt_shift_10
+ I2=FE_OFN1244_n4486
XU465 NR2 $PINS O=intadd_49/CI I1=FE_OFN1019_FE_DBTN115_IxIt_shift_14
+ I2=FE_OFN995_n143
XU466 NR2 $PINS O=n275 I1=FE_OFN1142_n318 I2=FE_DBTN128_Iy2_shift_0
XU467 INV1S $PINS O=intadd_49/B[1] I=n260
XU468 NR2 $PINS O=n265 I1=FE_OFN1460_FE_DBTN112_IxIt_shift_10 I2=n307
XU469 NR2 $PINS O=n264 I1=n262 I2=FE_DBTN131_Iy2_shift_4
XU470 NR2 $PINS O=n263 I1=FE_OFN1019_FE_DBTN115_IxIt_shift_14
+ I2=FE_OFN1207_n1438
XU471 NR2 $PINS O=n268 I1=FE_OFN1513_n433 I2=FE_DBTN132_Iy2_shift_6
XU472 FA1S $PINS S=intadd_48/B[1] CO=n266 A=n265 B=n264 CI=n263
XU473 FA1S $PINS S=intadd_49/B[3] CO=intadd_48/B[3] A=n268 B=n267 CI=n266
XU474 NR2 $PINS O=n269 I1=n262 I2=FE_DBTN129_Iy2_shift_2
XU475 AO13S $PINS O=intadd_50/B[1] A1=n270 B1=FE_OFN1208_n1622
+ B2=FE_OFN1362_IxIt_shift_8 B3=n269
XU476 NR2 $PINS O=intadd_50/A[0] I1=FE_DBTN109_IxIt_shift_8
+ I2=FE_OFN1446_FE_DBTN132_Iy2_shift_6
XU477 NR2 $PINS O=intadd_50/B[0] I1=FE_DBTN111_IxIt_shift_9 I2=FE_OFN1244_n4486
XU478 NR2 $PINS O=intadd_50/CI I1=FE_OFN225_IxIt_shift_12
+ I2=FE_OFN1451_FE_DBTN129_Iy2_shift_2
XU479 FA1S $PINS S=n273 CO=n258 A=n272 B=n271 CI=n270
XU480 INV1S $PINS O=intadd_50/A[2] I=n273
XU481 NR2 $PINS O=intadd_58/A[0] I1=FE_OFN1460_FE_DBTN112_IxIt_shift_10
+ I2=FE_DBTN131_Iy2_shift_4
XU482 NR2 $PINS O=intadd_58/CI I1=FE_OFN1728_IxIt_shift_11 I2=FE_OFN1201_n1438
XU483 FA1S $PINS S=n277 CO=n260 A=n276 B=n275 CI=n274
XU484 INV1S $PINS O=intadd_58/A[1] I=n277
XU485 NR2 $PINS O=intadd_59/A[0] I1=FE_DBTN109_IxIt_shift_8 I2=FE_OFN1244_n4486
XU486 NR2 $PINS O=intadd_59/B[0] I1=FE_DBTN112_IxIt_shift_10
+ I2=FE_OFN1201_n1438
XU487 NR2 $PINS O=intadd_59/CI I1=FE_OFN1728_IxIt_shift_11
+ I2=FE_OFN1451_FE_DBTN129_Iy2_shift_2
XU488 OAI22S $PINS O=n286 A1=n280 A2=intadd_58/B[0] B1=n279 B2=intadd_58/B[0]
XU490 NR2 $PINS O=n285 I1=n290 I2=n289
XU491 NR2 $PINS O=n284 I1=FE_DBTN111_IxIt_shift_9 I2=FE_DBTN131_Iy2_shift_4
XU492 FA1S $PINS S=intadd_38/A[4] CO=intadd_38/B[5] A=n281 B=intadd_59/SUM[1]
+ CI=intadd_58/SUM[0]
XU493 NR2 $PINS O=n303 I1=FE_DBTN109_IxIt_shift_8 I2=FE_DBTN131_Iy2_shift_4
XU494 NR2 $PINS O=n302 I1=FE_DBTN111_IxIt_shift_9 I2=FE_OFN1201_n1438
XU495 NR2 $PINS O=n301 I1=FE_DBTN112_IxIt_shift_10 I2=FE_OFN1605_Iy2_shift_2
XU496 FA1S $PINS S=n287 CO=n281 A=n286 B=n285 CI=n284
XU497 FA1S $PINS S=intadd_38/A[3] CO=intadd_38/B[4] A=n288 B=n287
+ CI=intadd_59/SUM[0]
XU498 MOAI1S $PINS O=n299 A1=n290 A2=n289 B1=n290 B2=n289
XU499 INV1S $PINS O=n292 I=n291
XU500 AOI13HS $PINS O=n298 A1=n292 B1=FE_OFN1362_IxIt_shift_8 B2=n293
+ B3=FE_OFN1203_n1438
XU501 INV1S $PINS O=intadd_38/B[3] I=n296
XU502 NR2 $PINS O=intadd_38/CI I1=FE_DBTN112_IxIt_shift_10
+ I2=FE_DBTN128_Iy2_shift_0
XU503 FA1S $PINS S=n300 CO=n296 A=n299 B=n298 CI=n297
XU504 INV1S $PINS O=intadd_38/A[2] I=n300
XU505 FA1S $PINS S=intadd_38/B[2] CO=n288 A=n303 B=n302 CI=n301
XU506 FA1S $PINS S=n249 CO=n312 A=n306 B=n305 CI=n304
XU507 NR2 $PINS O=n310 I1=FE_RN_7 I2=FE_DBTN132_Iy2_shift_6
XU508 INV1S $PINS O=intadd_38/B[11] I=n309
XU509 FA1S $PINS S=n309 CO=n313 A=n312 B=n311 CI=n310
XU510 INV1S $PINS O=intadd_38/B[12] I=n313
XU511 NR2 $PINS O=N35 I1=FE_DBTN109_IxIt_shift_8
+ I2=FE_OFN884_FE_DBTN128_Iy2_shift_0
XU512 INV1S $PINS O=N50 I=intadd_38/n1
XU514 OA222 $PINS O=n457 A1=FE_OFN962_Iy2_shift_13
+ A2=FE_OFN1194_FE_DBTN12_Iy2_shift_15
+ B1=FE_OFN4170_FE_OFN1011_FE_DBTN138_Iy2_shift_13
+ B2=FE_OFN1182_FE_DBTN27_Iy2_shift_14 C1=FE_OFN4256_FE_OFN1092_Iy2_shift_15
+ C2=FE_OFN1095_Iy2_shift_14
XU515 AOI22S $PINS O=n321 A1=FE_OFN1018_FE_DBTN115_IxIt_shift_14
+ A2=FE_OFN4256_FE_OFN1092_Iy2_shift_15 B1=B[14]
+ B2=FE_OFN1194_FE_DBTN12_Iy2_shift_15
XU517 MOAI1S $PINS O=n456 A1=FE_OFN150_IxIt_shift_15 A2=A[15]
+ B1=FE_OFN150_IxIt_shift_15 B2=A[15]
XU518 AOI22S $PINS O=intadd_40/A[10] A1=FE_OFN1514_n457 A2=n321
+ B1=FE_OFN1515_n458 B2=n456
XU519 INV1S $PINS O=intadd_40/A[11] I=intadd_40/A[10]
XU522 MOAI1S $PINS O=n322 A1=FE_RN_7 A2=FE_OFN962_Iy2_shift_13 B1=FE_RN_7
+ B2=FE_OFN962_Iy2_shift_13
XU523 OA222 $PINS O=n424 A1=FE_OFN1296_Iy2_shift_11 A2=FE_OFN964_Iy2_shift_13
+ B1=FE_OFN4284_n B2=A[12] C1=FE_OFN4167_FE_OFN1011_FE_DBTN138_Iy2_shift_13
+ C2=n404
XU524 MOAI1S $PINS O=n330 A1=FE_OFN962_Iy2_shift_13
+ A2=FE_OFN1018_FE_DBTN115_IxIt_shift_14 B1=FE_OFN962_Iy2_shift_13
+ B2=FE_OFN1018_FE_DBTN115_IxIt_shift_14
XU525 AOI22S $PINS O=n327 A1=FE_OFN1745_n431 A2=n322 B1=FE_OFN1534_n424 B2=n330
XU527 MOAI1S $PINS O=n328 A1=B[13] A2=FE_OFN1092_Iy2_shift_15 B1=B[13]
+ B2=FE_OFN1092_Iy2_shift_15
XU528 AOI22S $PINS O=n325 A1=FE_OFN1515_n458 A2=n321 B1=FE_OFN1514_n457 B2=n328
XU529 OA12 $PINS O=n324 A1=n322 B1=FE_OFN1745_n431 B2=FE_OFN1534_n424
XU530 INV1S $PINS O=intadd_40/B[10] I=n323
XU531 FA1S $PINS S=n326 CO=n323 A=n327 B=n325 CI=n324
XU532 INV1S $PINS O=intadd_40/A[9] I=n326
XU533 INV1S $PINS O=n454 I=n327
XU534 MOAI1S $PINS O=n331 A1=B[12] A2=FE_OFN4256_FE_OFN1092_Iy2_shift_15
+ B1=B[12] B2=FE_OFN1092_Iy2_shift_15
XU535 AOI22S $PINS O=n453 A1=FE_OFN1515_n458 A2=n328 B1=FE_OFN1514_n457 B2=n331
XU536 MOAI1S $PINS O=n337 A1=FE_OFN1293_Iy2_shift_11 A2=FE_OFN149_IxIt_shift_15
+ B1=FE_OFN1293_Iy2_shift_11 B2=FE_OFN149_IxIt_shift_15
XU537 MOAI1S $PINS O=n347 A1=FE_OFN4285_n
+ A2=FE_OFN1018_FE_DBTN115_IxIt_shift_14 B1=FE_OFN4285_n
+ B2=FE_OFN1018_FE_DBTN115_IxIt_shift_14
XU538 INV1S $PINS O=n329 I=n347
XU539 MOAI1S $PINS O=n360 A1=FE_OFN1481_FE_DBTN90_n348 A2=n337 B1=n444 B2=n329
XU540 INV1S $PINS O=n335 I=n360
XU541 MOAI1S $PINS O=n338 A1=B[13]
+ A2=FE_OFN4170_FE_OFN1011_FE_DBTN138_Iy2_shift_13 B1=B[13]
+ B2=FE_OFN4170_FE_OFN1011_FE_DBTN138_Iy2_shift_13
XU542 AOI22S $PINS O=n334 A1=FE_OFN1745_n431 A2=n330 B1=FE_OFN1534_n424 B2=n338
XU544 AOI22S $PINS O=n333 A1=FE_OFN1515_n458 A2=n331 B1=FE_OFN1514_n457 B2=n340
XU545 INV1S $PINS O=intadd_40/B[9] I=n332
XU546 FA1S $PINS S=n344 CO=n452 A=n335 B=n334 CI=n333
XU547 OAI22S $PINS O=n343 A1=FE_OFN1481_FE_DBTN90_n348 A2=n337 B1=n336 B2=n337
XU548 MOAI1S $PINS O=n351 A1=B[12]
+ A2=FE_OFN4170_FE_OFN1011_FE_DBTN138_Iy2_shift_13 B1=B[12]
+ B2=FE_OFN4170_FE_OFN1011_FE_DBTN138_Iy2_shift_13
XU549 AOI22S $PINS O=n359 A1=FE_OFN1745_n431 A2=n338 B1=FE_OFN1534_n424 B2=n351
XU550 AOI22S $PINS O=n350 A1=FE_OFN1460_FE_DBTN112_IxIt_shift_10
+ A2=FE_OFN1093_Iy2_shift_15 B1=B[10] B2=FE_OFN1195_FE_DBTN12_Iy2_shift_15
XU551 AOI22S $PINS O=n358 A1=n458 A2=n340 B1=n457 B2=n350
XU552 INV1S $PINS O=intadd_40/A[8] I=n341
XU553 FA1S $PINS S=n345 CO=n341 A=n344 B=n343 CI=n342
XU554 INV1S $PINS O=intadd_40/A[7] I=n345
XU555 MOAI1S $PINS O=n369 A1=FE_OFN152_IxIt_shift_13 A2=FE_OFN4285_n
+ B1=FE_OFN152_IxIt_shift_13 B2=FE_OFN4285_n
XU556 MOAI1S $PINS O=n367 A1=FE_OFN1481_FE_DBTN90_n348 A2=n347 B1=n444 B2=n369
XU557 MOAI1S $PINS O=n372 A1=FE_OFN1195_FE_DBTN12_Iy2_shift_15
+ A2=FE_OFN1461_FE_DBTN111_IxIt_shift_9 B1=FE_OFN1195_FE_DBTN12_Iy2_shift_15
+ B2=FE_OFN1461_FE_DBTN111_IxIt_shift_9
XU558 AO22 $PINS O=n365 A1=n458 A2=n350 B1=n457 B2=n372
XU559 NR2 $PINS O=n366 I1=n367 I2=n365
XU560 MOAI1S $PINS O=n374 A1=FE_OFN1727_IxIt_shift_11
+ A2=FE_OFN1011_FE_DBTN138_Iy2_shift_13 B1=FE_OFN1727_IxIt_shift_11
+ B2=FE_OFN1011_FE_DBTN138_Iy2_shift_13
XU561 AOI22S $PINS O=n377 A1=FE_OFN1535_n431 A2=n351 B1=FE_OFN1534_n424 B2=n374
XU562 MOAI1S $PINS O=n357 A1=FE_OFN1306_Iy2_shift_9 A2=FE_OFN150_IxIt_shift_15
+ B1=FE_OFN1306_Iy2_shift_9 B2=FE_OFN150_IxIt_shift_15
XU563 NR2 $PINS O=n354 I1=A[8] I2=FE_OFN2741_Iy2_shift_9
XU564 NR2 $PINS O=n376 I1=n357 I2=n354
XU565 MXL2HS $PINS OB=n356 S=n458 A=FE_OFN1095_Iy2_shift_14
+ B=FE_OFN1466_FE_DBTN109_IxIt_shift_8
XU566 NR2 $PINS O=n384 I1=FE_OFN4256_FE_OFN1092_Iy2_shift_15 I2=n356
XU567 MOAI1S $PINS O=n383 A1=FE_OFN1512_n410 A2=n357 B1=n436
+ B2=FE_OFN1018_FE_DBTN115_IxIt_shift_14
XU568 FA1S $PINS S=n362 CO=n342 A=n360 B=n359 CI=n358
XU569 INV1S $PINS O=intadd_40/B[7] I=n361
XU570 FA1S $PINS S=n364 CO=n361 A=n366 B=n363 CI=n362
XU571 INV1S $PINS O=intadd_40/A[6] I=n364
XU572 OAI22S $PINS O=n381 A1=n367 A2=n366 B1=n365 B2=n366
XU573 MOAI1S $PINS O=n390 A1=FE_OFN4221_FE_OFN1293_Iy2_shift_11
+ A2=FE_OFN1513_n433 B1=FE_OFN4221_FE_OFN1293_Iy2_shift_11 B2=FE_OFN1513_n433
XU574 AOI22S $PINS O=n393 A1=FE_OFN1657_n348 A2=n369 B1=FE_OFN1536_n444 B2=n390
XU576 AOI22S $PINS O=n392 A1=n458 A2=n372 B1=n457 B2=n371
XU577 MOAI1S $PINS O=n399 A1=B[10] A2=FE_OFN1011_FE_DBTN138_Iy2_shift_13
+ B1=B[10] B2=FE_OFN1011_FE_DBTN138_Iy2_shift_13
XU578 AOI22S $PINS O=n391 A1=FE_OFN1535_n431 A2=n374 B1=FE_OFN1534_n424 B2=n399
XU579 FA1S $PINS S=n379 CO=n363 A=n377 B=n376 CI=n375
XU580 INV1S $PINS O=intadd_40/B[6] I=n378
XU581 FA1S $PINS S=n382 CO=n378 A=n381 B=n380 CI=n379
XU582 INV1S $PINS O=intadd_40/A[5] I=n382
XU583 MOAI1S $PINS O=n397 A1=n384 A2=n383 B1=n384 B2=n383
XU584 MOAI1S $PINS O=n387 A1=FE_OFN4371_n
+ A2=FE_OFN1019_FE_DBTN115_IxIt_shift_14 B1=FE_OFN4371_n
+ B2=FE_OFN1019_FE_DBTN115_IxIt_shift_14
XU585 AOI22S $PINS O=n401 A1=FE_OFN4336_Iy2_shift_8 A2=n387 B1=n436 B2=n262
XU586 MOAI1S $PINS O=n420 A1=FE_OFN226_IxIt_shift_11 A2=FE_OFN4284_n
+ B1=FE_OFN226_IxIt_shift_11 B2=FE_OFN4284_n
XU587 AOI22S $PINS O=n400 A1=FE_OFN1657_n348 A2=n390 B1=FE_OFN1536_n444 B2=n420
XU588 FA1S $PINS S=n395 CO=n380 A=n393 B=n392 CI=n391
XU589 INV1S $PINS O=intadd_40/B[5] I=n394
XU590 FA1S $PINS S=n398 CO=n394 A=n397 B=n396 CI=n395
XU591 INV1S $PINS O=intadd_40/A[4] I=n398
XU592 MOAI1S $PINS O=n425 A1=B[9] A2=FE_OFN1012_FE_DBTN138_Iy2_shift_13 B1=B[9]
+ B2=FE_OFN1012_FE_DBTN138_Iy2_shift_13
XU593 AOI22S $PINS O=n414 A1=FE_OFN1535_n431 A2=n399 B1=n424 B2=n425
XU594 FA1S $PINS S=n413 CO=n396 A=n402 B=n401 CI=n400
XU596 MXL2HS $PINS OB=n405 S=n431 A=n404 B=FE_OFN1466_FE_DBTN109_IxIt_shift_8
XU597 NR2 $PINS O=n417 I1=FE_OFN1012_FE_DBTN138_Iy2_shift_13 I2=n405
XU598 MOAI1S $PINS O=n409 A1=FE_OFN4371_n A2=FE_OFN152_IxIt_shift_13
+ B1=FE_OFN4371_n B2=FE_OFN152_IxIt_shift_13
XU599 MOAI1S $PINS O=n416 A1=FE_OFN1512_n410 A2=n409 B1=n436 B2=FE_OFN1513_n433
XU600 INV1S $PINS O=intadd_40/B[4] I=n411
XU601 FA1S $PINS S=n415 CO=n411 A=n414 B=n413 CI=n412
XU602 INV1S $PINS O=intadd_40/A[3] I=n415
XU603 MOAI1S $PINS O=n429 A1=n417 A2=n416 B1=n417 B2=n416
XU604 MOAI1S $PINS O=n440 A1=B[10] A2=FE_OFN4286_n B1=B[10] B2=FE_OFN4286_n
XU605 AOI22S $PINS O=n428 A1=FE_OFN1657_n348 A2=n420 B1=FE_OFN1536_n444 B2=n440
XU606 MOAI1S $PINS O=n423 A1=FE_OFN4261_FE_OFN1361_IxIt_shift_8
+ A2=FE_OFN1012_FE_DBTN138_Iy2_shift_13 B1=FE_OFN228_IxIt_shift_8
+ B2=FE_OFN1012_FE_DBTN138_Iy2_shift_13
XU607 AOI22S $PINS O=n427 A1=FE_OFN1535_n431 A2=n425 B1=n424 B2=n423
XU608 INV1S $PINS O=intadd_40/B[3] I=n426
XU609 FA1S $PINS S=n430 CO=n426 A=n429 B=n428 CI=n427
XU610 INV1S $PINS O=intadd_40/A[2] I=n430
XU611 MOAI1S $PINS O=n437 A1=FE_OFN1308_Iy2_shift_9 A2=FE_OFN225_IxIt_shift_12
+ B1=FE_OFN1308_Iy2_shift_9 B2=FE_OFN1513_n433
XU612 AOI22S $PINS O=n449 A1=FE_OFN4336_Iy2_shift_8 A2=n437 B1=n436
+ B2=FE_OFN1728_IxIt_shift_11
XU613 AOI22S $PINS O=n448 A1=FE_OFN1657_n348 A2=n440 B1=FE_OFN1536_n444 B2=n439
XU614 INV1S $PINS O=intadd_40/B[2] I=n441
XU615 MOAI1S $PINS O=intadd_40/CI A1=n447 A2=FE_OFN4261_FE_OFN1361_IxIt_shift_8
+ B1=FE_OFN4222_FE_OFN1293_Iy2_shift_11 B2=FE_OFN1536_n444
XU616 FA1S $PINS S=n451 CO=n441 A=n450 B=n449 CI=n448
XU617 INV1S $PINS O=intadd_40/B[1] I=n451
XU618 FA1S $PINS S=n455 CO=n332 A=n454 B=n453 CI=n452
XU619 INV1S $PINS O=intadd_40/B[8] I=n455
XU620 OAI12HS $PINS O=intadd_40/B[11] A1=n456 B1=FE_OFN1515_n458
+ B2=FE_OFN1514_n457
XU621 INV1S $PINS O=N67 I=intadd_40/n1
XU622 INV1S $PINS O=intadd_37/B[21] I=s1_P3[13]
XU623 INV1S $PINS O=intadd_37/B[20] I=s1_P3[12]
XU624 INV1S $PINS O=intadd_37/B[19] I=s1_P3[11]
XU625 INV1S $PINS O=intadd_37/B[18] I=s1_P3[10]
XU626 INV1S $PINS O=intadd_37/A[17] I=s1_P3[9]
XU627 NR2 $PINS O=n459 I1=s1_P0[9] I2=s1_P2[1]
XU628 NR2 $PINS O=intadd_37/B[1] I1=intadd_37/A[2] I2=n459
XU629 FA1S $PINS S=n480 CO=n481 A=N37 B=N20 CI=N11
XU630 FA1S $PINS S=n482 CO=n483 A=N38 B=N21 CI=N12
XU631 FA1S $PINS S=n484 CO=n485 A=N39 B=N22 CI=N13
XU632 FA1S $PINS S=n486 CO=n487 A=N40 B=N23 CI=N14
XU633 NR2 $PINS O=n462 I1=n460 I2=intadd_41/n1
XU634 NR2 $PINS O=n463 I1=n462 I2=n461
XU635 FA1 $PINS S=n490 CO=n491 A=N42 B=N25 CI=n463
XU636 NR2 $PINS O=n466 I1=FE_OFN4360_n I2=FE_DBTN109_IxIt_shift_8
XU637 FA1S $PINS S=n492 CO=n493 A=n466 B=N26 CI=N43
XU638 NR2 $PINS O=n473 I1=n466 I2=FE_DBTN136_Iy2_shift_9
XU639 MOAI1S $PINS O=n470 A1=B[9] A2=FE_OFN4293_FE_DBTN136_Iy2_shift_9 B1=B[9]
+ B2=FE_OFN4293_FE_DBTN136_Iy2_shift_9
XU640 AN2 $PINS O=n472 I1=n470 I2=FE_OFN4335_Iy2_shift_8
XU641 OA12 $PINS O=n474 A1=n471 B1=n473 B2=n472
XU642 FA1S $PINS S=n494 CO=n495 A=n474 B=N27 CI=N44
XU643 OAI22S $PINS O=n477 A1=n476 A2=intadd_40/B[0] B1=n475 B2=intadd_40/B[0]
XU644 FA1S $PINS S=n496 CO=n497 A=n477 B=N28 CI=N45
XU645 FA1S $PINS S=n498 CO=n499 A=N55 B=N29 CI=N46
XU646 FA1S $PINS S=n500 CO=n501 A=N56 B=N30 CI=N47
XU647 FA1S $PINS S=n502 CO=n503 A=N57 B=N31 CI=N48
XU648 FA1 $PINS S=n504 CO=n505 A=N58 B=N32 CI=N49
XU649 FA1 $PINS S=N90 CO=intadd_37/n9 A=intadd_37/B[14] B=intadd_37/A[14]
+ CI=intadd_37/n10
XU650 FA1 $PINS S=N89 CO=intadd_37/n10 A=intadd_37/B[13] B=intadd_37/A[13]
+ CI=intadd_37/n11
XU651 FA1 $PINS S=N91 CO=intadd_37/n8 A=intadd_37/B[15] B=intadd_37/A[15]
+ CI=intadd_37/n9
XU652 FA1 $PINS S=N66 CO=intadd_40/n1 A=intadd_40/B[11] B=intadd_40/A[11]
+ CI=intadd_40/n2
Xs1_P3_reg[15] QDFFRBS $PINS Q=s1_P3[15] D=N67 CK=clk_clone1
+ RB=FE_OFN90_i_reset_n_i
Xs2_result_reg[25] QDFFRBS $PINS Q=result[25] D=N93 CK=clk_clone1
+ RB=FE_OFN64_i_reset_n_i
Xs2_result_reg[10] QDFFRBS $PINS Q=result[10] D=N78 CK=clk_clone1 RB=rst_n
XR_4 QDFFRBS $PINS Q=intadd_37/A[13] D=n501 CK=clk_clone1
+ RB=FE_OFN259_i_reset_n_i
XR_19 QDFFRBS $PINS Q=intadd_37/B[5] D=n486 CK=clk RB=FE_OFN233_i_reset_n_i
XU654 FA1S $PINS S=N64 CO=intadd_40/n3 A=intadd_40/B[9] B=intadd_40/A[9]
+ CI=intadd_40/n4
XU653 FA1S $PINS S=N65 CO=intadd_40/n2 A=intadd_40/B[10] B=intadd_40/A[10]
+ CI=intadd_40/n3
XU8 ND2S $PINS O=n224 I1=FE_OFN1296_Iy2_shift_11 I2=FE_OFN134_IxIt_shift_1
XU9 ND2S $PINS O=n289 I1=FE_OFN1348_IxIt_shift_12 I2=FE_OFN840_Iy2_shift_0
XU10 ND2S $PINS O=n85 I1=FE_OFN1309_Iy2_shift_8 I2=FE_OFN234_IxIt_shift_3
XU12 ND2S $PINS O=n166 I1=FE_OFN865_IxIt_shift_0 I2=A[4]
XU17 ND2S $PINS O=n157 I1=FE_OFN4131_IxIt_shift_1 I2=A[4]
XU20 ND2S $PINS O=n92 I1=FE_OFN1309_Iy2_shift_8 I2=FE_OFN1598_n1437
XU23 ND2S $PINS O=n108 I1=FE_OFN1359_IxIt_shift_9 I2=FE_OFN840_Iy2_shift_0
.ENDS

.SUBCKT mult_pipe_4 rst_n A[15] A[14] A[13] A[12] A[11] A[10] A[9] A[8] A[7]
+ A[6] A[5] A[4] A[3] A[2] A[1] A[0] B[15] B[14] B[13] B[12] B[11] B[10] B[9]
+ B[8] B[7] B[6] B[5] B[4] B[3] B[2] B[1] B[0] result[31] result[30] result[29]
+ result[28] result[27] result[26] result[25] result[24] result[23] result[22]
+ result[21] result[20] result[19] result[18] result[17] result[16] result[15]
+ result[14] result[13] result[12] result[11] result[10] result[9] result[8]
+ result[7] result[6] result[5] result[4] result[3] result[2] result[1]
+ result[0] IyIt_shift_7 Ix2_shift_12 Ix2_shift_15 IyIt_shift_15 Ix2_shift_3
+ Ix2_shift_14 n4484 Ix2_shift_4 n4488 FE_OFN113_i_reset_n_i
+ FE_OFN112_i_reset_n_i FE_OFN106_i_reset_n_i FE_OFN98_i_reset_n_i
+ FE_OFN91_i_reset_n_i FE_OFN84_i_reset_n_i FE_OFN71_i_reset_n_i
+ FE_OFN65_i_reset_n_i FE_OFN63_i_reset_n_i FE_OFN61_i_reset_n_i
+ FE_OFN60_i_reset_n_i FE_OFN49_i_reset_n_i FE_OFN46_i_reset_n_i
+ FE_OFN41_i_reset_n_i FE_OFN40_i_reset_n_i FE_OFN38_i_reset_n_i
+ FE_OFN37_i_reset_n_i FE_OFN28_i_reset_n_i FE_OFN26_i_reset_n_i
+ FE_OFN22_i_reset_n_i FE_OFN21_i_reset_n_i FE_OFN6_i_reset_n_i
+ FE_OFN139_IyIt_shift_1 FE_OFN138_IyIt_shift_1 FE_OFN141_IyIt_shift_0
+ FE_OFN140_IyIt_shift_0 FE_OFN154_IyIt_shift_14 FE_OFN160_Ix2_shift_15
+ FE_OFN166_IyIt_shift_15 FE_OFN168_IyIt_shift_13 FE_OFN167_IyIt_shift_13
+ FE_OFN170_IyIt_shift_12 FE_OFN169_IyIt_shift_12 FE_OFN171_IyIt_shift_9
+ FE_OFN172_IyIt_shift_7 FE_OFN185_n4484 FE_OFN184_n4484 FE_OFN188_n4488
+ FE_OFN187_n4488 FE_OFN194_Ix2_shift_9 FE_OFN201_Ix2_shift_7
+ FE_OFN236_IyIt_shift_11 FE_OFN235_IyIt_shift_11 FE_OFN238_IyIt_shift_8
+ FE_OFN237_IyIt_shift_8 FE_OFN239_IyIt_shift_3 FE_OFN242_FE_DBTN31_Ix2_shift_4
+ FE_OFN250_IyIt_shift_8 FE_OFN262_IyIt_shift_11 FE_OFN1263_Ix2_shift_9
+ FE_OFN267_FE_OFN1554_n3259 clk_clone3 clk_clone2 clk_clone1 clk
XFE_PHC3117_N76 DELB $PINS O=FE_PHN3117_N76 I=N76
XFE_PHC3116_N75 DELB $PINS O=N75 I=FE_PHN3116_N75
XFE_PHC3114_N70 DELB $PINS O=FE_PHN3114_N70 I=N70
XFE_PHC3103_N72 DELB $PINS O=FE_PHN3103_N72 I=N72
XFE_PHC3096_N71 DELB $PINS O=FE_PHN3096_N71 I=N71
XFE_PHC3090_N68 DELB $PINS O=FE_PHN3090_N68 I=N68
XFE_PHC3078_N73 DELB $PINS O=FE_PHN3078_N73 I=N73
XFE_PHC3004_N74 DELB $PINS O=FE_PHN3004_N74 I=N74
XFE_PHC2953_N69 DELB $PINS O=FE_PHN2953_N69 I=N69
XFE_OCPC11_IyIt_shift_13 BUF1 $PINS O=FE_OCPN4_IyIt_shift_13 I=B[13]
XFE_OFC2932_FE_DBTN154_n3259 BUF1 $PINS O=FE_OFN4367_n
+ I=FE_OFN2739_FE_DBTN154_n3259
XFE_OFC2928_FE_DBTN154_n3259 BUF2CK $PINS O=FE_OFN4363_n
+ I=FE_OFN1418_FE_DBTN154_n3259
XFE_OFC2911_Ix2_shift_13 BUF1 $PINS O=FE_OFN4346_n I=FE_OFN961_Ix2_shift_13
XFE_OFC2739_FE_DBTN154_n3259 BUF6 $PINS O=FE_OFN2739_FE_DBTN154_n3259
+ I=FE_OFN1418_FE_DBTN154_n3259
XFE_OFC2895_Ix2_shift_9 BUF1 $PINS O=FE_OFN4330_n I=FE_OFN4329_n
XFE_OFC2894_Ix2_shift_9 INV1S $PINS O=FE_OFN4329_n I=FE_OFN4327_n
XFE_OFC2893_Ix2_shift_9 INV1S $PINS O=FE_OFN4328_n I=FE_OFN4327_n
XFE_OFC2892_Ix2_shift_9 INV1S $PINS O=FE_OFN4327_n I=FE_OFN1266_Ix2_shift_9
XFE_OFC2881_Ix2_shift_13 BUF1 $PINS O=FE_OFN4316_n I=FE_OFN960_Ix2_shift_13
XFE_OFC2877_n3259 BUF1CK $PINS O=FE_OFN4312_n I=FE_OFN1233_n3259
XFE_OFC2876_n3259 BUF1 $PINS O=FE_OFN4311_n I=FE_OFN1233_n3259
XFE_OFC2862_Ix2_shift_9 BUF1 $PINS O=FE_OFN4297_n I=FE_OFN1268_Ix2_shift_9
XFE_OFC2861_Ix2_shift_9 BUF1 $PINS O=FE_OFN4296_n I=FE_OFN1268_Ix2_shift_9
XFE_OFC2834_n455 BUF1 $PINS O=FE_OFN4269_n455 I=n455
XFE_OFC2830_n421 BUF1 $PINS O=FE_OFN4265_n421 I=n421
XFE_OFC2801_FE_DBTN97_IyIt_shift_8 BUF1 $PINS
+ O=FE_OFN4236_FE_DBTN97_IyIt_shift_8 I=FE_OFN4235_FE_DBTN97_IyIt_shift_8
XFE_OFC2800_FE_DBTN97_IyIt_shift_8 BUF1 $PINS
+ O=FE_OFN4235_FE_DBTN97_IyIt_shift_8 I=FE_DBTN97_IyIt_shift_8
XFE_OFC2777_FE_OFN876_IyIt_shift_0 BUF1 $PINS
+ O=FE_OFN4211_FE_OFN876_IyIt_shift_0 I=B[0]
XFE_OFC2775_FE_OFN876_IyIt_shift_0 BUF1 $PINS O=FE_RN_6 I=B[0]
XFE_OFC2765_FE_OFN1580_Ix2_shift_13 BUF1 $PINS
+ O=FE_OFN4200_FE_OFN1580_Ix2_shift_13 I=FE_OFN4199_FE_OFN1580_Ix2_shift_13
XFE_OFC2764_FE_OFN1580_Ix2_shift_13 BUF1 $PINS
+ O=FE_OFN4199_FE_OFN1580_Ix2_shift_13 I=A[13]
XFE_OFC2730_FE_OFN1078_Ix2_shift_15 BUF1 $PINS O=FE_RN_5
+ I=FE_OFN160_Ix2_shift_15
XFE_OFC2606_IyIt_shift_11 BUF1 $PINS O=FE_OFN4127_IyIt_shift_11 I=B[11]
XFE_OFC2602_IyIt_shift_9 BUF1 $PINS O=FE_DBTN99_IyIt_shift_9
+ I=FE_OFN1172_FE_DBTN99_IyIt_shift_9
XFE_OFC2601_IyIt_shift_9 INV1S $PINS O=FE_OFN1172_FE_DBTN99_IyIt_shift_9 I=B[9]
XFE_OFC2584_IyIt_shift_8 INV2 $PINS O=FE_DBTN97_IyIt_shift_8
+ I=FE_OFN250_IyIt_shift_8
XFE_OFC2583_IyIt_shift_8 BUF1 $PINS O=FE_RN_4 I=FE_OFN250_IyIt_shift_8
XFE_OFC2485_IyIt_shift_7 BUF1 $PINS O=FE_OFN1757_IyIt_shift_7 I=IyIt_shift_7
XFE_OFC2480_IyIt_shift_7 INV1S $PINS O=FE_OFN1756_IyIt_shift_7 I=B[7]
XFE_OFC2479_IyIt_shift_7 INV1S $PINS O=FE_OFN1755_IyIt_shift_7 I=B[7]
XFE_OFC2478_IyIt_shift_7 INV1S $PINS O=FE_OFN1754_IyIt_shift_7 I=B[7]
XFE_OFC2477_IyIt_shift_7 INV1S $PINS O=FE_OFN1753_IyIt_shift_7 I=B[7]
XFE_OFC2476_IyIt_shift_7 INV1S $PINS O=FE_OFN1193_FE_DBTN14_IyIt_shift_7 I=B[7]
XFE_OFC2474_n468 BUF1 $PINS O=FE_OFN1752_n468 I=FE_OFN1519_n468
XFE_OFC2473_n468 BUF1 $PINS O=FE_OFN1519_n468 I=n468
XFE_OFC2391_IyIt_shift_3 INV1S $PINS O=FE_OFN1719_IyIt_shift_3 I=B[3]
XFE_OFC2390_IyIt_shift_3 BUF1 $PINS O=FE_OFN1479_FE_DBTN91_IyIt_shift_3
+ I=FE_OFN1480_FE_DBTN91_IyIt_shift_3
XFE_OFC2389_IyIt_shift_3 BUF1 $PINS O=FE_DBTN91_IyIt_shift_3
+ I=FE_OFN1480_FE_DBTN91_IyIt_shift_3
XFE_OFC2387_IyIt_shift_3 INV1S $PINS O=FE_OFN1480_FE_DBTN91_IyIt_shift_3
+ I=FE_OFN239_IyIt_shift_3
XFE_OFC2386_IyIt_shift_10 BUF1 $PINS O=FE_OFN1718_IyIt_shift_10
+ I=FE_OFN1715_IyIt_shift_10
XFE_OFC2385_IyIt_shift_10 BUF1 $PINS O=FE_OFN1717_IyIt_shift_10
+ I=FE_OFN1376_IyIt_shift_10
XFE_OFC2383_IyIt_shift_10 INV1S $PINS O=FE_OFN1715_IyIt_shift_10
+ I=FE_OFN1376_IyIt_shift_10
XFE_OFC2380_IyIt_shift_10 INV1S $PINS O=FE_OFN1376_IyIt_shift_10 I=B[10]
XFE_OFC2347_Ix2_shift_4 BUF1 $PINS O=FE_OFN1286_Ix2_shift_4
+ I=FE_OFN1285_Ix2_shift_4
XFE_OFC2345_Ix2_shift_4 INV1S $PINS O=FE_OFN1492_FE_DBTN31_Ix2_shift_4
+ I=Ix2_shift_4
XFE_OFC2343_Ix2_shift_4 BUF1 $PINS O=FE_OFN1285_Ix2_shift_4 I=Ix2_shift_4
XFE_OFC2317_IyIt_shift_1 BUF1 $PINS O=FE_OFN1699_IyIt_shift_1
+ I=FE_OFN138_IyIt_shift_1
XFE_OFC2316_IyIt_shift_1 INV1S $PINS O=FE_OFN1698_IyIt_shift_1
+ I=FE_OFN138_IyIt_shift_1
XFE_OFC2315_IyIt_shift_1 INV1S $PINS O=n208 I=FE_OFN138_IyIt_shift_1
XFE_OFC2314_IyIt_shift_1 INV1S $PINS O=FE_OFN1697_IyIt_shift_1
+ I=FE_OFN138_IyIt_shift_1
XFE_OFC2274_Ix2_shift_1 BUF1 $PINS O=FE_OFN1686_Ix2_shift_1
+ I=FE_OFN829_Ix2_shift_1
XFE_OFC2269_Ix2_shift_1 BUF1 $PINS O=FE_OFN1684_Ix2_shift_1
+ I=FE_OFN827_Ix2_shift_1
XFE_OFC2268_Ix2_shift_1 INV2 $PINS O=FE_OFN829_Ix2_shift_1
+ I=FE_OFN827_Ix2_shift_1
XFE_OFC2267_Ix2_shift_1 INV1S $PINS O=n158 I=FE_OFN827_Ix2_shift_1
XFE_OFC2264_Ix2_shift_1 INV1S $PINS O=FE_OFN827_Ix2_shift_1 I=A[1]
XFE_OFC2262_Ix2_shift_12 BUF1 $PINS O=FE_OFN1504_FE_DBTN20_Ix2_shift_12
+ I=Ix2_shift_12
XFE_OFC2260_Ix2_shift_12 INV1S $PINS O=FE_RN_3 I=Ix2_shift_12
XFE_OFC2243_Ix2_shift_2 BUF1 $PINS O=FE_OFN1433_FE_DBTN140_Ix2_shift_2
+ I=FE_OFN1432_FE_DBTN140_Ix2_shift_2
XFE_OFC2240_Ix2_shift_2 BUF1 $PINS O=FE_OFN1432_FE_DBTN140_Ix2_shift_2 I=A[2]
XFE_OFC2239_Ix2_shift_2 BUF1 $PINS O=FE_OFN1434_FE_DBTN140_Ix2_shift_2 I=A[2]
XFE_OFC2238_Ix2_shift_2 INV1S $PINS O=FE_DBTN140_Ix2_shift_2 I=A[2]
XFE_OFC2229_Ix2_shift_14 BUF1 $PINS O=FE_OFN1183_FE_DBTN26_Ix2_shift_14
+ I=FE_RN_2
XFE_OFC2227_Ix2_shift_14 INV1S $PINS O=FE_RN_2 I=Ix2_shift_14
XFE_OFC2226_Ix2_shift_14 BUF1 $PINS O=FE_OFN1087_Ix2_shift_14 I=Ix2_shift_14
XFE_OFC2207_Ix2_shift_5 BUF1 $PINS O=FE_OFN1429_FE_DBTN142_Ix2_shift_5
+ I=FE_OFN1428_FE_DBTN142_Ix2_shift_5
XFE_OFC2204_Ix2_shift_5 INV1S $PINS O=FE_DBTN142_Ix2_shift_5 I=A[5]
XFE_OFC2203_Ix2_shift_5 INV1S $PINS O=FE_OFN1428_FE_DBTN142_Ix2_shift_5 I=A[5]
XFE_OFC2165_intadd_144_n1 INV1S $PINS O=N50 I=intadd_144/n1
XFE_OFC2160_FE_DBTN93_IyIt_shift_5 BUF1 $PINS
+ O=FE_OFN1654_FE_DBTN93_IyIt_shift_5 I=FE_OFN1176_FE_DBTN93_IyIt_shift_5
XFE_OFC2159_FE_DBTN93_IyIt_shift_5 BUF1 $PINS
+ O=FE_OFN1175_FE_DBTN93_IyIt_shift_5 I=FE_DBTN93_IyIt_shift_5
XFE_OFC2158_FE_DBTN93_IyIt_shift_5 BUF1CK $PINS
+ O=FE_OFN1176_FE_DBTN93_IyIt_shift_5 I=FE_DBTN93_IyIt_shift_5
XFE_OFC2057_n435 BUF1 $PINS O=FE_OFN1537_n435 I=n435
XFE_OFC2037_Ix2_shift_6 INV1S $PINS O=FE_OFN1630_Ix2_shift_6 I=A[6]
XFE_OFC2036_Ix2_shift_6 INV1S $PINS O=FE_OFN279_FE_DBTN144_Ix2_shift_6 I=A[6]
XFE_OFC2035_Ix2_shift_6 BUF1 $PINS O=FE_DBTN144_Ix2_shift_6 I=A[6]
XFE_OFC2010_Ix2_shift_10 BUF1 $PINS O=FE_OFN1625_Ix2_shift_10
+ I=FE_OFN1261_Ix2_shift_10
XFE_OFC2009_Ix2_shift_10 INV1S $PINS O=FE_OFN1624_Ix2_shift_10
+ I=FE_OFN1261_Ix2_shift_10
XFE_OFC2007_Ix2_shift_10 INV1S $PINS O=FE_OFN1261_Ix2_shift_10
+ I=FE_DBTN148_Ix2_shift_10
XFE_OFC2004_Ix2_shift_10 BUF1 $PINS O=FE_DBTN148_Ix2_shift_10 I=A[10]
XFE_OFC1946_Ix2_shift_3 BUF1 $PINS O=FE_OFN1290_Ix2_shift_3
+ I=FE_OFN1289_Ix2_shift_3
XFE_OFC1943_Ix2_shift_3 INV1S $PINS O=FE_OFN1289_Ix2_shift_3 I=A[3]
XFE_OFC1915_FE_DBTN95_IyIt_shift_6 BUF1 $PINS
+ O=FE_OFN294_FE_DBTN95_IyIt_shift_6 I=FE_DBTN95_IyIt_shift_6
XFE_OFC1914_FE_DBTN95_IyIt_shift_6 BUF1 $PINS
+ O=FE_OFN295_FE_DBTN95_IyIt_shift_6 I=FE_DBTN95_IyIt_shift_6
XFE_OFC1895_Ix2_shift_8 INV1S $PINS O=FE_OFN1595_Ix2_shift_8 I=n421
XFE_OFC1893_Ix2_shift_8 INV1S $PINS O=FE_OFN1517_n421 I=n421
XFE_OFC1892_Ix2_shift_8 INV2 $PINS O=n421 I=FE_OFN1276_Ix2_shift_8
XFE_OFC1891_Ix2_shift_8 INV2 $PINS O=FE_OFN1276_Ix2_shift_8
+ I=FE_OFN1274_Ix2_shift_8
XFE_OFC1890_Ix2_shift_8 INV1S $PINS O=FE_OFN1275_Ix2_shift_8
+ I=FE_OFN1274_Ix2_shift_8
XFE_OFC1889_Ix2_shift_8 INV1S $PINS O=FE_OFN1274_Ix2_shift_8 I=A[8]
XFE_OFC1878_Ix2_shift_15 BUF1 $PINS O=FE_OFN1587_Ix2_shift_15
+ I=FE_OFN1189_FE_DBTN21_Ix2_shift_15
XFE_OFC1877_Ix2_shift_15 INV1S $PINS O=FE_OFN1586_Ix2_shift_15
+ I=FE_OFN1084_Ix2_shift_15
XFE_OFC1874_Ix2_shift_15 INV1S $PINS O=FE_OFN1083_Ix2_shift_15
+ I=FE_OFN1084_Ix2_shift_15
XFE_OFC1873_Ix2_shift_15 INV1S $PINS O=FE_OFN1080_Ix2_shift_15
+ I=FE_OFN1084_Ix2_shift_15
XFE_OFC1871_Ix2_shift_15 INV1S $PINS O=FE_OFN1189_FE_DBTN21_Ix2_shift_15
+ I=FE_RN_5
XFE_OFC1870_Ix2_shift_15 INV1S $PINS O=FE_OFN1084_Ix2_shift_15 I=FE_RN_5
XFE_OFC1841_n4484 BUF1 $PINS O=FE_OFN1497_FE_DBTN29_n4484 I=FE_OFN185_n4484
XFE_OFC1839_n4484 INV1S $PINS O=FE_RN_1 I=FE_OFN185_n4484
XFE_OFC1835_Ix2_shift_13 BUF1 $PINS O=FE_OFN961_Ix2_shift_13 I=FE_OFN4316_n
XFE_OFC1834_Ix2_shift_13 INV1S $PINS O=FE_DBTN150_Ix2_shift_13 I=A[13]
XFE_OFC1833_Ix2_shift_13 INV1S $PINS O=FE_OFN960_Ix2_shift_13
+ I=FE_OFN4199_FE_OFN1580_Ix2_shift_13
XFE_OFC1679_IyIt_shift_8 INV1S $PINS O=FE_OFN1565_IyIt_shift_8
+ I=FE_OFN238_IyIt_shift_8
XFE_OFC1678_IyIt_shift_8 INV1S $PINS O=FE_OFN1475_FE_DBTN97_IyIt_shift_8
+ I=FE_OFN238_IyIt_shift_8
XFE_OFC1619_Ix2_shift_9 INV1S $PINS O=FE_OFN1266_Ix2_shift_9
+ I=FE_OFN1268_Ix2_shift_9
XFE_OFC1618_Ix2_shift_9 BUF1 $PINS O=FE_OFN1268_Ix2_shift_9
+ I=FE_OFN194_Ix2_shift_9
XFE_OFC1610_n3259 INV3 $PINS O=FE_OFN1418_FE_DBTN154_n3259 I=FE_OFN1233_n3259
XFE_OFC1609_n3259 BUF2 $PINS O=FE_OFN1233_n3259 I=FE_OFN1237_n3259
XFE_OFC1608_n3259 BUF1CK $PINS O=FE_OFN1237_n3259 I=A[11]
XFE_OFC1536_n442 BUF1 $PINS O=FE_OFN1538_n442 I=n442
XFE_OFC1516_n467 BUF1 $PINS O=FE_OFN1518_n467 I=n467
XFE_OFC1514_n316 BUF1 $PINS O=FE_OFN1516_n316 I=n316
XFE_OFC1480_FE_DBTN89_n359 BUF1 $PINS O=FE_OFN1482_FE_DBTN89_n359
+ I=FE_DBTN89_n359
XFE_OFC1385_n348 BUF1 $PINS O=FE_OFN1387_n348 I=n348
XFE_OFC1279_Ix2_shift_7 BUF1 $PINS O=FE_OFN1281_Ix2_shift_7 I=A[7]
XFE_OFC1184_FE_DBTN22_IyIt_shift_15 BUF1 $PINS
+ O=FE_OFN1186_FE_DBTN22_IyIt_shift_15 I=B[15]
XFE_OFC1083_Ix2_shift_15 INV1S $PINS O=FE_OFN1085_Ix2_shift_15
+ I=FE_OFN1084_Ix2_shift_15
XFE_OFC1021_FE_DBTN102_IyIt_shift_14 BUF1 $PINS
+ O=FE_OFN1023_FE_DBTN102_IyIt_shift_14 I=FE_DBTN102_IyIt_shift_14
XFE_OFC1020_FE_DBTN102_IyIt_shift_14 BUF1 $PINS
+ O=FE_OFN1022_FE_DBTN102_IyIt_shift_14 I=FE_DBTN102_IyIt_shift_14
XFE_OFC881_FE_DBTN139_Ix2_shift_0 BUF1CK $PINS
+ O=FE_OFN883_FE_DBTN139_Ix2_shift_0 I=FE_DBTN139_Ix2_shift_0
XFE_OFC831_Ix2_shift_0 BUF1 $PINS O=FE_OFN833_Ix2_shift_0 I=A[0]
XFE_OFC191_i_reset_n_i BUF1 $PINS O=FE_OFN193_i_reset_n_i
+ I=FE_OFN144_i_reset_n_i
XFE_OFC183_i_reset_n_i BUF1 $PINS O=FE_OFN185_i_reset_n_i
+ I=FE_OFN65_i_reset_n_i
XFE_OFC178_i_reset_n_i BUF1 $PINS O=FE_OFN180_i_reset_n_i
+ I=FE_OFN60_i_reset_n_i
XFE_OFC142_i_reset_n_i BUF1 $PINS O=FE_OFN144_i_reset_n_i
+ I=FE_OFN96_i_reset_n_i
XFE_OFC94_i_reset_n_i BUF1 $PINS O=FE_OFN96_i_reset_n_i I=FE_OFN26_i_reset_n_i
XFE_OFC51_i_reset_n_i BUF1 $PINS O=FE_OFN52_i_reset_n_i I=rst_n
XFE_DBTC139_Ix2_shift_0 INV2 $PINS O=FE_DBTN139_Ix2_shift_0
+ I=FE_OFN833_Ix2_shift_0
XFE_DBTC102_IyIt_shift_14 INV1S $PINS O=FE_DBTN102_IyIt_shift_14
+ I=FE_OFN154_IyIt_shift_14
XFE_DBTC95_IyIt_shift_6 INV1S $PINS O=FE_DBTN95_IyIt_shift_6 I=B[6]
XFE_DBTC93_IyIt_shift_5 INV1S $PINS O=FE_DBTN93_IyIt_shift_5 I=B[5]
XFE_DBTC89_n359 INV2 $PINS O=FE_DBTN89_n359 I=n359
Xs1_P0_reg[9] QDFFRBN $PINS Q=s1_P0[9] D=N10 CK=clk_clone2
+ RB=FE_OFN180_i_reset_n_i
Xs1_P0_reg[7] QDFFRBN $PINS Q=FE_PHN3116_N75 D=N8 CK=clk
+ RB=FE_OFN28_i_reset_n_i
Xs1_P0_reg[6] QDFFRBN $PINS Q=N74 D=N7 CK=clk RB=FE_OFN28_i_reset_n_i
Xs1_P0_reg[5] QDFFRBN $PINS Q=N73 D=N6 CK=clk RB=FE_OFN28_i_reset_n_i
Xs1_P0_reg[4] QDFFRBN $PINS Q=N72 D=N5 CK=clk RB=FE_OFN49_i_reset_n_i
Xs1_P0_reg[3] QDFFRBN $PINS Q=N71 D=N4 CK=clk RB=FE_OFN84_i_reset_n_i
Xs1_P0_reg[1] QDFFRBN $PINS Q=N69 D=N2 CK=clk_clone2 RB=FE_OFN112_i_reset_n_i
Xs1_P0_reg[0] QDFFRBN $PINS Q=N68 D=N1 CK=clk_clone2 RB=FE_OFN112_i_reset_n_i
Xs1_P1_reg[15] QDFFRBN $PINS Q=s1_P1[15] D=N33 CK=clk_clone3
+ RB=FE_OFN144_i_reset_n_i
Xs1_P1_reg[1] QDFFRBN $PINS Q=s1_P1[1] D=N19 CK=clk RB=FE_OFN180_i_reset_n_i
Xs1_P2_reg[15] QDFFRBN $PINS Q=s1_P2[15] D=N50 CK=clk_clone2
+ RB=FE_OFN193_i_reset_n_i
Xs1_P2_reg[1] QDFFRBN $PINS Q=s1_P2[1] D=N36 CK=clk_clone2
+ RB=FE_OFN180_i_reset_n_i
Xs1_P3_reg[15] QDFFRBN $PINS Q=s1_P3[15] D=N67 CK=clk_clone3
+ RB=FE_OFN46_i_reset_n_i
Xs1_P3_reg[14] QDFFRBN $PINS Q=s1_P3[14] D=N66 CK=clk_clone3
+ RB=FE_OFN96_i_reset_n_i
Xs1_P3_reg[13] QDFFRBN $PINS Q=s1_P3[13] D=N65 CK=clk_clone3
+ RB=FE_OFN96_i_reset_n_i
Xs1_P3_reg[12] QDFFRBN $PINS Q=s1_P3[12] D=N64 CK=clk_clone3
+ RB=FE_OFN96_i_reset_n_i
Xs1_P3_reg[11] QDFFRBN $PINS Q=s1_P3[11] D=N63 CK=clk_clone3
+ RB=FE_OFN144_i_reset_n_i
Xs1_P3_reg[10] QDFFRBN $PINS Q=s1_P3[10] D=N62 CK=clk_clone3
+ RB=FE_OFN144_i_reset_n_i
Xs1_P3_reg[9] QDFFRBN $PINS Q=s1_P3[9] D=N61 CK=clk_clone3
+ RB=FE_OFN144_i_reset_n_i
Xs1_P3_reg[8] QDFFRBN $PINS Q=s1_P3[8] D=N60 CK=clk_clone3
+ RB=FE_OFN144_i_reset_n_i
Xs2_result_reg[31] QDFFRBN $PINS Q=result[31] D=N99 CK=clk_clone1
+ RB=FE_OFN61_i_reset_n_i
Xs2_result_reg[30] QDFFRBN $PINS Q=result[30] D=N98 CK=clk_clone1
+ RB=FE_OFN61_i_reset_n_i
Xs2_result_reg[29] QDFFRBN $PINS Q=result[29] D=N97 CK=clk_clone1
+ RB=FE_OFN61_i_reset_n_i
Xs2_result_reg[28] QDFFRBN $PINS Q=result[28] D=N96 CK=clk_clone1
+ RB=FE_OFN40_i_reset_n_i
Xs2_result_reg[27] QDFFRBN $PINS Q=result[27] D=N95 CK=clk_clone1
+ RB=FE_OFN61_i_reset_n_i
Xs2_result_reg[26] QDFFRBN $PINS Q=result[26] D=N94 CK=clk_clone2
+ RB=FE_OFN38_i_reset_n_i
Xs2_result_reg[25] QDFFRBN $PINS Q=result[25] D=N93 CK=clk_clone2
+ RB=FE_OFN38_i_reset_n_i
Xs2_result_reg[24] QDFFRBN $PINS Q=result[24] D=N92 CK=clk_clone1
+ RB=FE_OFN38_i_reset_n_i
Xs2_result_reg[23] QDFFRBN $PINS Q=result[23] D=N91 CK=clk_clone1
+ RB=FE_OFN40_i_reset_n_i
Xs2_result_reg[22] QDFFRBN $PINS Q=result[22] D=N90 CK=clk_clone2
+ RB=FE_OFN22_i_reset_n_i
Xs2_result_reg[21] QDFFRBN $PINS Q=result[21] D=N89 CK=clk
+ RB=FE_OFN185_i_reset_n_i
Xs2_result_reg[20] QDFFRBN $PINS Q=result[20] D=N88 CK=clk_clone2
+ RB=FE_OFN41_i_reset_n_i
Xs2_result_reg[19] QDFFRBN $PINS Q=result[19] D=N87 CK=clk_clone2
+ RB=FE_OFN113_i_reset_n_i
Xs2_result_reg[18] QDFFRBN $PINS Q=result[18] D=N86 CK=clk_clone2
+ RB=FE_OFN113_i_reset_n_i
Xs2_result_reg[16] QDFFRBN $PINS Q=result[16] D=N84 CK=clk_clone2
+ RB=FE_OFN113_i_reset_n_i
Xs2_result_reg[15] QDFFRBN $PINS Q=result[15] D=N83 CK=clk_clone2
+ RB=FE_OFN113_i_reset_n_i
Xs2_result_reg[14] QDFFRBN $PINS Q=result[14] D=N82 CK=clk
+ RB=FE_OFN84_i_reset_n_i
Xs2_result_reg[13] QDFFRBN $PINS Q=result[13] D=N81 CK=clk
+ RB=FE_OFN185_i_reset_n_i
Xs2_result_reg[12] QDFFRBN $PINS Q=result[12] D=N80 CK=clk
+ RB=FE_OFN6_i_reset_n_i
Xs2_result_reg[11] QDFFRBN $PINS Q=result[11] D=N79 CK=clk
+ RB=FE_OFN185_i_reset_n_i
Xs2_result_reg[10] QDFFRBN $PINS Q=result[10] D=N78 CK=clk
+ RB=FE_OFN185_i_reset_n_i
Xs2_result_reg[9] QDFFRBN $PINS Q=result[9] D=N77 CK=clk
+ RB=FE_OFN185_i_reset_n_i
Xs2_result_reg[8] QDFFRBN $PINS Q=result[8] D=FE_PHN3117_N76 CK=clk
+ RB=FE_OFN185_i_reset_n_i
Xs2_result_reg[7] QDFFRBN $PINS Q=result[7] D=N75 CK=clk
+ RB=FE_OFN106_i_reset_n_i
Xs2_result_reg[6] QDFFRBN $PINS Q=result[6] D=FE_PHN3004_N74 CK=clk
+ RB=FE_OFN71_i_reset_n_i
Xs2_result_reg[5] QDFFRBN $PINS Q=result[5] D=FE_PHN3078_N73 CK=clk
+ RB=FE_OFN106_i_reset_n_i
Xs2_result_reg[4] QDFFRBN $PINS Q=result[4] D=FE_PHN3103_N72 CK=clk
+ RB=FE_OFN91_i_reset_n_i
Xs2_result_reg[3] QDFFRBN $PINS Q=result[3] D=FE_PHN3096_N71 CK=clk
+ RB=FE_OFN98_i_reset_n_i
Xs2_result_reg[1] QDFFRBN $PINS Q=result[1] D=FE_PHN2953_N69 CK=clk
+ RB=FE_OFN98_i_reset_n_i
Xs2_result_reg[0] QDFFRBN $PINS Q=result[0] D=FE_PHN3090_N68 CK=clk_clone2
+ RB=FE_OFN98_i_reset_n_i
Xintadd_145/U14 FA1 $PINS S=N20 CO=intadd_145/n13 A=intadd_145/B[0]
+ B=intadd_145/A[0] CI=intadd_145/CI
Xintadd_145/U13 FA1 $PINS S=N21 CO=intadd_145/n12 A=intadd_145/B[1]
+ B=intadd_145/A[1] CI=intadd_145/n13
Xintadd_145/U11 FA1 $PINS S=N23 CO=intadd_145/n10 A=intadd_145/B[3]
+ B=intadd_145/A[3] CI=intadd_145/n11
Xintadd_145/U9 FA1 $PINS S=N25 CO=intadd_145/n8 A=intadd_145/B[5]
+ B=intadd_145/A[5] CI=intadd_145/n9
Xintadd_145/U4 FA1 $PINS S=N30 CO=intadd_145/n3 A=intadd_151/n1
+ B=intadd_145/A[10] CI=intadd_145/n4
Xintadd_145/U3 FA1 $PINS S=N31 CO=intadd_145/n2 A=intadd_145/B[11]
+ B=intadd_160/n1 CI=intadd_145/n3
Xintadd_148/U5 FA1S $PINS S=intadd_148/SUM[0] CO=intadd_148/n4
+ A=intadd_148/B[0] B=intadd_148/A[0] CI=intadd_148/CI
Xintadd_148/U4 FA1S $PINS S=intadd_148/SUM[1] CO=intadd_148/n3
+ A=intadd_148/B[1] B=intadd_148/A[1] CI=intadd_148/n4
Xintadd_148/U3 FA1S $PINS S=intadd_148/SUM[2] CO=intadd_148/n2
+ A=intadd_148/B[2] B=intadd_148/A[2] CI=intadd_148/n3
Xintadd_148/U2 FA1S $PINS S=intadd_148/SUM[3] CO=intadd_148/n1
+ A=intadd_148/B[3] B=intadd_148/A[3] CI=intadd_148/n2
Xintadd_149/U5 FA1S $PINS S=intadd_149/SUM[0] CO=intadd_149/n4
+ A=intadd_149/B[0] B=intadd_149/A[0] CI=intadd_149/CI
Xintadd_149/U4 FA1S $PINS S=intadd_149/SUM[1] CO=intadd_149/n3
+ A=intadd_149/B[1] B=intadd_149/A[1] CI=intadd_149/n4
Xintadd_149/U3 FA1S $PINS S=intadd_149/SUM[2] CO=intadd_149/n2
+ A=intadd_149/B[2] B=intadd_149/A[2] CI=intadd_149/n3
Xintadd_149/U2 FA1S $PINS S=intadd_149/SUM[3] CO=intadd_149/n1
+ A=intadd_149/B[3] B=intadd_148/SUM[2] CI=intadd_149/n2
Xintadd_150/U5 FA1S $PINS S=intadd_150/SUM[0] CO=intadd_150/n4
+ A=intadd_150/B[0] B=intadd_150/A[0] CI=intadd_150/CI
Xintadd_150/U4 FA1S $PINS S=intadd_150/SUM[1] CO=intadd_150/n3
+ A=intadd_150/B[1] B=intadd_150/A[1] CI=intadd_150/n4
Xintadd_150/U3 FA1S $PINS S=intadd_150/SUM[2] CO=intadd_150/n2
+ A=intadd_148/SUM[0] B=intadd_150/A[2] CI=intadd_150/n3
Xintadd_150/U2 FA1S $PINS S=intadd_150/SUM[3] CO=intadd_150/n1
+ A=intadd_148/SUM[1] B=intadd_149/SUM[2] CI=intadd_150/n2
Xintadd_151/U5 FA1S $PINS S=intadd_151/SUM[0] CO=intadd_151/n4
+ A=intadd_151/B[0] B=intadd_151/A[0] CI=intadd_151/CI
Xintadd_151/U4 FA1S $PINS S=intadd_151/SUM[1] CO=intadd_151/n3
+ A=intadd_151/B[1] B=intadd_151/A[1] CI=intadd_151/n4
Xintadd_151/U3 FA1S $PINS S=intadd_151/SUM[2] CO=intadd_151/n2
+ A=intadd_151/B[2] B=intadd_151/A[2] CI=intadd_151/n3
Xintadd_151/U2 FA1S $PINS S=intadd_145/A[9] CO=intadd_151/n1 A=intadd_151/B[3]
+ B=intadd_151/A[3] CI=intadd_151/n2
Xintadd_152/U5 FA1S $PINS S=intadd_152/SUM[0] CO=intadd_152/n4
+ A=intadd_152/B[0] B=intadd_152/A[0] CI=intadd_152/CI
Xintadd_152/U4 FA1S $PINS S=intadd_152/SUM[1] CO=intadd_152/n3
+ A=intadd_152/B[1] B=intadd_152/A[1] CI=intadd_152/n4
Xintadd_152/U3 FA1S $PINS S=intadd_152/SUM[2] CO=intadd_152/n2
+ A=intadd_152/B[2] B=intadd_152/A[2] CI=intadd_152/n3
Xintadd_152/U2 FA1S $PINS S=intadd_145/A[8] CO=intadd_152/n1 A=intadd_152/B[3]
+ B=intadd_151/SUM[2] CI=intadd_152/n2
Xintadd_153/U5 FA1S $PINS S=intadd_153/SUM[0] CO=intadd_153/n4
+ A=intadd_153/B[0] B=intadd_153/A[0] CI=intadd_153/CI
Xintadd_153/U4 FA1S $PINS S=intadd_153/SUM[1] CO=intadd_153/n3
+ A=intadd_153/B[1] B=intadd_153/A[1] CI=intadd_153/n4
Xintadd_153/U3 FA1S $PINS S=intadd_153/SUM[2] CO=intadd_153/n2
+ A=intadd_151/SUM[0] B=intadd_153/A[2] CI=intadd_153/n3
Xintadd_153/U2 FA1S $PINS S=intadd_145/A[7] CO=intadd_153/n1
+ A=intadd_152/SUM[2] B=intadd_151/SUM[1] CI=intadd_153/n2
Xintadd_154/U5 FA1S $PINS S=intadd_154/SUM[0] CO=intadd_154/n4
+ A=intadd_154/B[0] B=intadd_154/A[0] CI=intadd_154/CI
Xintadd_154/U4 FA1S $PINS S=intadd_154/SUM[1] CO=intadd_154/n3
+ A=intadd_154/B[1] B=intadd_154/A[1] CI=intadd_154/n4
Xintadd_154/U3 FA1S $PINS S=intadd_154/SUM[2] CO=intadd_154/n2
+ A=intadd_154/B[2] B=intadd_154/A[2] CI=intadd_154/n3
Xintadd_155/U5 FA1S $PINS S=intadd_155/SUM[0] CO=intadd_155/n4
+ A=intadd_155/B[0] B=intadd_155/A[0] CI=intadd_155/CI
Xintadd_155/U4 FA1S $PINS S=intadd_155/SUM[1] CO=intadd_155/n3
+ A=intadd_155/B[1] B=intadd_155/A[1] CI=intadd_155/n4
Xintadd_155/U3 FA1S $PINS S=intadd_155/SUM[2] CO=intadd_155/n2
+ A=intadd_155/B[2] B=intadd_155/A[2] CI=intadd_155/n3
Xintadd_156/U5 FA1S $PINS S=intadd_156/SUM[0] CO=intadd_156/n4
+ A=intadd_156/B[0] B=intadd_156/A[0] CI=intadd_156/CI
Xintadd_156/U4 FA1S $PINS S=intadd_156/SUM[1] CO=intadd_156/n3
+ A=intadd_156/B[1] B=intadd_156/A[1] CI=intadd_156/n4
Xintadd_156/U3 FA1 $PINS S=intadd_156/SUM[2] CO=intadd_156/n2
+ A=intadd_154/SUM[0] B=intadd_156/A[2] CI=intadd_156/n3
Xintadd_157/U4 FA1S $PINS S=intadd_148/A[2] CO=intadd_157/n3 A=intadd_157/B[0]
+ B=intadd_157/A[0] CI=intadd_157/CI
Xintadd_157/U3 FA1S $PINS S=intadd_148/A[3] CO=intadd_157/n2 A=intadd_157/B[1]
+ B=intadd_157/A[1] CI=intadd_157/n3
Xintadd_157/U2 FA1S $PINS S=intadd_157/SUM[2] CO=intadd_157/n1
+ A=intadd_157/B[2] B=intadd_157/A[2] CI=intadd_157/n2
Xintadd_158/U4 FA1S $PINS S=intadd_158/SUM[0] CO=intadd_158/n3
+ A=intadd_158/B[0] B=intadd_158/A[0] CI=intadd_158/CI
Xintadd_158/U3 FA1S $PINS S=intadd_158/SUM[1] CO=intadd_158/n2
+ A=intadd_149/SUM[0] B=intadd_158/A[1] CI=intadd_158/n3
Xintadd_158/U2 FA1S $PINS S=intadd_158/SUM[2] CO=intadd_158/n1
+ A=intadd_149/SUM[1] B=intadd_150/SUM[2] CI=intadd_158/n2
Xintadd_159/U4 FA1S $PINS S=intadd_159/SUM[0] CO=intadd_159/n3
+ A=intadd_159/B[0] B=intadd_159/A[0] CI=intadd_159/CI
Xintadd_159/U3 FA1S $PINS S=intadd_159/SUM[1] CO=intadd_159/n2
+ A=intadd_159/B[1] B=intadd_150/SUM[0] CI=intadd_159/n3
Xintadd_159/U2 FA1S $PINS S=intadd_159/SUM[2] CO=intadd_159/n1
+ A=intadd_150/SUM[1] B=intadd_158/SUM[1] CI=intadd_159/n2
Xintadd_160/U4 FA1S $PINS S=intadd_151/B[2] CO=intadd_160/n3 A=intadd_160/B[0]
+ B=intadd_160/A[0] CI=intadd_160/CI
Xintadd_160/U3 FA1S $PINS S=intadd_151/A[3] CO=intadd_160/n2 A=intadd_160/B[1]
+ B=intadd_160/A[1] CI=intadd_160/n3
Xintadd_160/U2 FA1S $PINS S=intadd_145/A[10] CO=intadd_160/n1 A=intadd_160/B[2]
+ B=intadd_160/A[2] CI=intadd_160/n2
Xintadd_161/U4 FA1S $PINS S=intadd_161/SUM[0] CO=intadd_161/n3
+ A=intadd_161/B[0] B=intadd_161/A[0] CI=intadd_161/CI
Xintadd_161/U3 FA1S $PINS S=intadd_161/SUM[1] CO=intadd_161/n2
+ A=intadd_152/SUM[0] B=intadd_161/A[1] CI=intadd_161/n3
Xintadd_161/U2 FA1S $PINS S=intadd_145/A[6] CO=intadd_161/n1
+ A=intadd_153/SUM[2] B=intadd_152/SUM[1] CI=intadd_161/n2
Xintadd_162/U4 FA1S $PINS S=intadd_162/SUM[0] CO=intadd_162/n3
+ A=intadd_162/B[0] B=intadd_162/A[0] CI=intadd_162/CI
Xintadd_162/U3 FA1S $PINS S=intadd_162/SUM[1] CO=intadd_162/n2
+ A=intadd_153/SUM[0] B=intadd_162/A[1] CI=intadd_162/n3
Xintadd_162/U2 FA1S $PINS S=intadd_145/A[5] CO=intadd_162/n1
+ A=intadd_153/SUM[1] B=intadd_161/SUM[1] CI=intadd_162/n2
Xintadd_163/U4 FA1S $PINS S=intadd_154/B[2] CO=intadd_163/n3 A=intadd_163/B[0]
+ B=intadd_163/A[0] CI=intadd_163/CI
Xintadd_163/U3 FA1S $PINS S=intadd_154/A[3] CO=intadd_163/n2 A=intadd_163/B[1]
+ B=intadd_163/A[1] CI=intadd_163/n3
Xintadd_163/U2 FA1S $PINS S=intadd_163/SUM[2] CO=intadd_163/n1
+ A=intadd_163/B[2] B=intadd_163/A[2] CI=intadd_163/n2
Xintadd_164/U4 FA1S $PINS S=intadd_164/SUM[0] CO=intadd_164/n3
+ A=intadd_164/B[0] B=intadd_164/A[0] CI=intadd_164/CI
Xintadd_164/U3 FA1S $PINS S=intadd_164/SUM[1] CO=intadd_164/n2
+ A=intadd_155/SUM[0] B=intadd_164/A[1] CI=intadd_164/n3
Xintadd_165/U4 FA1S $PINS S=intadd_165/SUM[0] CO=intadd_165/n3
+ A=intadd_165/B[0] B=intadd_165/A[0] CI=intadd_165/CI
Xintadd_165/U3 FA1S $PINS S=intadd_165/SUM[1] CO=intadd_165/n2
+ A=intadd_156/SUM[0] B=intadd_165/A[1] CI=intadd_165/n3
Xintadd_143/U4 FA1 $PINS S=N96 CO=intadd_143/n3 A=intadd_143/B[20] B=s1_P3[11]
+ CI=intadd_143/n4
Xintadd_143/U3 FA1 $PINS S=N97 CO=intadd_143/n2 A=intadd_143/B[21] B=s1_P3[12]
+ CI=intadd_143/n3
Xintadd_144/U14 FA1S $PINS S=N37 CO=intadd_144/n13 A=intadd_144/B[0]
+ B=intadd_144/A[0] CI=intadd_144/CI
Xintadd_144/U13 FA1S $PINS S=N38 CO=intadd_144/n12 A=intadd_144/B[1]
+ B=intadd_144/A[1] CI=intadd_144/n13
Xintadd_144/U11 FA1 $PINS S=N40 CO=intadd_144/n10 A=intadd_144/B[3]
+ B=intadd_144/A[3] CI=intadd_144/n11
Xintadd_144/U10 FA1 $PINS S=N41 CO=intadd_144/n9 A=intadd_144/B[4]
+ B=intadd_144/A[4] CI=intadd_144/n10
Xintadd_144/U9 FA1 $PINS S=N42 CO=intadd_144/n8 A=intadd_144/B[5]
+ B=intadd_165/SUM[2] CI=intadd_144/n9
Xintadd_144/U8 FA1S $PINS S=N43 CO=intadd_144/n7 A=intadd_165/n1
+ B=intadd_164/SUM[2] CI=intadd_144/n8
Xintadd_144/U7 FA1S $PINS S=N44 CO=intadd_144/n6 A=intadd_164/n1
+ B=intadd_156/SUM[3] CI=intadd_144/n7
Xintadd_144/U6 FA1S $PINS S=N45 CO=intadd_144/n5 A=intadd_156/n1
+ B=intadd_155/SUM[3] CI=intadd_144/n6
Xintadd_144/U5 FA1 $PINS S=N46 CO=intadd_144/n4 A=intadd_155/n1
+ B=intadd_154/SUM[3] CI=intadd_144/n5
Xintadd_144/U4 FA1 $PINS S=N47 CO=intadd_144/n3 A=intadd_154/n1
+ B=intadd_163/SUM[2] CI=intadd_144/n4
Xintadd_144/U3 FA1 $PINS S=N48 CO=intadd_144/n2 A=intadd_144/B[11]
+ B=intadd_163/n1 CI=intadd_144/n3
Xintadd_144/U2 FA1 $PINS S=N49 CO=intadd_144/n1 A=intadd_144/B[12]
+ B=intadd_144/A[12] CI=intadd_144/n2
Xintadd_146/U13 FA1S $PINS S=N55 CO=intadd_146/n12 A=intadd_146/B[0]
+ B=intadd_146/A[0] CI=intadd_146/CI
Xintadd_146/U12 FA1 $PINS S=N56 CO=intadd_146/n11 A=intadd_146/B[1]
+ B=intadd_146/A[1] CI=intadd_146/n12
Xintadd_146/U11 FA1 $PINS S=N57 CO=intadd_146/n10 A=intadd_146/B[2]
+ B=intadd_146/A[2] CI=intadd_146/n11
Xintadd_146/U8 FA1 $PINS S=N60 CO=intadd_146/n7 A=intadd_146/B[5]
+ B=intadd_146/A[5] CI=intadd_146/n8
Xintadd_146/U7 FA1 $PINS S=N61 CO=intadd_146/n6 A=intadd_146/B[6]
+ B=intadd_146/A[6] CI=intadd_146/n7
Xintadd_146/U6 FA1 $PINS S=N62 CO=intadd_146/n5 A=intadd_146/B[7]
+ B=intadd_146/A[7] CI=intadd_146/n6
Xintadd_146/U5 FA1 $PINS S=N63 CO=intadd_146/n4 A=intadd_146/B[8]
+ B=intadd_146/A[8] CI=intadd_146/n5
Xintadd_147/U13 FA1 $PINS S=N3 CO=intadd_147/n12 A=intadd_147/B[0]
+ B=intadd_147/A[0] CI=intadd_147/CI
Xintadd_147/U11 FA1 $PINS S=N5 CO=intadd_147/n10 A=intadd_147/B[2]
+ B=intadd_147/A[2] CI=intadd_147/n11
Xintadd_147/U9 FA1 $PINS S=N7 CO=intadd_147/n8 A=intadd_147/B[4]
+ B=intadd_147/A[4] CI=intadd_147/n9
XR_87 QDFFRBN $PINS Q=intadd_143/A[15] D=n510 CK=clk_clone2
+ RB=FE_OFN193_i_reset_n_i
XR_88 QDFFRBN $PINS Q=intadd_143/B[14] D=n509 CK=clk_clone2
+ RB=FE_OFN193_i_reset_n_i
XR_89 QDFFRBN $PINS Q=intadd_143/A[14] D=n508 CK=clk_clone2
+ RB=FE_OFN193_i_reset_n_i
XR_90 QDFFRBN $PINS Q=intadd_143/B[13] D=n507 CK=clk_clone2
+ RB=FE_OFN193_i_reset_n_i
XR_91 QDFFRBN $PINS Q=intadd_143/A[13] D=n506 CK=clk_clone2
+ RB=FE_OFN52_i_reset_n_i
XR_92 QDFFRBN $PINS Q=intadd_143/B[12] D=n505 CK=clk_clone2
+ RB=FE_OFN52_i_reset_n_i
XR_93 QDFFRBN $PINS Q=intadd_143/A[12] D=n504 CK=clk_clone2
+ RB=FE_OFN52_i_reset_n_i
XR_94 QDFFRBN $PINS Q=intadd_143/B[11] D=n503 CK=clk_clone2
+ RB=FE_OFN52_i_reset_n_i
XR_95 QDFFRBN $PINS Q=intadd_143/A[11] D=n502 CK=clk_clone2 RB=rst_n
XR_96 QDFFRBN $PINS Q=intadd_143/B[10] D=n501 CK=clk_clone2 RB=rst_n
XR_97 QDFFRBN $PINS Q=intadd_143/A[10] D=n500 CK=clk_clone2 RB=rst_n
XR_98 QDFFRBN $PINS Q=intadd_143/B[9] D=n499 CK=clk_clone2 RB=rst_n
XR_100 QDFFRBN $PINS Q=intadd_143/B[8] D=n497 CK=clk_clone2
+ RB=FE_OFN21_i_reset_n_i
XR_101 QDFFRBN $PINS Q=intadd_143/A[8] D=n496 CK=clk_clone2
+ RB=FE_OFN21_i_reset_n_i
XR_102 QDFFRBN $PINS Q=intadd_143/B[7] D=n495 CK=clk_clone2
+ RB=FE_OFN21_i_reset_n_i
XR_105 QDFFRBN $PINS Q=intadd_143/A[6] D=n494 CK=clk_clone2
+ RB=FE_OFN37_i_reset_n_i
XR_106 QDFFRBN $PINS Q=intadd_143/B[5] D=n493 CK=clk_clone2
+ RB=FE_OFN37_i_reset_n_i
XR_107 QDFFRBN $PINS Q=intadd_143/A[5] D=n492 CK=clk_clone2
+ RB=FE_OFN37_i_reset_n_i
XR_108 QDFFRBN $PINS Q=intadd_143/B[4] D=n491 CK=clk_clone2
+ RB=FE_OFN37_i_reset_n_i
XR_109 QDFFRBN $PINS Q=intadd_143/A[4] D=n490 CK=clk_clone2
+ RB=FE_OFN60_i_reset_n_i
XR_110 QDFFRBN $PINS Q=intadd_143/B[3] D=n489 CK=clk_clone2
+ RB=FE_OFN60_i_reset_n_i
XR_111 QDFFRBN $PINS Q=intadd_143/A[3] D=n488 CK=clk_clone2
+ RB=FE_OFN60_i_reset_n_i
XR_112 QDFFRBN $PINS Q=intadd_143/B[2] D=n487 CK=clk_clone2
+ RB=FE_OFN60_i_reset_n_i
XR_113 QDFFRBN $PINS Q=intadd_143/n23 D=n486 CK=clk RB=FE_OFN49_i_reset_n_i
XR_114 QDFFRBN $PINS Q=N76 D=n485 CK=clk RB=FE_OFN91_i_reset_n_i
Xintadd_146/U2 FA1 $PINS S=N66 CO=intadd_146/n1 A=intadd_146/B[11]
+ B=intadd_146/A[11] CI=intadd_146/n2
Xintadd_155/U2 FA1S $PINS S=intadd_155/SUM[3] CO=intadd_155/n1
+ A=intadd_155/B[3] B=intadd_154/SUM[2] CI=intadd_155/n2
Xintadd_154/U2 FA1S $PINS S=intadd_154/SUM[3] CO=intadd_154/n1
+ A=intadd_154/B[3] B=intadd_154/A[3] CI=intadd_154/n2
Xintadd_156/U2 FA1S $PINS S=intadd_156/SUM[3] CO=intadd_156/n1
+ A=intadd_155/SUM[2] B=intadd_154/SUM[1] CI=intadd_156/n2
Xintadd_164/U2 FA1S $PINS S=intadd_164/SUM[2] CO=intadd_164/n1
+ A=intadd_156/SUM[2] B=intadd_155/SUM[1] CI=intadd_164/n2
Xintadd_165/U2 FA1S $PINS S=intadd_165/SUM[2] CO=intadd_165/n1
+ A=intadd_156/SUM[1] B=intadd_164/SUM[1] CI=intadd_165/n2
Xintadd_143/U6 FA1 $PINS S=N94 CO=intadd_143/n5 A=intadd_143/B[18] B=s1_P3[9]
+ CI=intadd_143/n6
Xintadd_143/U8 FA1 $PINS S=N92 CO=intadd_143/n7 A=intadd_143/B[16]
+ B=intadd_143/A[16] CI=intadd_143/n8
Xintadd_143/U17 FA1 $PINS S=N83 CO=intadd_143/n16 A=intadd_143/B[7]
+ B=intadd_143/A[7] CI=intadd_143/n17
Xintadd_143/U11 FA1 $PINS S=N89 CO=intadd_143/n10 A=intadd_143/B[13]
+ B=intadd_143/A[13] CI=intadd_143/n11
Xintadd_143/U13 FA1 $PINS S=N87 CO=intadd_143/n12 A=intadd_143/B[11]
+ B=intadd_143/A[11] CI=intadd_143/n13
Xintadd_143/U15 FA1 $PINS S=N85 CO=intadd_143/n14 A=intadd_143/B[9]
+ B=intadd_143/A[9] CI=intadd_143/n15
Xintadd_143/U19 FA1 $PINS S=N81 CO=intadd_143/n18 A=intadd_143/B[5]
+ B=intadd_143/A[5] CI=intadd_143/n19
Xintadd_143/U21 FA1S $PINS S=N79 CO=intadd_143/n20 A=intadd_143/B[3]
+ B=intadd_143/A[3] CI=intadd_143/n21
Xintadd_143/U22 FA1S $PINS S=N78 CO=intadd_143/n21 A=intadd_143/B[2]
+ B=intadd_143/A[2] CI=intadd_143/n22
Xintadd_147/U3 FA1 $PINS S=N13 CO=intadd_147/n2 A=intadd_148/n1
+ B=intadd_157/SUM[2] CI=intadd_147/n3
Xintadd_145/U5 FA1 $PINS S=N29 CO=intadd_145/n4 A=intadd_152/n1
+ B=intadd_145/A[9] CI=intadd_145/n5
Xintadd_147/U4 FA1 $PINS S=N12 CO=intadd_147/n3 A=intadd_149/n1
+ B=intadd_148/SUM[3] CI=intadd_147/n4
Xintadd_145/U6 FA1 $PINS S=N28 CO=intadd_145/n5 A=intadd_153/n1
+ B=intadd_145/A[8] CI=intadd_145/n6
Xintadd_147/U5 FA1 $PINS S=N11 CO=intadd_147/n4 A=intadd_150/n1
+ B=intadd_149/SUM[3] CI=intadd_147/n5
Xintadd_145/U7 FA1 $PINS S=N27 CO=intadd_145/n6 A=intadd_161/n1
+ B=intadd_145/A[7] CI=intadd_145/n7
Xintadd_147/U7 FA1 $PINS S=N9 CO=intadd_147/n6 A=intadd_159/n1
+ B=intadd_158/SUM[2] CI=intadd_147/n7
Xintadd_147/U6 FA1 $PINS S=N10 CO=intadd_147/n5 A=intadd_158/n1
+ B=intadd_150/SUM[3] CI=intadd_147/n6
Xintadd_147/U8 FA1 $PINS S=N8 CO=intadd_147/n7 A=intadd_147/B[5]
+ B=intadd_159/SUM[2] CI=intadd_147/n8
Xintadd_147/U2 FA1 $PINS S=N14 CO=intadd_147/n1 A=intadd_157/n1
+ B=intadd_147/A[11] CI=intadd_147/n2
Xintadd_143/U5 FA1 $PINS S=N95 CO=intadd_143/n4 A=intadd_143/B[19] B=s1_P3[10]
+ CI=intadd_143/n5
Xintadd_143/U7 FA1 $PINS S=N93 CO=intadd_143/n6 A=intadd_143/B[17]
+ B=intadd_143/A[17] CI=intadd_143/n7
Xintadd_145/U10 FA1 $PINS S=N24 CO=intadd_145/n9 A=intadd_145/B[4]
+ B=intadd_145/A[4] CI=intadd_145/n10
Xintadd_143/U12 FA1 $PINS S=N88 CO=intadd_143/n11 A=intadd_143/B[12]
+ B=intadd_143/A[12] CI=intadd_143/n12
Xintadd_145/U2 FA1 $PINS S=N32 CO=intadd_145/n1 A=intadd_145/B[12]
+ B=intadd_145/A[12] CI=intadd_145/n2
Xintadd_145/U12 FA1 $PINS S=N22 CO=intadd_145/n11 A=intadd_145/B[2]
+ B=intadd_145/A[2] CI=intadd_145/n12
XR_119 QDFFRBN $PINS Q=intadd_143/A[7] D=n37 CK=clk_clone2
+ RB=FE_OFN21_i_reset_n_i
Xintadd_143/U20 FA1 $PINS S=N80 CO=intadd_143/n19 A=intadd_143/B[4]
+ B=intadd_143/A[4] CI=intadd_143/n20
Xintadd_143/U18 FA1 $PINS S=N82 CO=intadd_143/n17 A=intadd_143/B[6]
+ B=intadd_143/A[6] CI=intadd_143/n18
Xintadd_143/U16 FA1 $PINS S=N84 CO=intadd_143/n15 A=intadd_143/B[8]
+ B=intadd_143/A[8] CI=intadd_143/n16
Xintadd_143/U14 FA1 $PINS S=N86 CO=intadd_143/n13 A=intadd_143/B[10]
+ B=intadd_143/A[10] CI=intadd_143/n14
Xintadd_147/U12 FA1 $PINS S=N4 CO=intadd_147/n11 A=intadd_147/B[1]
+ B=intadd_147/A[1] CI=intadd_147/n12
Xintadd_144/U12 FA1S $PINS S=N39 CO=intadd_144/n11 A=intadd_144/B[2]
+ B=intadd_144/A[2] CI=intadd_144/n12
Xintadd_147/U10 FA1 $PINS S=N6 CO=intadd_147/n9 A=intadd_147/B[3]
+ B=intadd_147/A[3] CI=intadd_147/n10
Xintadd_143/U2 FA1 $PINS S=N98 CO=intadd_143/n1 A=s1_P3[13] B=intadd_143/A[22]
+ CI=intadd_143/n2
Xintadd_145/U8 FA1 $PINS S=N26 CO=intadd_145/n7 A=intadd_162/n1
+ B=intadd_145/A[6] CI=intadd_145/n8
XU3 MOAI1 $PINS O=N15 A1=n114 A2=n113 B1=n114 B2=n113
XU21 NR2P $PINS O=n455 I1=FE_DBTN89_n359 I2=n346
XU42 MOAI1 $PINS O=n440 A1=n428 A2=n427 B1=n428 B2=n427
XU43 MOAI1S $PINS O=n104 A1=n244 A2=n102 B1=n244 B2=n102
XU47 MOAI1S $PINS O=n91 A1=n301 A2=n89 B1=n301 B2=n89
XU50 ND3 $PINS O=n242 I1=FE_OFN1595_Ix2_shift_8 I2=FE_OFN1497_FE_DBTN29_n4484
+ I3=n103
XU51 ND2S $PINS O=n227 I1=A[13] I2=FE_OFN4211_FE_OFN876_IyIt_shift_0
XU52 ND2S $PINS O=n240 I1=FE_OFN1504_FE_DBTN20_Ix2_shift_12
+ I2=FE_OFN4211_FE_OFN876_IyIt_shift_0
XU53 ND2S $PINS O=n136 I1=FE_OFN833_Ix2_shift_0 I2=FE_OFN1497_FE_DBTN29_n4484
XU54 ND2S $PINS O=n100 I1=FE_OFN1595_Ix2_shift_8 I2=FE_OFN1497_FE_DBTN29_n4484
XU55 ND2S $PINS O=n144 I1=FE_OFN833_Ix2_shift_0 I2=n208
XU56 ND2S $PINS O=n125 I1=B[14] I2=A[0]
XU57 ND2S $PINS O=n93 I1=B[12] I2=n158
XU58 FA1S $PINS S=n507 CO=n508 A=N57 B=N31 CI=N48
XU59 MOAI1S $PINS O=N99 A1=intadd_143/A[22] A2=n108 B1=intadd_143/A[22] B2=n108
XU60 ND2S $PINS O=n386 I1=n395 I2=n394
XU61 FA1S $PINS S=n252 CO=n247 A=n251 B=n250 CI=n249
XU62 ND2S $PINS O=n423 I1=n428 I2=n427
XU63 MOAI1S $PINS O=n371 A1=n359 A2=n347 B1=FE_OFN4269_n455 B2=n339
XU64 ND2S $PINS O=intadd_160/A[1] I1=FE_OFN1189_FE_DBTN21_Ix2_shift_15 I2=B[4]
XU65 ND2S $PINS O=intadd_145/A[12] I1=FE_OFN1587_Ix2_shift_15 I2=IyIt_shift_7
XU66 ND3 $PINS O=n306 I1=FE_OFN1715_IyIt_shift_10 I2=FE_OFN829_Ix2_shift_1
+ I3=n305
XU67 NR2 $PINS O=intadd_164/B[0] I1=n93 I2=n92
XU68 NR2 $PINS O=intadd_156/A[1] I1=n126 I2=n125
XU69 ND2S $PINS O=n413 I1=B[8] I2=n468
XU71 ND3 $PINS O=n249 I1=FE_OFN1624_Ix2_shift_10 I2=FE_OFN139_IyIt_shift_1
+ I3=n245
XU72 ND2S $PINS O=n126 I1=FE_OCPN4_IyIt_shift_13 I2=FE_OFN829_Ix2_shift_1
XU74 ND2S $PINS O=n460 I1=FE_OFN1565_IyIt_shift_8 I2=n442
XU76 ND2S $PINS O=n314 I1=FE_OCPN4_IyIt_shift_13 I2=FE_OFN1281_Ix2_shift_7
XU77 ND2S $PINS O=n133 I1=FE_RN_2 I2=FE_OFN185_n4484
XU78 ND2S $PINS O=n184 I1=FE_OFN1497_FE_DBTN29_n4484 I2=FE_OFN1686_Ix2_shift_1
XU79 ND2S $PINS O=n128 I1=B[9] I2=A[7]
XU80 ND2S $PINS O=n224 I1=Ix2_shift_12 I2=FE_OFN239_IyIt_shift_3
XU81 ND2S $PINS O=n193 I1=A[3] I2=FE_RN_6
XU82 ND2S $PINS O=n181 I1=FE_RN_6 I2=FE_OFN1492_FE_DBTN31_Ix2_shift_4
XU83 ND3 $PINS O=n189 I1=A[3] I2=FE_RN_6 I3=n194
XU84 ND2S $PINS O=n457 I1=FE_OFN4311_n I2=FE_OFN1482_FE_DBTN89_n359
XU85 ND2S $PINS O=n139 I1=FE_OFN201_Ix2_shift_7 I2=FE_RN_6
XU86 ND2S $PINS O=n141 I1=B[1] I2=FE_OFN201_Ix2_shift_7
XU87 ND2S $PINS O=n142 I1=FE_OFN1497_FE_DBTN29_n4484 I2=FE_DBTN144_Ix2_shift_6
XU88 ND2S $PINS O=n320 I1=FE_OFN154_IyIt_shift_14 I2=FE_OFN1281_Ix2_shift_7
XU89 ND2S $PINS O=intadd_144/A[12] I1=FE_OFN1186_FE_DBTN22_IyIt_shift_15
+ I2=FE_OFN1281_Ix2_shift_7
XU90 ND3 $PINS O=n478 I1=n111 I2=FE_OFN4296_n
+ I3=FE_OFN4235_FE_DBTN97_IyIt_shift_8
XU91 ND2S $PINS O=n171 I1=FE_OFN141_IyIt_shift_0 I2=A[5]
XU93 ND2S $PINS O=n132 I1=A[13] I2=FE_OFN139_IyIt_shift_1
XU94 ND2S $PINS O=n137 I1=FE_DBTN144_Ix2_shift_6 I2=FE_RN_6
XU95 ND2S $PINS O=n131 I1=FE_RN_2 I2=FE_OFN4211_FE_OFN876_IyIt_shift_0
XU96 ND2S $PINS O=n114 I1=FE_OFN1281_Ix2_shift_7 I2=FE_OFN1757_IyIt_shift_7
XU97 ND2S $PINS O=n205 I1=Ix2_shift_12 I2=B[5]
XU98 ND2S $PINS O=n257 I1=FE_OFN4199_FE_OFN1580_Ix2_shift_13
+ I2=FE_OFN1757_IyIt_shift_7
XU99 ND2S $PINS O=n220 I1=Ix2_shift_12 I2=B[4]
XU100 ND2S $PINS O=n145 I1=FE_OFN1686_Ix2_shift_1
+ I2=FE_OFN4211_FE_OFN876_IyIt_shift_0
XU102 ND2S $PINS O=n138 I1=B[1] I2=A[5]
XU103 ND2S $PINS O=n102 I1=FE_OFN1595_Ix2_shift_8 I2=FE_OFN239_IyIt_shift_3
XU104 ND2S $PINS O=n172 I1=B[1] I2=FE_OFN1492_FE_DBTN31_Ix2_shift_4
XU106 ND2S $PINS O=n111 I1=FE_OFN171_IyIt_shift_9 I2=FE_OFN1517_n421
XU107 ND2S $PINS O=n182 I1=B[1] I2=A[3]
XU110 ND2S $PINS O=n135 I1=FE_OFN1686_Ix2_shift_1 I2=FE_OFN1697_IyIt_shift_1
XU111 ND2S $PINS O=n101 I1=FE_OFN1624_Ix2_shift_10 I2=FE_OFN139_IyIt_shift_1
XU112 ND2S $PINS O=n203 I1=FE_OFN267_FE_OFN1554_n3259 I2=B[6]
XU113 ND2S $PINS O=n271 I1=FE_OFN235_IyIt_shift_11 I2=A[6]
XU114 ND2S $PINS O=n273 I1=FE_OFN169_IyIt_shift_12 I2=A[5]
XU115 ND2S $PINS O=n222 I1=FE_OFN267_FE_OFN1554_n3259 I2=B[4]
XU116 ND2S $PINS O=n215 I1=FE_OFN1189_FE_DBTN21_Ix2_shift_15
+ I2=FE_OFN1719_IyIt_shift_3
XU117 ND2S $PINS O=n298 I1=FE_OFN235_IyIt_shift_11 I2=n158
XU119 ND2S $PINS O=n284 I1=FE_OFN1186_FE_DBTN22_IyIt_shift_15 I2=Ix2_shift_3
XU120 ND2S $PINS O=n291 I1=FE_OFN235_IyIt_shift_11
+ I2=FE_OFN1492_FE_DBTN31_Ix2_shift_4
XU121 ND2S $PINS O=n293 I1=B[12] I2=Ix2_shift_3
XU122 ND2S $PINS O=n288 I1=B[12] I2=A[4]
XU124 ND2S $PINS O=n88 I1=B[9] I2=FE_OFN829_Ix2_shift_1
XU125 ND2S $PINS O=n123 I1=FE_OFN250_IyIt_shift_8 I2=FE_OFN1686_Ix2_shift_1
XU126 ND2S $PINS O=n89 I1=FE_OFN250_IyIt_shift_8 I2=Ix2_shift_3
XU128 ND2S $PINS O=intadd_163/A[1] I1=FE_OFN1186_FE_DBTN22_IyIt_shift_15
+ I2=A[4]
XU129 ND2S $PINS O=n304 I1=FE_OFN1715_IyIt_shift_10 I2=FE_OFN829_Ix2_shift_1
XU130 ND2S $PINS O=n134 I1=FE_OFN194_Ix2_shift_9 I2=FE_OFN1757_IyIt_shift_7
XU132 ND2S $PINS O=n262 I1=FE_OFN1183_FE_DBTN26_Ix2_shift_14
+ I2=FE_OFN1757_IyIt_shift_7
XU134 ND2S $PINS O=n127 I1=FE_OFN154_IyIt_shift_14 I2=FE_DBTN140_Ix2_shift_2
XU140 ND2S $PINS O=n313 I1=FE_OFN154_IyIt_shift_14 I2=A[6]
XU145 ND2S $PINS O=n256 I1=FE_OFN1183_FE_DBTN26_Ix2_shift_14 I2=B[6]
XU147 ND2S $PINS O=n140 I1=B[1] I2=FE_DBTN144_Ix2_shift_6
XU157 FA1S $PINS S=N77 CO=intadd_143/n22 A=intadd_143/B[1] B=s1_P1[1]
+ CI=intadd_143/n23
XU158 ND2S $PINS O=intadd_143/A[16] I1=n115 I2=n116
XU159 ND2S $PINS O=intadd_143/B[17] I1=n118 I2=n117
XU160 ND2S $PINS O=n109 I1=n117 I2=n116
XU161 ND2S $PINS O=n115 I1=s1_P3[7] I2=n117
XU162 ND2S $PINS O=n116 I1=s1_P1[15] I2=s1_P2[15]
XU163 FA1 $PINS S=n36 CO=n37 A=N41 B=N24 CI=N15
XU170 MOAI1S $PINS O=n468 A1=FE_OFN1183_FE_DBTN26_Ix2_shift_14
+ A2=FE_OFN960_Ix2_shift_13 B1=FE_OFN1183_FE_DBTN26_Ix2_shift_14
+ B2=FE_OFN960_Ix2_shift_13
XU173 INV1S $PINS O=n316 I=FE_OFN201_Ix2_shift_7
XU176 INV1S $PINS O=n348 I=FE_OFN169_IyIt_shift_12
XU213 NR2 $PINS O=n292 I1=IyIt_shift_15 I2=FE_OFN883_FE_DBTN139_Ix2_shift_0
XU215 NR2 $PINS O=intadd_150/B[0] I1=FE_OFN883_FE_DBTN139_Ix2_shift_0
+ I2=FE_OFN294_FE_DBTN95_IyIt_shift_6
XU216 NR2 $PINS O=n167 I1=n140 I2=n139
XU219 FA1S $PINS S=n309 CO=n302 A=n308 B=n307 CI=n306
XU221 NR2 $PINS O=n85 I1=n112 I2=intadd_147/n1
XU223 MOAI1 $PINS O=n108 A1=s1_P3[15] A2=intadd_143/n1 B1=s1_P3[15]
+ B2=intadd_143/n1
XU224 FA1 $PINS S=n495 CO=n496 A=N42 B=N25 CI=n86
XU225 FA1 $PINS S=n509 CO=n510 A=N58 B=N32 CI=N49
XU226 NR2 $PINS O=n151 I1=FE_OFN1630_Ix2_shift_6 I2=FE_DBTN95_IyIt_shift_6
XU227 NR2 $PINS O=n150 I1=FE_OFN172_IyIt_shift_7 I2=FE_DBTN142_Ix2_shift_5
XU229 NR2 $PINS O=n149 I1=n316 I2=FE_OFN1176_FE_DBTN93_IyIt_shift_5
XU230 NR2 $PINS O=n147 I1=FE_OFN172_IyIt_shift_7 I2=FE_OFN1630_Ix2_shift_6
XU231 NR2 $PINS O=n146 I1=n316 I2=FE_DBTN95_IyIt_shift_6
XU232 NR2 $PINS O=n86 I1=n85 I2=n114
XU233 NR2 $PINS O=intadd_149/B[0] I1=FE_OFN883_FE_DBTN139_Ix2_shift_0
+ I2=FE_OFN1753_IyIt_shift_7
XU234 INV1S $PINS O=n279 I=FE_OFN167_IyIt_shift_13
XU235 NR2 $PINS O=n87 I1=n279 I2=FE_OFN1434_FE_DBTN140_Ix2_shift_2
XU236 AOI22S $PINS O=n286 A1=FE_RN_4 A2=FE_OFN1281_Ix2_shift_7
+ B1=FE_OCPN4_IyIt_shift_13 B2=FE_DBTN140_Ix2_shift_2
XU237 AO13S $PINS O=intadd_156/B[1] A1=n286 B1=FE_OFN1281_Ix2_shift_7
+ B2=FE_RN_4 B3=n87
XU238 NR2 $PINS O=n90 I1=FE_DBTN97_IyIt_shift_8
+ I2=FE_OFN1432_FE_DBTN140_Ix2_shift_2
XU240 MOAI1S $PINS O=intadd_144/A[0] A1=n90 A2=n88 B1=n90 B2=n88
XU241 NR2 $PINS O=n301 I1=FE_OFN1172_FE_DBTN99_IyIt_shift_9
+ I2=FE_OFN1434_FE_DBTN140_Ix2_shift_2
XU242 ND3 $PINS O=n299 I1=B[9] I2=FE_OFN829_Ix2_shift_1 I3=n90
XU243 MOAI1 $PINS O=intadd_144/B[1] A1=n91 A2=n299 B1=n91 B2=n299
XU244 NR2 $PINS O=intadd_154/A[1] I1=n128 I2=n127
XU246 NR2 $PINS O=intadd_144/B[0] I1=n124 I2=n123
XU247 OR2 $PINS O=n117 I1=s1_P1[15] I2=s1_P2[15]
XU248 MOAI1S $PINS O=intadd_143/B[15] A1=s1_P3[7] A2=n109 B1=s1_P3[7] B2=n109
XU250 ND2 $PINS O=n92 I1=B[13] I2=FE_OFN833_Ix2_shift_0
XU251 NR2 $PINS O=n312 I1=FE_DBTN97_IyIt_shift_8 I2=FE_OFN1285_Ix2_shift_4
XU252 NR2 $PINS O=n311 I1=FE_OFN1172_FE_DBTN99_IyIt_shift_9
+ I2=FE_OFN1289_Ix2_shift_3
XU253 NR2 $PINS O=n310 I1=FE_OFN1717_IyIt_shift_10
+ I2=FE_OFN1434_FE_DBTN140_Ix2_shift_2
XU254 OAI22S $PINS O=n98 A1=n93 A2=intadd_164/B[0] B1=n92 B2=intadd_164/B[0]
XU255 ND2 $PINS O=n297 I1=B[12] I2=A[0]
XU256 NR2 $PINS O=n97 I1=n298 I2=n297
XU257 NR2 $PINS O=n96 I1=FE_OFN1172_FE_DBTN99_IyIt_shift_9
+ I2=FE_OFN1285_Ix2_shift_4
XU258 FA1S $PINS S=intadd_144/A[3] CO=intadd_144/B[4] A=n95 B=n94
+ CI=intadd_165/SUM[0]
XU259 FA1S $PINS S=n94 CO=n99 A=n98 B=n97 CI=n96
XU260 FA1S $PINS S=intadd_144/A[4] CO=intadd_144/B[5] A=n99 B=intadd_165/SUM[1]
+ CI=intadd_164/SUM[0]
XU262 NR2 $PINS O=n103 I1=FE_OFN4328_n I2=FE_OFN1699_IyIt_shift_1
XU265 MOAI1S $PINS O=intadd_145/A[0] A1=n103 A2=n100 B1=n103 B2=n100
XU267 INV1S $PINS O=n192 I=FE_OFN4211_FE_OFN876_IyIt_shift_0
XU268 NR2 $PINS O=n245 I1=FE_OFN4363_n I2=n192
XU270 MOAI1S $PINS O=intadd_145/A[1] A1=n245 A2=n101 B1=n245 B2=n101
XU271 NR2 $PINS O=n244 I1=FE_OFN4328_n I2=FE_OFN184_n4484
XU272 MOAI1S $PINS O=intadd_145/B[1] A1=n104 A2=n242 B1=n104 B2=n242
XU284 NR2 $PINS O=n186 I1=n136 I2=n135
XU286 MOAI1S $PINS O=n107 A1=n184 A2=n183 B1=n184 B2=n183
XU287 MOAI1S $PINS O=intadd_147/A[1] A1=n186 A2=n107 B1=n186 B2=n107
XU288 INV1S $PINS O=intadd_143/A[22] I=s1_P3[14]
XU289 MOAI1S $PINS O=intadd_143/B[16] A1=s1_P3[8] A2=n109 B1=s1_P3[8] B2=n109
XU292 MOAI1S $PINS O=n110 A1=FE_OFN1715_IyIt_shift_10 A2=FE_OFN4330_n
+ B1=FE_OFN1715_IyIt_shift_10 B2=FE_OFN4330_n
XU293 NR2 $PINS O=n447 I1=FE_OFN1276_Ix2_shift_8 I2=FE_OFN4329_n
XU294 AOI22S $PINS O=n482 A1=FE_OFN1276_Ix2_shift_8 A2=n110 B1=n447
+ B2=FE_DBTN99_IyIt_shift_9
XU296 MOAI1S $PINS O=n359 A1=FE_OFN1268_Ix2_shift_9 A2=FE_DBTN148_Ix2_shift_10
+ B1=FE_OFN1268_Ix2_shift_9 B2=FE_DBTN148_Ix2_shift_10
XU297 OA12 $PINS O=n483 A1=n478 B1=FE_OFN4235_FE_DBTN97_IyIt_shift_8 B2=n359
XU298 NR2 $PINS O=intadd_146/B[0] I1=n482 I2=n483
XU300 ND2 $PINS O=n130 I1=FE_OFN1263_Ix2_shift_9
+ I2=FE_OFN4211_FE_OFN876_IyIt_shift_0
XU302 ND2 $PINS O=n129 I1=FE_OFN1595_Ix2_shift_8 I2=FE_OFN1698_IyIt_shift_1
XU303 NR2 $PINS O=intadd_145/B[0] I1=n130 I2=n129
XU304 MAOI1 $PINS O=n113 A1=n112 A2=intadd_147/n1 B1=n112 B2=intadd_147/n1
XU305 AN2 $PINS O=intadd_143/A[2] I1=s1_P0[9] I2=s1_P2[1]
XU306 ND2S $PINS O=n118 I1=s1_P3[8] I2=n116
XU308 MOAI1S $PINS O=n119 A1=FE_OFN262_IyIt_shift_11 A2=FE_OFN4329_n
+ B1=FE_OFN262_IyIt_shift_11 B2=FE_OFN4329_n
XU309 AOI22S $PINS O=n121 A1=FE_OFN1276_Ix2_shift_8 A2=n119 B1=n447
+ B2=FE_OFN1376_IyIt_shift_10
XU310 MOAI1S $PINS O=n450 A1=FE_OFN4312_n A2=FE_DBTN99_IyIt_shift_9
+ B1=FE_OFN4312_n B2=FE_DBTN99_IyIt_shift_9
XU311 MOAI1S $PINS O=n346 A1=FE_DBTN148_Ix2_shift_10 A2=FE_OFN1237_n3259
+ B1=FE_DBTN148_Ix2_shift_10 B2=FE_OFN1237_n3259
XU312 MOAI1S $PINS O=n120 A1=FE_OFN4312_n A2=FE_OFN4235_FE_DBTN97_IyIt_shift_8
+ B1=FE_OFN4312_n B2=FE_OFN4235_FE_DBTN97_IyIt_shift_8
XU313 AOI22S $PINS O=n122 A1=FE_OFN1482_FE_DBTN89_n359 A2=n450 B1=n455 B2=n120
XU314 NR2 $PINS O=intadd_146/A[1] I1=n121 I2=n122
XU315 OAI22S $PINS O=intadd_146/A[0] A1=n122 A2=intadd_146/A[1] B1=n121
+ B2=intadd_146/A[1]
XU316 OAI22S $PINS O=N36 A1=n124 A2=intadd_144/B[0] B1=n123 B2=intadd_144/B[0]
XU317 OAI22S $PINS O=intadd_165/A[1] A1=n126 A2=intadd_156/A[1] B1=n125
+ B2=intadd_156/A[1]
XU318 OAI22S $PINS O=intadd_155/A[1] A1=n128 A2=intadd_154/A[1] B1=n127
+ B2=intadd_154/A[1]
XU319 OAI22S $PINS O=N19 A1=n130 A2=intadd_145/B[0] B1=n129 B2=intadd_145/B[0]
XU320 ND2 $PINS O=n228 I1=FE_OFN1504_FE_DBTN20_Ix2_shift_12
+ I2=FE_OFN139_IyIt_shift_1
XU321 NR2 $PINS O=intadd_161/B[0] I1=n228 I2=n227
XU322 NR2 $PINS O=intadd_153/A[1] I1=n132 I2=n131
XU323 OAI22S $PINS O=intadd_162/A[1] A1=n132 A2=intadd_153/A[1] B1=n131
+ B2=intadd_153/A[1]
XU324 NR2 $PINS O=intadd_151/A[1] I1=n134 I2=n133
XU325 OAI22S $PINS O=intadd_152/A[1] A1=n134 A2=intadd_151/A[1] B1=n133
+ B2=intadd_151/A[1]
XU326 OAI22S $PINS O=intadd_147/A[0] A1=n136 A2=n186 B1=n135 B2=n186
XU327 NR2 $PINS O=intadd_158/A[0] I1=n172 I2=n171
XU328 NR2 $PINS O=intadd_150/B[1] I1=n138 I2=n137
XU329 OAI22S $PINS O=intadd_159/B[1] A1=n138 A2=intadd_150/B[1] B1=n137
+ B2=intadd_150/B[1]
XU330 OAI22S $PINS O=intadd_150/A[1] A1=n140 A2=n167 B1=n139 B2=n167
XU331 NR2 $PINS O=intadd_148/B[1] I1=n142 I2=n141
XU332 OAI22S $PINS O=intadd_149/A[1] A1=n142 A2=intadd_148/B[1] B1=n141
+ B2=intadd_148/B[1]
XU333 NR2 $PINS O=N1 I1=n192 I2=FE_DBTN139_Ix2_shift_0
XU334 NR2 $PINS O=intadd_147/CI I1=n145 I2=n144
XU335 AOI12HS $PINS O=N2 A1=intadd_147/CI B1=n145 B2=n144
XU336 FA1S $PINS S=intadd_147/A[11] CO=n112 A=n148 B=n147 CI=n146
XU337 FA1S $PINS S=intadd_157/A[2] CO=n148 A=n151 B=n150 CI=n149
XU338 NR2 $PINS O=n154 I1=FE_OFN1630_Ix2_shift_6
+ I2=FE_OFN1176_FE_DBTN93_IyIt_shift_5
XU339 NR2 $PINS O=n153 I1=FE_OFN1756_IyIt_shift_7 I2=FE_OFN1286_Ix2_shift_4
XU340 NR2 $PINS O=n152 I1=n316 I2=FE_OFN187_n4488
XU341 FA1S $PINS S=intadd_157/A[1] CO=intadd_157/B[2] A=n154 B=n153 CI=n152
XU342 NR2 $PINS O=intadd_157/B[1] I1=FE_DBTN142_Ix2_shift_5
+ I2=FE_OFN294_FE_DBTN95_IyIt_shift_6
XU343 NR2 $PINS O=intadd_157/A[0] I1=FE_OFN1630_Ix2_shift_6 I2=FE_OFN187_n4488
XU344 NR2 $PINS O=intadd_157/B[0] I1=FE_OFN1290_Ix2_shift_3
+ I2=FE_OFN1755_IyIt_shift_7
XU345 NR2 $PINS O=intadd_157/CI I1=FE_OFN1480_FE_DBTN91_IyIt_shift_3 I2=n316
XU346 NR2 $PINS O=intadd_148/A[0] I1=FE_OFN1684_Ix2_shift_1
+ I2=FE_OFN1193_FE_DBTN14_IyIt_shift_7
XU347 NR2 $PINS O=intadd_148/B[0] I1=FE_OFN1286_Ix2_shift_4 I2=n4488
XU348 NR2 $PINS O=intadd_148/CI I1=FE_OFN1479_FE_DBTN91_IyIt_shift_3
+ I2=FE_DBTN142_Ix2_shift_5
XU349 NR2 $PINS O=n157 I1=FE_OFN1286_Ix2_shift_4
+ I2=FE_OFN1654_FE_DBTN93_IyIt_shift_5
XU350 NR2 $PINS O=n156 I1=FE_OFN1290_Ix2_shift_3
+ I2=FE_OFN294_FE_DBTN95_IyIt_shift_6
XU351 NR2 $PINS O=n155 I1=FE_DBTN142_Ix2_shift_5 I2=FE_OFN187_n4488
XU352 FA1S $PINS S=intadd_149/A[2] CO=intadd_148/B[2] A=n157 B=n156 CI=n155
XU353 NR2 $PINS O=intadd_149/A[0] I1=FE_OFN1684_Ix2_shift_1
+ I2=FE_OFN294_FE_DBTN95_IyIt_shift_6
XU354 NR2 $PINS O=intadd_149/CI I1=n4484 I2=FE_DBTN142_Ix2_shift_5
XU355 NR2 $PINS O=n161 I1=FE_OFN1480_FE_DBTN91_IyIt_shift_3
+ I2=FE_OFN1630_Ix2_shift_6
XU356 NR2 $PINS O=n160 I1=FE_OFN1432_FE_DBTN140_Ix2_shift_2
+ I2=FE_OFN1754_IyIt_shift_7
XU357 NR2 $PINS O=n159 I1=n4484 I2=n316
XU358 FA1S $PINS S=intadd_149/B[2] CO=n164 A=n161 B=n160 CI=n159
XU359 NR2 $PINS O=n163 I1=FE_OFN1286_Ix2_shift_4
+ I2=FE_OFN294_FE_DBTN95_IyIt_shift_6
XU360 NR2 $PINS O=n162 I1=FE_DBTN142_Ix2_shift_5
+ I2=FE_OFN1654_FE_DBTN93_IyIt_shift_5
XU361 FA1S $PINS S=intadd_149/B[3] CO=intadd_148/B[3] A=n164 B=n163 CI=n162
XU362 NR2 $PINS O=n166 I1=FE_OFN1433_FE_DBTN140_Ix2_shift_2
+ I2=FE_OFN294_FE_DBTN95_IyIt_shift_6
XU363 NR2 $PINS O=n165 I1=FE_OFN1290_Ix2_shift_3
+ I2=FE_OFN1654_FE_DBTN93_IyIt_shift_5
XU364 FA1S $PINS S=intadd_150/A[2] CO=intadd_148/A[1] A=n167 B=n166 CI=n165
XU365 NR2 $PINS O=intadd_150/A[0] I1=FE_OFN1684_Ix2_shift_1
+ I2=FE_OFN1176_FE_DBTN93_IyIt_shift_5
XU366 NR2 $PINS O=intadd_150/CI I1=n4484 I2=FE_OFN1286_Ix2_shift_4
XU367 NR2 $PINS O=n170 I1=FE_OFN1433_FE_DBTN140_Ix2_shift_2
+ I2=FE_OFN1176_FE_DBTN93_IyIt_shift_5
XU368 NR2 $PINS O=n169 I1=FE_OFN1479_FE_DBTN91_IyIt_shift_3
+ I2=FE_OFN1286_Ix2_shift_4
XU369 NR2 $PINS O=n168 I1=FE_OFN1290_Ix2_shift_3 I2=n4488
XU370 FA1S $PINS S=intadd_158/A[1] CO=intadd_149/B[1] A=n170 B=n169 CI=n168
XU371 NR2 $PINS O=intadd_158/B[0] I1=FE_OFN1433_FE_DBTN140_Ix2_shift_2 I2=n4488
XU372 NR2 $PINS O=intadd_158/CI I1=FE_OFN1479_FE_DBTN91_IyIt_shift_3
+ I2=FE_OFN1290_Ix2_shift_3
XU373 NR2 $PINS O=intadd_159/A[0] I1=FE_OFN1479_FE_DBTN91_IyIt_shift_3
+ I2=FE_OFN1433_FE_DBTN140_Ix2_shift_2
XU374 NR2 $PINS O=intadd_159/B[0] I1=FE_OFN883_FE_DBTN139_Ix2_shift_0
+ I2=FE_OFN1176_FE_DBTN93_IyIt_shift_5
XU375 NR2 $PINS O=intadd_159/CI I1=n4484 I2=FE_OFN1290_Ix2_shift_3
XU376 OAI22S $PINS O=n178 A1=n172 A2=intadd_158/A[0] B1=n171 B2=intadd_158/A[0]
XU377 NR2 $PINS O=n177 I1=FE_OFN1684_Ix2_shift_1 I2=n4488
XU378 NR2 $PINS O=n176 I1=n182 I2=n181
XU379 FA1S $PINS S=intadd_147/A[4] CO=intadd_147/B[5] A=intadd_159/SUM[1]
+ B=n175 CI=intadd_158/SUM[0]
XU380 FA1S $PINS S=n180 CO=n175 A=n178 B=n177 CI=n176
XU381 NR2 $PINS O=n197 I1=FE_OFN1684_Ix2_shift_1
+ I2=FE_OFN1479_FE_DBTN91_IyIt_shift_3
XU382 NR2 $PINS O=n196 I1=FE_OFN883_FE_DBTN139_Ix2_shift_0 I2=n4488
XU383 NR2 $PINS O=n195 I1=n4484 I2=FE_OFN1433_FE_DBTN140_Ix2_shift_2
XU384 FA1S $PINS S=intadd_147/A[3] CO=intadd_147/B[4] A=n180 B=n179
+ CI=intadd_159/SUM[0]
XU385 MOAI1S $PINS O=n190 A1=n182 A2=n181 B1=n182 B2=n181
XU386 NR2 $PINS O=n194 I1=FE_OFN1699_IyIt_shift_1
+ I2=FE_OFN1432_FE_DBTN140_Ix2_shift_2
XU387 NR2 $PINS O=n185 I1=n184 I2=n183
XU388 NR2 $PINS O=n188 I1=n186 I2=n185
XU389 INV1S $PINS O=intadd_147/B[3] I=n187
XU390 FA1S $PINS S=n191 CO=n187 A=n190 B=n189 CI=n188
XU391 INV1S $PINS O=intadd_147/A[2] I=n191
XU392 NR2 $PINS O=intadd_147/B[0] I1=FE_OFN1432_FE_DBTN140_Ix2_shift_2 I2=n192
XU393 MOAI1S $PINS O=intadd_147/B[1] A1=n194 A2=n193 B1=n194 B2=n193
XU394 FA1S $PINS S=intadd_147/B[2] CO=n179 A=n197 B=n196 CI=n195
XU395 NR2 $PINS O=n258 I1=FE_OFN1080_Ix2_shift_15
+ I2=FE_OFN1175_FE_DBTN93_IyIt_shift_5
XU396 INV1S $PINS O=intadd_160/A[2] I=n198
XU397 NR2 $PINS O=intadd_160/A[0] I1=FE_OFN4367_n I2=FE_OFN172_IyIt_shift_7
XU399 NR2 $PINS O=intadd_160/B[0] I1=FE_DBTN150_Ix2_shift_13
+ I2=FE_OFN1175_FE_DBTN93_IyIt_shift_5
XU401 NR2 $PINS O=intadd_160/CI I1=FE_OFN1087_Ix2_shift_14 I2=FE_OFN188_n4488
XU403 NR2 $PINS O=n201 I1=FE_RN_3 I2=FE_OFN172_IyIt_shift_7
XU404 NR2 $PINS O=n200 I1=FE_DBTN150_Ix2_shift_13
+ I2=FE_OFN295_FE_DBTN95_IyIt_shift_6
XU405 NR2 $PINS O=n199 I1=FE_OFN1087_Ix2_shift_14
+ I2=FE_OFN1175_FE_DBTN93_IyIt_shift_5
XU406 FA1S $PINS S=intadd_160/B[1] CO=intadd_160/B[2] A=n201 B=n200 CI=n199
XU407 NR2 $PINS O=n204 I1=FE_RN_5 I2=FE_RN_1
XU408 INV1S $PINS O=intadd_151/A[2] I=n202
XU409 NR2 $PINS O=intadd_151/A[0] I1=FE_DBTN150_Ix2_shift_13
+ I2=FE_DBTN91_IyIt_shift_3
XU410 NR2 $PINS O=intadd_151/B[0] I1=FE_OFN4367_n
+ I2=FE_OFN1175_FE_DBTN93_IyIt_shift_5
XU412 NR2 $PINS O=intadd_151/CI I1=FE_OFN1625_Ix2_shift_10
+ I2=FE_OFN295_FE_DBTN95_IyIt_shift_6
XU413 FA1S $PINS S=n206 CO=n202 A=n205 B=n204 CI=n203
XU414 INV1S $PINS O=intadd_152/A[2] I=n206
XU415 NR2 $PINS O=n219 I1=FE_RN_5 I2=FE_OFN1699_IyIt_shift_1
XU416 AOI22S $PINS O=n218 A1=A[8] A2=FE_OFN1757_IyIt_shift_7 B1=A[13]
+ B2=FE_OFN1497_FE_DBTN29_n4484
XU417 INV1S $PINS O=intadd_152/B[2] I=n207
XU418 NR2 $PINS O=intadd_152/A[0] I1=FE_OFN1266_Ix2_shift_9
+ I2=FE_DBTN95_IyIt_shift_6
XU419 NR2 $PINS O=intadd_152/B[0] I1=FE_OFN1625_Ix2_shift_10
+ I2=FE_DBTN93_IyIt_shift_5
XU420 NR2 $PINS O=intadd_152/CI I1=Ix2_shift_14 I2=FE_OFN1699_IyIt_shift_1
XU421 NR2 $PINS O=n223 I1=Ix2_shift_15 I2=n192
XU422 INV1S $PINS O=intadd_152/B[1] I=n209
XU423 NR2 $PINS O=n213 I1=FE_OFN1625_Ix2_shift_10 I2=FE_OFN172_IyIt_shift_7
XU424 NR2 $PINS O=n212 I1=FE_DBTN150_Ix2_shift_13 I2=FE_OFN188_n4488
XU425 NR2 $PINS O=n211 I1=FE_OFN1087_Ix2_shift_14 I2=FE_DBTN91_IyIt_shift_3
XU426 NR2 $PINS O=n216 I1=FE_RN_3 I2=FE_OFN295_FE_DBTN95_IyIt_shift_6
XU427 FA1S $PINS S=intadd_151/B[1] CO=n214 A=n213 B=n212 CI=n211
XU428 FA1S $PINS S=intadd_152/B[3] CO=intadd_151/B[3] A=n216 B=n215 CI=n214
XU429 NR2 $PINS O=n217 I1=FE_DBTN150_Ix2_shift_13 I2=FE_OFN184_n4484
XU430 AO13S $PINS O=intadd_153/B[1] A1=n218 B1=FE_OFN1757_IyIt_shift_7 B2=A[8]
+ B3=n217
XU431 NR2 $PINS O=intadd_153/A[0] I1=FE_OFN4265_n421 I2=FE_DBTN95_IyIt_shift_6
XU432 NR2 $PINS O=intadd_153/B[0] I1=FE_OFN1266_Ix2_shift_9
+ I2=FE_DBTN93_IyIt_shift_5
XU433 NR2 $PINS O=intadd_153/CI I1=FE_RN_3 I2=FE_OFN184_n4484
XU434 FA1S $PINS S=n221 CO=n207 A=n220 B=n219 CI=n218
XU435 INV1S $PINS O=intadd_153/A[2] I=n221
XU436 NR2 $PINS O=intadd_161/A[0] I1=FE_OFN1625_Ix2_shift_10 I2=FE_OFN188_n4488
XU437 NR2 $PINS O=intadd_161/CI I1=FE_OFN4367_n I2=FE_DBTN91_IyIt_shift_3
XU438 FA1S $PINS S=n225 CO=n209 A=n224 B=n223 CI=n222
XU439 INV1S $PINS O=intadd_161/A[1] I=n225
XU440 NR2 $PINS O=intadd_162/A[0] I1=FE_OFN4265_n421 I2=FE_DBTN93_IyIt_shift_5
XU441 NR2 $PINS O=intadd_162/B[0] I1=FE_OFN1625_Ix2_shift_10
+ I2=FE_OFN1480_FE_DBTN91_IyIt_shift_3
XU442 NR2 $PINS O=intadd_162/CI I1=FE_OFN4363_n I2=FE_OFN184_n4484
XU443 OAI22S $PINS O=n237 A1=n228 A2=intadd_161/B[0] B1=n227 B2=intadd_161/B[0]
XU445 NR2 $PINS O=n236 I1=n241 I2=n240
XU446 NR2 $PINS O=n235 I1=FE_OFN4329_n I2=FE_OFN187_n4488
XU447 FA1S $PINS S=intadd_145/A[4] CO=intadd_145/B[5] A=n230
+ B=intadd_162/SUM[1] CI=intadd_161/SUM[0]
XU448 NR2 $PINS O=n255 I1=FE_OFN4265_n421 I2=FE_OFN187_n4488
XU449 NR2 $PINS O=n254 I1=FE_OFN4329_n I2=FE_OFN1480_FE_DBTN91_IyIt_shift_3
XU450 NR2 $PINS O=n253 I1=FE_OFN1261_Ix2_shift_10 I2=FE_OFN184_n4484
XU451 FA1S $PINS S=n238 CO=n230 A=n237 B=n236 CI=n235
XU452 FA1S $PINS S=intadd_145/A[3] CO=intadd_145/B[4] A=n239 B=n238
+ CI=intadd_162/SUM[0]
XU453 MOAI1S $PINS O=n251 A1=n241 A2=n240 B1=n241 B2=n240
XU454 INV1S $PINS O=n243 I=n242
XU455 AOI13HS $PINS O=n250 A1=n243 B1=FE_OFN239_IyIt_shift_3
+ B2=FE_OFN1595_Ix2_shift_8 B3=n244
XU456 INV1S $PINS O=intadd_145/B[3] I=n247
XU457 NR2 $PINS O=intadd_145/CI I1=FE_OFN1261_Ix2_shift_10 I2=n192
XU458 INV1S $PINS O=intadd_145/A[2] I=n252
XU459 FA1S $PINS S=intadd_145/B[2] CO=n239 A=n255 B=n254 CI=n253
XU460 FA1S $PINS S=n198 CO=n263 A=n258 B=n257 CI=n256
XU461 NR2 $PINS O=n261 I1=FE_OFN1083_Ix2_shift_15
+ I2=FE_OFN295_FE_DBTN95_IyIt_shift_6
XU462 INV1S $PINS O=intadd_145/B[11] I=n260
XU463 FA1S $PINS S=n260 CO=n264 A=n263 B=n262 CI=n261
XU464 INV1S $PINS O=intadd_145/B[12] I=n264
XU465 NR2 $PINS O=N18 I1=FE_OFN4265_n421 I2=n192
XU466 INV1S $PINS O=N33 I=intadd_145/n1
XU467 NR2 $PINS O=n315 I1=IyIt_shift_15 I2=FE_OFN1428_FE_DBTN142_Ix2_shift_5
XU468 INV1S $PINS O=intadd_163/A[2] I=n266
XU469 NR2 $PINS O=intadd_163/A[0] I1=FE_OFN4127_IyIt_shift_11
+ I2=FE_OFN1516_n316
XU470 NR2 $PINS O=intadd_163/B[0] I1=n279 I2=FE_OFN1429_FE_DBTN142_Ix2_shift_5
XU471 NR2 $PINS O=intadd_163/CI I1=FE_OFN1022_FE_DBTN102_IyIt_shift_14
+ I2=FE_OFN1285_Ix2_shift_4
XU473 NR2 $PINS O=n269 I1=n348 I2=FE_OFN1516_n316
XU474 NR2 $PINS O=n268 I1=n279 I2=FE_OFN279_FE_DBTN144_Ix2_shift_6
XU475 NR2 $PINS O=n267 I1=FE_OFN1022_FE_DBTN102_IyIt_shift_14
+ I2=FE_OFN1429_FE_DBTN142_Ix2_shift_5
XU476 FA1S $PINS S=intadd_163/B[1] CO=intadd_163/B[2] A=n269 B=n268 CI=n267
XU477 NR2 $PINS O=n272 I1=IyIt_shift_15 I2=FE_OFN1434_FE_DBTN140_Ix2_shift_2
XU478 INV1S $PINS O=intadd_154/A[2] I=n270
XU479 NR2 $PINS O=intadd_154/A[0] I1=n279 I2=FE_OFN1289_Ix2_shift_3
XU480 NR2 $PINS O=intadd_154/B[0] I1=FE_OFN4127_IyIt_shift_11
+ I2=FE_OFN1429_FE_DBTN142_Ix2_shift_5
XU481 NR2 $PINS O=intadd_154/CI I1=FE_OFN1717_IyIt_shift_10
+ I2=FE_OFN279_FE_DBTN144_Ix2_shift_6
XU482 FA1S $PINS S=n274 CO=n270 A=n273 B=n272 CI=n271
XU483 INV1S $PINS O=intadd_155/A[2] I=n274
XU484 NR2 $PINS O=n287 I1=IyIt_shift_15 I2=FE_OFN827_Ix2_shift_1
XU485 INV1S $PINS O=intadd_155/B[2] I=n275
XU486 NR2 $PINS O=intadd_155/A[0] I1=FE_OFN1172_FE_DBTN99_IyIt_shift_9
+ I2=FE_OFN279_FE_DBTN144_Ix2_shift_6
XU487 NR2 $PINS O=intadd_155/B[0] I1=FE_OFN1717_IyIt_shift_10
+ I2=FE_OFN1428_FE_DBTN142_Ix2_shift_5
XU488 NR2 $PINS O=intadd_155/CI I1=FE_OFN1022_FE_DBTN102_IyIt_shift_14
+ I2=FE_OFN827_Ix2_shift_1
XU489 INV1S $PINS O=intadd_155/B[1] I=n277
XU490 NR2 $PINS O=n282 I1=FE_OFN1717_IyIt_shift_10 I2=FE_OFN1516_n316
XU491 NR2 $PINS O=n281 I1=n279 I2=FE_OFN1285_Ix2_shift_4
XU492 NR2 $PINS O=n280 I1=FE_OFN1022_FE_DBTN102_IyIt_shift_14
+ I2=FE_OFN1289_Ix2_shift_3
XU493 NR2 $PINS O=n285 I1=n348 I2=FE_OFN279_FE_DBTN144_Ix2_shift_6
XU494 FA1S $PINS S=intadd_154/B[1] CO=n283 A=n282 B=n281 CI=n280
XU495 FA1S $PINS S=intadd_155/B[3] CO=intadd_154/B[3] A=n285 B=n284 CI=n283
XU496 NR2 $PINS O=intadd_156/A[0] I1=FE_DBTN97_IyIt_shift_8
+ I2=FE_OFN279_FE_DBTN144_Ix2_shift_6
XU497 NR2 $PINS O=intadd_156/B[0] I1=FE_OFN1172_FE_DBTN99_IyIt_shift_9
+ I2=FE_OFN1428_FE_DBTN142_Ix2_shift_5
XU498 NR2 $PINS O=intadd_156/CI I1=n348 I2=FE_OFN1434_FE_DBTN140_Ix2_shift_2
XU499 FA1S $PINS S=n289 CO=n275 A=n288 B=n287 CI=n286
XU500 INV1S $PINS O=intadd_156/A[2] I=n289
XU501 NR2 $PINS O=intadd_164/A[0] I1=FE_OFN1717_IyIt_shift_10
+ I2=FE_OFN1285_Ix2_shift_4
XU502 NR2 $PINS O=intadd_164/CI I1=FE_OFN4127_IyIt_shift_11
+ I2=FE_OFN1289_Ix2_shift_3
XU503 FA1S $PINS S=n294 CO=n277 A=n293 B=n292 CI=n291
XU504 INV1S $PINS O=intadd_164/A[1] I=n294
XU505 NR2 $PINS O=intadd_165/A[0] I1=FE_DBTN97_IyIt_shift_8
+ I2=FE_OFN1428_FE_DBTN142_Ix2_shift_5
XU506 NR2 $PINS O=intadd_165/B[0] I1=FE_OFN1717_IyIt_shift_10
+ I2=FE_OFN1289_Ix2_shift_3
XU507 NR2 $PINS O=intadd_165/CI I1=FE_OFN4127_IyIt_shift_11
+ I2=FE_OFN1434_FE_DBTN140_Ix2_shift_2
XU508 MOAI1S $PINS O=n308 A1=n298 A2=n297 B1=n298 B2=n297
XU509 INV1S $PINS O=n300 I=n299
XU510 AOI13HS $PINS O=n307 A1=n300 B1=FE_OFN250_IyIt_shift_8 B2=n301
+ B3=Ix2_shift_3
XU511 NR2 $PINS O=n305 I1=B[11] I2=FE_DBTN139_Ix2_shift_0
XU512 INV1S $PINS O=intadd_144/B[3] I=n302
XU513 MOAI1S $PINS O=intadd_144/A[1] A1=n305 A2=n304 B1=n305 B2=n304
XU514 NR2 $PINS O=intadd_144/CI I1=FE_OFN1376_IyIt_shift_10
+ I2=FE_DBTN139_Ix2_shift_0
XU515 INV1S $PINS O=intadd_144/A[2] I=n309
XU516 FA1S $PINS S=intadd_144/B[2] CO=n95 A=n312 B=n311 CI=n310
XU517 FA1S $PINS S=n266 CO=n321 A=n315 B=n314 CI=n313
XU518 NR2 $PINS O=n319 I1=IyIt_shift_15 I2=FE_OFN279_FE_DBTN144_Ix2_shift_6
XU519 INV1S $PINS O=intadd_144/B[11] I=n318
XU520 FA1S $PINS S=n318 CO=n322 A=n321 B=n320 CI=n319
XU521 INV1S $PINS O=intadd_144/B[12] I=n322
XU522 NR2 $PINS O=N35 I1=FE_DBTN97_IyIt_shift_8 I2=FE_DBTN139_Ix2_shift_0
XU525 OA222 $PINS O=n467 A1=FE_OFN4200_FE_OFN1580_Ix2_shift_13
+ A2=FE_OFN1587_Ix2_shift_15 B1=FE_OFN4316_n B2=FE_OFN1183_FE_DBTN26_Ix2_shift_14
+ C1=FE_OFN1586_Ix2_shift_15 C2=FE_OFN1087_Ix2_shift_14
XU526 AOI22S $PINS O=n331 A1=FE_OFN1023_FE_DBTN102_IyIt_shift_14
+ A2=FE_OFN1586_Ix2_shift_15 B1=FE_OFN154_IyIt_shift_14
+ B2=FE_OFN1587_Ix2_shift_15
XU528 MOAI1S $PINS O=n466 A1=B[15] A2=FE_OFN1085_Ix2_shift_15 B1=B[15]
+ B2=FE_OFN1085_Ix2_shift_15
XU529 AOI22S $PINS O=intadd_146/A[10] A1=FE_OFN1518_n467 A2=n331
+ B1=FE_OFN1752_n468 B2=n466
XU530 INV1S $PINS O=intadd_146/A[11] I=intadd_146/A[10]
XU533 MOAI1 $PINS O=n442 A1=FE_OFN1504_FE_DBTN20_Ix2_shift_12
+ A2=FE_OFN2739_FE_DBTN154_n3259 B1=FE_OFN1504_FE_DBTN20_Ix2_shift_12
+ B2=FE_OFN4367_n
XU534 MOAI1S $PINS O=n332 A1=FE_OFN166_IyIt_shift_15
+ A2=FE_OFN4200_FE_OFN1580_Ix2_shift_13 B1=FE_OFN166_IyIt_shift_15
+ B2=FE_OFN4200_FE_OFN1580_Ix2_shift_13
XU535 OA222 $PINS O=n435 A1=FE_OFN1237_n3259
+ A2=FE_OFN4199_FE_OFN1580_Ix2_shift_13 B1=FE_OFN2739_FE_DBTN154_n3259
+ B2=FE_OFN1504_FE_DBTN20_Ix2_shift_12 C1=FE_DBTN150_Ix2_shift_13 C2=FE_RN_3
XU536 MOAI1S $PINS O=n340 A1=FE_OFN4200_FE_OFN1580_Ix2_shift_13
+ A2=FE_OFN1023_FE_DBTN102_IyIt_shift_14 B1=FE_OFN4200_FE_OFN1580_Ix2_shift_13
+ B2=FE_OFN1023_FE_DBTN102_IyIt_shift_14
XU537 AOI22S $PINS O=n337 A1=FE_OFN1538_n442 A2=n332 B1=FE_OFN1537_n435 B2=n340
XU539 MOAI1S $PINS O=n338 A1=FE_OFN168_IyIt_shift_13 A2=FE_OFN1085_Ix2_shift_15
+ B1=FE_OFN168_IyIt_shift_13 B2=FE_OFN1085_Ix2_shift_15
XU540 AOI22S $PINS O=n335 A1=FE_OFN1752_n468 A2=n331 B1=FE_OFN1518_n467 B2=n338
XU541 OA12 $PINS O=n334 A1=n332 B1=FE_OFN1538_n442 B2=FE_OFN1537_n435
XU542 INV1S $PINS O=intadd_146/B[10] I=n333
XU543 FA1S $PINS S=n336 CO=n333 A=n337 B=n335 CI=n334
XU544 INV1S $PINS O=intadd_146/A[9] I=n336
XU545 INV1S $PINS O=n464 I=n337
XU546 MOAI1S $PINS O=n341 A1=FE_OFN170_IyIt_shift_12 A2=FE_OFN1085_Ix2_shift_15
+ B1=FE_OFN169_IyIt_shift_12 B2=FE_OFN1085_Ix2_shift_15
XU547 AOI22S $PINS O=n463 A1=FE_OFN1752_n468 A2=n338 B1=FE_OFN1518_n467 B2=n341
XU548 MOAI1S $PINS O=n347 A1=FE_OFN1237_n3259 A2=B[15] B1=FE_OFN1237_n3259
+ B2=FE_OFN1186_FE_DBTN22_IyIt_shift_15
XU549 MOAI1S $PINS O=n358 A1=FE_OFN2739_FE_DBTN154_n3259
+ A2=FE_OFN1023_FE_DBTN102_IyIt_shift_14 B1=FE_OFN2739_FE_DBTN154_n3259
+ B2=FE_OFN1023_FE_DBTN102_IyIt_shift_14
XU550 INV1S $PINS O=n339 I=n358
XU551 INV1S $PINS O=n345 I=n371
XU552 MOAI1S $PINS O=n349 A1=FE_OFN168_IyIt_shift_13 A2=FE_OFN4346_n
+ B1=FE_OFN168_IyIt_shift_13 B2=FE_OFN4346_n
XU553 AOI22S $PINS O=n344 A1=FE_OFN1538_n442 A2=n340 B1=FE_OFN1537_n435 B2=n349
XU554 MOAI1S $PINS O=n351 A1=FE_OFN236_IyIt_shift_11 A2=FE_OFN1586_Ix2_shift_15
+ B1=FE_OFN236_IyIt_shift_11 B2=FE_OFN1586_Ix2_shift_15
XU555 AOI22S $PINS O=n343 A1=FE_OFN1519_n468 A2=n341 B1=FE_OFN1518_n467 B2=n351
XU556 INV1S $PINS O=intadd_146/B[9] I=n342
XU557 FA1S $PINS S=n355 CO=n462 A=n345 B=n344 CI=n343
XU558 OAI22S $PINS O=n354 A1=n359 A2=n347 B1=n346 B2=n347
XU559 MOAI1S $PINS O=n362 A1=FE_OFN169_IyIt_shift_12 A2=FE_OFN4346_n
+ B1=FE_OFN169_IyIt_shift_12 B2=FE_OFN4346_n
XU560 AOI22S $PINS O=n370 A1=FE_OFN1538_n442 A2=n349 B1=FE_OFN1537_n435 B2=n362
XU561 AOI22S $PINS O=n361 A1=FE_OFN1376_IyIt_shift_10 A2=FE_RN_5
+ B1=FE_OFN1718_IyIt_shift_10 B2=FE_OFN1587_Ix2_shift_15
XU562 AOI22S $PINS O=n369 A1=FE_OFN1519_n468 A2=n351 B1=FE_OFN1518_n467 B2=n361
XU563 INV1S $PINS O=intadd_146/A[8] I=n352
XU564 FA1S $PINS S=n356 CO=n352 A=n355 B=n354 CI=n353
XU565 INV1S $PINS O=intadd_146/A[7] I=n356
XU566 MOAI1S $PINS O=n380 A1=FE_OFN167_IyIt_shift_13
+ A2=FE_OFN1418_FE_DBTN154_n3259 B1=FE_OFN167_IyIt_shift_13
+ B2=FE_OFN2739_FE_DBTN154_n3259
XU567 MOAI1S $PINS O=n378 A1=n359 A2=n358 B1=FE_OFN4269_n455 B2=n380
XU568 MOAI1S $PINS O=n383 A1=FE_OFN1587_Ix2_shift_15 A2=FE_DBTN99_IyIt_shift_9
+ B1=FE_OFN1587_Ix2_shift_15 B2=FE_DBTN99_IyIt_shift_9
XU569 AO22 $PINS O=n376 A1=FE_OFN1519_n468 A2=n361 B1=n467 B2=n383
XU570 NR2 $PINS O=n377 I1=n378 I2=n376
XU571 MOAI1S $PINS O=n385 A1=FE_OFN236_IyIt_shift_11 A2=FE_OFN961_Ix2_shift_13
+ B1=FE_OFN236_IyIt_shift_11 B2=FE_OFN961_Ix2_shift_13
XU572 AOI22S $PINS O=n388 A1=FE_OFN1538_n442 A2=n362 B1=FE_OFN1537_n435 B2=n385
XU573 MOAI1S $PINS O=n368 A1=FE_OFN4297_n A2=FE_OFN1186_FE_DBTN22_IyIt_shift_15
+ B1=FE_OFN4297_n B2=FE_OFN1186_FE_DBTN22_IyIt_shift_15
XU574 NR2 $PINS O=n365 I1=FE_OFN1275_Ix2_shift_8 I2=FE_OFN4297_n
XU575 NR2 $PINS O=n387 I1=n368 I2=n365
XU576 MXL2HS $PINS OB=n367 S=n468 A=FE_OFN1087_Ix2_shift_14
+ B=FE_OFN4236_FE_DBTN97_IyIt_shift_8
XU577 NR2 $PINS O=n395 I1=FE_RN_5 I2=n367
XU578 MOAI1S $PINS O=n394 A1=n421 A2=n368 B1=n447
+ B2=FE_OFN1023_FE_DBTN102_IyIt_shift_14
XU579 FA1S $PINS S=n373 CO=n353 A=n371 B=n370 CI=n369
XU580 INV1S $PINS O=intadd_146/B[7] I=n372
XU581 FA1S $PINS S=n375 CO=n372 A=n377 B=n374 CI=n373
XU582 INV1S $PINS O=intadd_146/A[6] I=n375
XU583 OAI22S $PINS O=n392 A1=n378 A2=n377 B1=n376 B2=n377
XU584 MOAI1S $PINS O=n401 A1=FE_OFN4311_n A2=FE_OFN1387_n348 B1=FE_OFN4311_n
+ B2=FE_OFN1387_n348
XU585 AOI22S $PINS O=n404 A1=FE_DBTN89_n359 A2=n380 B1=FE_OFN4269_n455 B2=n401
XU586 MOAI1S $PINS O=n382 A1=B[8] A2=FE_OFN1586_Ix2_shift_15 B1=B[8]
+ B2=FE_OFN1586_Ix2_shift_15
XU587 AOI22S $PINS O=n403 A1=n468 A2=n383 B1=n467 B2=n382
XU588 MOAI1S $PINS O=n410 A1=FE_OFN1718_IyIt_shift_10 A2=FE_OFN960_Ix2_shift_13
+ B1=FE_OFN1718_IyIt_shift_10 B2=FE_OFN960_Ix2_shift_13
XU589 AOI22S $PINS O=n402 A1=FE_OFN1538_n442 A2=n385 B1=n435 B2=n410
XU590 FA1S $PINS S=n390 CO=n374 A=n388 B=n387 CI=n386
XU591 INV1S $PINS O=intadd_146/B[6] I=n389
XU592 FA1S $PINS S=n393 CO=n389 A=n392 B=n391 CI=n390
XU593 INV1S $PINS O=intadd_146/A[5] I=n393
XU594 MOAI1S $PINS O=n408 A1=n395 A2=n394 B1=n395 B2=n394
XU595 MOAI1S $PINS O=n398 A1=FE_OFN4297_n A2=FE_DBTN102_IyIt_shift_14
+ B1=FE_OFN4297_n B2=FE_DBTN102_IyIt_shift_14
XU596 AOI22S $PINS O=n412 A1=FE_OFN1276_Ix2_shift_8 A2=n398 B1=n447 B2=n279
XU597 MOAI1S $PINS O=n431 A1=FE_OFN236_IyIt_shift_11
+ A2=FE_OFN1418_FE_DBTN154_n3259 B1=FE_OFN262_IyIt_shift_11
+ B2=FE_OFN1418_FE_DBTN154_n3259
XU598 AOI22S $PINS O=n411 A1=FE_OFN1482_FE_DBTN89_n359 A2=n401 B1=n455 B2=n431
XU599 FA1S $PINS S=n406 CO=n391 A=n404 B=n403 CI=n402
XU600 INV1S $PINS O=intadd_146/B[5] I=n405
XU601 FA1S $PINS S=n409 CO=n405 A=n408 B=n407 CI=n406
XU602 INV1S $PINS O=intadd_146/A[4] I=n409
XU603 MOAI1S $PINS O=n436 A1=FE_OFN171_IyIt_shift_9 A2=FE_OFN961_Ix2_shift_13
+ B1=FE_OFN171_IyIt_shift_9 B2=FE_OFN4346_n
XU604 AOI22S $PINS O=n425 A1=n442 A2=n410 B1=n435 B2=n436
XU605 FA1S $PINS S=n424 CO=n407 A=n413 B=n412 CI=n411
XU607 MXL2HS $PINS OB=n416 S=n442 A=FE_RN_3 B=FE_OFN4236_FE_DBTN97_IyIt_shift_8
XU608 NR2 $PINS O=n428 I1=FE_OFN960_Ix2_shift_13 I2=n416
XU609 MOAI1S $PINS O=n420 A1=FE_OFN4296_n A2=FE_OFN167_IyIt_shift_13
+ B1=FE_OFN4296_n B2=FE_OFN167_IyIt_shift_13
XU610 MOAI1S $PINS O=n427 A1=n421 A2=n420 B1=n447 B2=FE_OFN1387_n348
XU611 INV1S $PINS O=intadd_146/B[4] I=n422
XU612 FA1S $PINS S=n426 CO=n422 A=n425 B=n424 CI=n423
XU613 INV1S $PINS O=intadd_146/A[3] I=n426
XU614 MOAI1S $PINS O=n451 A1=FE_OFN1718_IyIt_shift_10 A2=FE_OFN4363_n
+ B1=FE_OFN1718_IyIt_shift_10 B2=FE_OFN4363_n
XU615 AOI22S $PINS O=n439 A1=FE_OFN1482_FE_DBTN89_n359 A2=n431 B1=n455 B2=n451
XU616 MOAI1S $PINS O=n434 A1=B[8] A2=FE_OFN4316_n B1=B[8] B2=FE_OFN4316_n
XU617 AOI22S $PINS O=n438 A1=n442 A2=n436 B1=n435 B2=n434
XU618 INV1S $PINS O=intadd_146/B[3] I=n437
XU619 FA1S $PINS S=n441 CO=n437 A=n440 B=n439 CI=n438
XU620 INV1S $PINS O=intadd_146/A[2] I=n441
XU621 MOAI1S $PINS O=n448 A1=FE_OFN4296_n A2=FE_OFN1387_n348 B1=FE_OFN4296_n
+ B2=FE_OFN1387_n348
XU622 AOI22S $PINS O=n459 A1=FE_OFN1276_Ix2_shift_8 A2=n448 B1=n447 B2=B[11]
XU623 AOI22S $PINS O=n458 A1=FE_OFN1482_FE_DBTN89_n359 A2=n451 B1=n455 B2=n450
XU624 INV1S $PINS O=intadd_146/B[2] I=n452
XU625 MOAI1S $PINS O=intadd_146/CI A1=n457 A2=FE_OFN1475_FE_DBTN97_IyIt_shift_8
+ B1=FE_OFN1233_n3259 B2=n455
XU626 FA1S $PINS S=n461 CO=n452 A=n460 B=n459 CI=n458
XU627 INV1S $PINS O=intadd_146/B[1] I=n461
XU628 FA1S $PINS S=n465 CO=n342 A=n464 B=n463 CI=n462
XU629 INV1S $PINS O=intadd_146/B[8] I=n465
XU630 OAI12HS $PINS O=intadd_146/B[11] A1=n466 B1=FE_OFN1752_n468
+ B2=FE_OFN1518_n467
XU631 INV1S $PINS O=N67 I=intadd_146/n1
XU632 INV1S $PINS O=intadd_143/B[21] I=s1_P3[13]
XU633 INV1S $PINS O=intadd_143/B[20] I=s1_P3[12]
XU634 INV1S $PINS O=intadd_143/B[19] I=s1_P3[11]
XU635 INV1S $PINS O=intadd_143/B[18] I=s1_P3[10]
XU636 INV1S $PINS O=intadd_143/A[17] I=s1_P3[9]
XU637 NR2 $PINS O=n469 I1=s1_P0[9] I2=s1_P2[1]
XU638 NR2 $PINS O=intadd_143/B[1] I1=intadd_143/A[2] I2=n469
XU639 FA1S $PINS S=n487 CO=n488 A=N37 B=N20 CI=N11
XU640 FA1S $PINS S=n489 CO=n490 A=N38 B=N21 CI=N12
XU641 FA1S $PINS S=n491 CO=n492 A=N39 B=N22 CI=N13
XU642 FA1S $PINS S=n493 CO=n494 A=N40 B=N23 CI=N14
XU643 NR2 $PINS O=n472 I1=FE_OFN4265_n421 I2=FE_OFN4235_FE_DBTN97_IyIt_shift_8
XU644 FA1S $PINS S=n497 CO=n498 A=n472 B=N26 CI=N43
XU645 NR2 $PINS O=n480 I1=n472 I2=FE_OFN4330_n
XU646 MOAI1S $PINS O=n477 A1=FE_OFN171_IyIt_shift_9 A2=FE_OFN4330_n
+ B1=FE_OFN171_IyIt_shift_9 B2=FE_OFN4330_n
XU647 AN2 $PINS O=n479 I1=n477 I2=FE_OFN1595_Ix2_shift_8
XU648 OA12 $PINS O=n481 A1=n478 B1=n480 B2=n479
XU649 FA1S $PINS S=n499 CO=n500 A=n481 B=N27 CI=N44
XU650 OAI22S $PINS O=n484 A1=n483 A2=intadd_146/B[0] B1=n482 B2=intadd_146/B[0]
XU651 FA1S $PINS S=n501 CO=n502 A=n484 B=N28 CI=N45
XU652 FA1S $PINS S=n503 CO=n504 A=N55 B=N29 CI=N46
XU653 FA1S $PINS S=n505 CO=n506 A=N56 B=N30 CI=N47
XU654 FA1 $PINS S=N90 CO=intadd_143/n9 A=intadd_143/B[14] B=intadd_143/A[14]
+ CI=intadd_143/n10
XU655 FA1 $PINS S=N91 CO=intadd_143/n8 A=intadd_143/B[15] B=intadd_143/A[15]
+ CI=intadd_143/n9
XU656 FA1 $PINS S=N65 CO=intadd_146/n2 A=intadd_146/B[10] B=intadd_146/A[10]
+ CI=intadd_146/n3
XU657 FA1 $PINS S=N64 CO=intadd_146/n3 A=intadd_146/B[9] B=intadd_146/A[9]
+ CI=intadd_146/n4
XU658 FA1 $PINS S=N59 CO=intadd_146/n8 A=intadd_146/B[4] B=intadd_146/A[4]
+ CI=intadd_146/n9
XU659 FA1 $PINS S=N58 CO=intadd_146/n9 A=intadd_146/B[3] B=intadd_146/A[3]
+ CI=intadd_146/n10
XU660 FA1S $PINS S=n485 CO=n486 A=N9 B=N18 CI=N35
Xs1_P0_reg[2] QDFFRBS $PINS Q=N70 D=N3 CK=clk RB=FE_OFN84_i_reset_n_i
Xs1_P3_reg[7] QDFFRBS $PINS Q=s1_P3[7] D=N59 CK=clk_clone2
+ RB=FE_OFN193_i_reset_n_i
Xs2_result_reg[17] QDFFRBS $PINS Q=result[17] D=N85 CK=clk
+ RB=FE_OFN63_i_reset_n_i
Xs2_result_reg[2] QDFFRBS $PINS Q=result[2] D=FE_PHN3114_N70 CK=clk
+ RB=FE_OFN98_i_reset_n_i
XR_99 QDFFRBS $PINS Q=intadd_143/A[9] D=n498 CK=clk_clone2
+ RB=FE_OFN21_i_reset_n_i
XR_120 QDFFRBS $PINS Q=intadd_143/B[6] D=n36 CK=clk_clone2
+ RB=FE_OFN37_i_reset_n_i
XU16 ND2S $PINS O=n241 I1=FE_OFN1233_n3259 I2=FE_OFN139_IyIt_shift_1
XU28 ND2S $PINS O=n183 I1=FE_OFN833_Ix2_shift_0 I2=FE_OFN239_IyIt_shift_3
XU37 ND2S $PINS O=n124 I1=B[9] I2=FE_OFN833_Ix2_shift_0
.ENDS

.SUBCKT mult_pipe_3 rst_n A[15] A[14] A[13] A[12] A[11] A[10] A[9] A[8] A[7]
+ A[6] A[5] A[4] A[3] A[2] A[1] A[0] B[15] B[14] B[13] B[12] B[11] B[10] B[9]
+ B[8] B[7] B[6] B[5] B[4] B[3] B[2] B[1] B[0] result[31] result[30] result[29]
+ result[28] result[27] result[26] result[25] result[24] result[23] result[22]
+ result[21] result[20] result[19] result[18] result[17] result[16] result[15]
+ result[14] result[13] result[12] result[11] result[10] result[9] result[8]
+ result[7] result[6] result[5] result[4] result[3] result[2] result[1]
+ result[0] Iy2_shift_15 Ix2_shift_12 Ix2_shift_15 Ix2_shift_3 Ix2_shift_14
+ Iy2_shift_14 Ix2_shift_4 n1438 n4486 FE_OFN96_i_reset_n_i
+ FE_OFN95_i_reset_n_i FE_OFN82_i_reset_n_i FE_OFN80_i_reset_n_i
+ FE_OFN79_i_reset_n_i FE_OFN75_i_reset_n_i FE_OFN59_i_reset_n_i
+ FE_OFN57_i_reset_n_i FE_OFN55_i_reset_n_i FE_OFN54_i_reset_n_i
+ FE_OFN52_i_reset_n_i FE_OFN34_i_reset_n_i FE_OFN33_i_reset_n_i
+ FE_OFN32_i_reset_n_i FE_OFN20_i_reset_n_i FE_OFN18_i_reset_n_i
+ FE_OFN15_i_reset_n_i FE_OFN12_i_reset_n_i FE_OFN3_i_reset_n_i
+ FE_OFN117_Ix2_shift_1 FE_OFN116_Ix2_shift_1 FE_OFN119_Ix2_shift_0
+ FE_OFN118_Ix2_shift_0 FE_OFN120_Iy2_shift_1 FE_OFN122_Iy2_shift_0
+ FE_OFN121_Iy2_shift_0 FE_OFN143_Ix2_shift_13 FE_OFN142_Ix2_shift_13
+ FE_OFN145_Iy2_shift_13 FE_OFN144_Iy2_shift_13 FE_OFN159_Ix2_shift_15
+ FE_OFN158_Ix2_shift_15 FE_OFN157_Ix2_shift_15 FE_OFN156_Ix2_shift_15
+ FE_OFN161_Ix2_shift_14 FE_OFN173_FE_DBTN27_Iy2_shift_14
+ FE_OFN174_FE_DBTN26_Ix2_shift_14 FE_OFN176_FE_DBTN21_Ix2_shift_15
+ FE_OFN175_FE_DBTN21_Ix2_shift_15 FE_OFN183_n3259 FE_OFN182_n3259
+ FE_OFN181_n3259 FE_OFN190_Ix2_shift_10 FE_OFN189_Ix2_shift_10
+ FE_OFN193_Ix2_shift_9 FE_OFN192_Ix2_shift_9 FE_OFN191_Ix2_shift_9
+ FE_OFN197_Ix2_shift_8 FE_OFN196_Ix2_shift_8 FE_OFN195_Ix2_shift_8
+ FE_OFN200_Ix2_shift_7 FE_OFN199_Ix2_shift_7 FE_OFN198_Ix2_shift_7
+ FE_OFN202_Ix2_shift_5 FE_OFN203_Ix2_shift_4 FE_OFN204_Ix2_shift_3
+ FE_OFN205_Ix2_shift_2 FE_OFN206_Iy2_shift_11 FE_OFN207_Iy2_shift_10
+ FE_OFN209_Iy2_shift_9 FE_OFN208_Iy2_shift_9 FE_OFN211_Iy2_shift_8
+ FE_OFN210_Iy2_shift_8 FE_OFN213_Iy2_shift_2 FE_OFN212_Iy2_shift_2
+ FE_OFN241_FE_DBTN38_n1438 FE_OFN243_FE_DBTN31_Ix2_shift_4
+ FE_OFN246_FE_DBTN25_Ix2_shift_3 FE_OFN247_FE_DBTN20_Ix2_shift_12
+ FE_OFN256_Ix2_shift_13 FE_OFN258_Ix2_shift_3 FE_OFN260_Iy2_shift_15
+ FE_OFN1278_Ix2_shift_7 FE_OFN263_FE_OFN1078_Ix2_shift_15
+ FE_OFN268_FE_OFN1554_n3259 FE_OFN266_FE_OFN1554_n3259 FE_OFN269_n clk_clone3
+ clk_clone5 clk_clone4 clk_clone2 clk_clone1 clk
XFE_PHC3299_N99 BUF1CK $PINS O=N99 I=FE_PHN3299_N99
XFE_PHC3238_intadd_120_A_22 BUF1CK $PINS O=FE_PHN3238_intadd_120_A_22
+ I=intadd_120/A[22]
XFE_PHC3118_N68 DELB $PINS O=N68 I=FE_PHN3118_N68
XFE_PHC3101_N75 DELB $PINS O=FE_PHN3101_N75 I=N75
XFE_PHC3093_N76 DELB $PINS O=FE_PHN3093_N76 I=N76
XFE_PHC3092_N74 DELB $PINS O=FE_PHN3092_N74 I=N74
XFE_PHC3069_N73 DELB $PINS O=N73 I=FE_PHN3069_N73
XFE_PHC3060_N71 DELB $PINS O=FE_PHN3060_N71 I=N71
XFE_PHC3027_N72 DELB $PINS O=FE_PHN3027_N72 I=N72
XFE_PHC3026_N69 DELB $PINS O=N69 I=FE_PHN3026_N69
XFE_PHC2960_N70 DELB $PINS O=N70 I=FE_PHN2960_N70
XFE_RC_1_0 MOAI1 $PINS O=n82 A1=intadd_120/n1 A2=s1_P3[15] B1=intadd_120/n1
+ B2=s1_P3[15]
XFE_RC_27_0 MOAI1 $PINS O=n349 A1=FE_OFN191_Ix2_shift_9 A2=A[10]
+ B1=FE_OFN191_Ix2_shift_9 B2=A[10]
XFE_OFC2926_FE_DBTN134_Iy2_shift_8 BUF1 $PINS O=FE_OFN4361_n
+ I=FE_OFN1442_FE_DBTN134_Iy2_shift_8
XFE_OFC2917_Ix2_shift_8 BUF1 $PINS O=FE_OFN4352_Ix2_shift_8
+ I=FE_OFN197_Ix2_shift_8
XFE_OFC2915_Iy2_shift_8 BUF1 $PINS O=FE_OFN4350_n I=FE_OFN4348_n
XFE_OFC2913_Iy2_shift_8 BUF1 $PINS O=FE_OFN4348_n I=B[8]
XFE_OFC2847_FE_RN_2 BUF1 $PINS O=FE_OFN4282_FE_RN_2 I=FE_OFN4279_FE_RN_2
XFE_OFC2845_FE_RN_2 INV1S $PINS O=FE_OFN4280_FE_RN_2 I=FE_OFN4278_FE_RN_2
XFE_OFC2844_FE_RN_2 INV1S $PINS O=FE_OFN4279_FE_RN_2 I=FE_OFN4278_FE_RN_2
XFE_OFC2843_FE_RN_2 INV1S $PINS O=FE_OFN4278_FE_RN_2 I=FE_RN_2
XFE_OFC2741_FE_OFN1263_Ix2_shift_9 BUF1 $PINS
+ O=FE_OFN4176_FE_OFN1263_Ix2_shift_9 I=A[9]
XFE_OFC2739_FE_OFN1263_Ix2_shift_9 BUF1 $PINS
+ O=FE_OFN4174_FE_OFN1263_Ix2_shift_9 I=A[9]
XFE_OFC2738_FE_OFN1411_FE_DBTN155_n3259 BUF1 $PINS
+ O=FE_OFN4173_FE_OFN1411_FE_DBTN155_n3259 I=FE_OFN1411_FE_DBTN155_n3259
XFE_OFC2737_FE_OFN1411_FE_DBTN155_n3259 BUF1 $PINS
+ O=FE_OFN4172_FE_OFN1411_FE_DBTN155_n3259 I=FE_OFN1411_FE_DBTN155_n3259
XFE_OFC2736_FE_OFN1411_FE_DBTN155_n3259 BUF1 $PINS
+ O=FE_OFN4171_FE_OFN1411_FE_DBTN155_n3259 I=FE_OFN1411_FE_DBTN155_n3259
XFE_OFC2728_FE_OFN1078_Ix2_shift_15 BUF1 $PINS
+ O=FE_OFN4163_FE_OFN1078_Ix2_shift_15 I=FE_OFN157_Ix2_shift_15
XFE_OFC2727_FE_OFN1007_FE_DBTN149_Ix2_shift_13 BUF1 $PINS
+ O=FE_OFN4162_FE_OFN1007_FE_DBTN149_Ix2_shift_13
+ I=FE_OFN4160_FE_OFN1007_FE_DBTN149_Ix2_shift_13
XFE_OFC2726_FE_OFN1007_FE_DBTN149_Ix2_shift_13 BUF1 $PINS
+ O=FE_OFN4161_FE_OFN1007_FE_DBTN149_Ix2_shift_13
+ I=FE_OFN4160_FE_OFN1007_FE_DBTN149_Ix2_shift_13
XFE_OFC2725_FE_OFN1007_FE_DBTN149_Ix2_shift_13 BUF1 $PINS
+ O=FE_OFN4160_FE_OFN1007_FE_DBTN149_Ix2_shift_13
+ I=FE_OFN1007_FE_DBTN149_Ix2_shift_13
XFE_OFC2724_FE_OFN1007_FE_DBTN149_Ix2_shift_13 BUF1 $PINS
+ O=FE_OFN4159_FE_OFN1007_FE_DBTN149_Ix2_shift_13
+ I=FE_OFN1007_FE_DBTN149_Ix2_shift_13
XFE_OFC2609_Iy2_shift_0 INV1S $PINS O=FE_RN_14 I=FE_OFN122_Iy2_shift_0
XFE_OFC2590_Ix2_shift_3 BUF1 $PINS O=FE_RN_13 I=A[3]
XFE_OFC2547_Iy2_shift_1 BUF1 $PINS O=FE_OFN4117_Iy2_shift_1 I=B[1]
XFE_OFC2525_FE_DBTN38_n1438 BUF1 $PINS O=FE_RN_12 I=FE_OFN241_FE_DBTN38_n1438
XFE_OFC2400_n1623 BUF1 $PINS O=FE_OFN1721_n1623 I=FE_OFN1520_n189
XFE_OFC2399_n1623 BUF1 $PINS O=FE_OFN1720_n1623 I=FE_OFN1520_n189
XFE_OFC2398_n1623 INV1S $PINS O=FE_OFN1209_n1623 I=FE_OFN1520_n189
XFE_OFC2397_n1623 INV1S $PINS O=n189 I=FE_OFN1520_n189
XFE_OFC2396_n1623 INV1S $PINS O=FE_OFN1520_n189 I=B[7]
XFE_OFC2378_Iy2_shift_14 BUF1 $PINS O=FE_RN_11 I=FE_OFN1096_Iy2_shift_14
XFE_OFC2375_Iy2_shift_14 INV1S $PINS O=FE_OFN1096_Iy2_shift_14 I=Iy2_shift_14
XFE_OFC2341_Ix2_shift_4 BUF1 $PINS O=FE_OFN1283_Ix2_shift_4 I=Ix2_shift_4
XFE_OFC2296_n1668 BUF1 $PINS O=FE_OFN1524_n434 I=FE_OFN1216_n1668
XFE_OFC2295_n1668 INV1S $PINS O=n434 I=FE_OFN1216_n1668
XFE_OFC2294_n1668 INV1S $PINS O=FE_OFN1216_n1668 I=B[12]
XFE_OFC2276_Ix2_shift_1 BUF1 $PINS O=FE_OFN1688_Ix2_shift_1
+ I=FE_OFN1687_Ix2_shift_1
XFE_OFC2275_Ix2_shift_1 INV1S $PINS O=FE_OFN1687_Ix2_shift_1
+ I=FE_OFN117_Ix2_shift_1
XFE_OFC2273_Ix2_shift_1 INV1S $PINS O=FE_OFN1685_Ix2_shift_1
+ I=FE_OFN116_Ix2_shift_1
XFE_OFC2271_Ix2_shift_1 INV1S $PINS O=n166 I=FE_OFN116_Ix2_shift_1
XFE_OFC2270_Ix2_shift_1 INV1S $PINS O=FE_OFN997_n166 I=FE_OFN116_Ix2_shift_1
XFE_OFC2242_Ix2_shift_2 BUF1 $PINS O=FE_OFN1678_Ix2_shift_2
+ I=FE_OFN1430_FE_DBTN141_Ix2_shift_2
XFE_OFC2241_Ix2_shift_2 BUF1 $PINS O=FE_OFN1677_Ix2_shift_2
+ I=FE_DBTN141_Ix2_shift_2
XFE_OFC2237_Ix2_shift_2 INV1S $PINS O=FE_OFN1676_Ix2_shift_2 I=A[2]
XFE_OFC2235_Ix2_shift_2 INV1S $PINS O=FE_OFN1430_FE_DBTN141_Ix2_shift_2
+ I=FE_OFN205_Ix2_shift_2
XFE_OFC2234_Ix2_shift_2 INV1S $PINS O=FE_DBTN141_Ix2_shift_2
+ I=FE_OFN205_Ix2_shift_2
XFE_OFC2206_Ix2_shift_5 BUF1 $PINS O=FE_OFN1426_FE_DBTN143_Ix2_shift_5
+ I=FE_OFN1427_FE_DBTN143_Ix2_shift_5
XFE_OFC2205_Ix2_shift_5 BUF1 $PINS O=FE_DBTN143_Ix2_shift_5
+ I=FE_OFN1427_FE_DBTN143_Ix2_shift_5
XFE_OFC2202_Ix2_shift_5 INV1S $PINS O=FE_OFN1427_FE_DBTN143_Ix2_shift_5
+ I=FE_OFN202_Ix2_shift_5
XFE_OFC2200_FE_DBTN167_n1627 BUF1 $PINS O=FE_OFN272_FE_DBTN167_n1627
+ I=FE_DBTN167_n1627
XFE_OFC2199_FE_DBTN167_n1627 BUF1 $PINS O=FE_OFN271_FE_DBTN167_n1627
+ I=FE_DBTN167_n1627
XFE_OFC2191_n1640 INV1S $PINS O=FE_OFN1667_n1640 I=A[6]
XFE_OFC2190_n1640 INV1S $PINS O=FE_OFN273_FE_DBTN166_n1640 I=A[6]
XFE_OFC2189_n1640 BUF1 $PINS O=FE_DBTN166_n1640 I=A[6]
XFE_OFC2167_intadd_121_n1 INV1S $PINS O=N50 I=intadd_121/n1
XFE_OFC2153_n459 BUF1 $PINS O=FE_OFN1653_n459 I=n459
XFE_OFC2107_FE_DBTN88_n349 BUF1 $PINS O=FE_OFN1483_FE_DBTN88_n349
+ I=FE_DBTN88_n349
XFE_OFC2093_Iy2_shift_15 BUF1 $PINS O=FE_OFN1642_Iy2_shift_15
+ I=FE_OFN260_Iy2_shift_15
XFE_OFC2090_Iy2_shift_15 BUF1 $PINS O=FE_OFN1089_Iy2_shift_15
+ I=FE_OFN1196_FE_DBTN12_Iy2_shift_15
XFE_OFC2086_Iy2_shift_15 BUF1 $PINS O=FE_OFN1196_FE_DBTN12_Iy2_shift_15 I=B[15]
XFE_OFC2067_n425 BUF1 $PINS O=FE_OFN1540_n425 I=n425
XFE_OFC2050_n4486 BUF1 $PINS O=FE_OFN1634_n4486 I=FE_OFN1245_n4486
XFE_OFC2049_n4486 BUF1 $PINS O=FE_OFN1246_n4486 I=FE_RN_10
XFE_OFC2048_n4486 BUF1 $PINS O=FE_OFN1245_n4486 I=FE_RN_10
XFE_OFC2045_n4486 INV1S $PINS O=FE_RN_10 I=B[5]
XFE_OFC2026_Iy2_shift_10 BUF1 $PINS O=FE_OFN1522_n340 I=B[10]
XFE_OFC2023_Iy2_shift_10 BUF1 $PINS O=FE_OFN1302_Iy2_shift_10
+ I=FE_OFN207_Iy2_shift_10
XFE_OFC2022_Iy2_shift_10 BUF1 $PINS O=n340 I=FE_OFN207_Iy2_shift_10
XFE_OFC2006_Ix2_shift_10 INV1S $PINS O=FE_RN_9 I=FE_OFN189_Ix2_shift_10
XFE_OFC2005_Ix2_shift_10 INV1S $PINS O=FE_OFN1420_FE_DBTN147_Ix2_shift_10
+ I=FE_OFN189_Ix2_shift_10
XFE_OFC1963_n1438 BUF1 $PINS O=FE_OFN1202_n1438 I=FE_RN_8
XFE_OFC1962_n1438 BUF1 $PINS O=FE_OFN1205_n1438 I=FE_RN_8
XFE_OFC1958_n1438 INV1S $PINS O=FE_RN_8 I=FE_OFN241_FE_DBTN38_n1438
XFE_OFC1942_Ix2_shift_3 INV1S $PINS O=FE_OFN1607_Ix2_shift_3
+ I=FE_OFN246_FE_DBTN25_Ix2_shift_3
XFE_OFC1939_Ix2_shift_3 BUF1 $PINS O=FE_OFN1287_Ix2_shift_3 I=FE_RN_13
XFE_OFC1934_Iy2_shift_2 INV1S $PINS O=FE_OFN1448_FE_DBTN130_Iy2_shift_2
+ I=FE_RN_7
XFE_OFC1933_Iy2_shift_2 INV1S $PINS O=FE_OFN1447_FE_DBTN130_Iy2_shift_2
+ I=FE_RN_7
XFE_OFC1928_Iy2_shift_2 INV1S $PINS O=FE_RN_7 I=FE_OFN213_Iy2_shift_2
XFE_OFC1887_Ix2_shift_8 INV1S $PINS O=FE_OFN1593_Ix2_shift_8
+ I=FE_OFN196_Ix2_shift_8
XFE_OFC1886_Ix2_shift_8 INV1S $PINS O=FE_OFN1592_Ix2_shift_8
+ I=FE_OFN196_Ix2_shift_8
XFE_OFC1885_Ix2_shift_8 INV1S $PINS O=FE_OFN1523_n410 I=FE_OFN196_Ix2_shift_8
XFE_OFC1884_Ix2_shift_8 INV1S $PINS O=FE_OFN1273_Ix2_shift_8
+ I=FE_OFN196_Ix2_shift_8
XFE_OFC1883_Ix2_shift_8 INV1S $PINS O=n410 I=A[8]
XFE_OFC1882_Ix2_shift_8 INV1S $PINS O=FE_OFN1591_Ix2_shift_8
+ I=FE_OFN197_Ix2_shift_8
XFE_OFC1879_Ix2_shift_15 BUF1 $PINS O=FE_OFN1588_Ix2_shift_15 I=A[15]
XFE_OFC1830_Ix2_shift_13 INV1S $PINS O=FE_OFN1007_FE_DBTN149_Ix2_shift_13
+ I=FE_OFN143_Ix2_shift_13
XFE_OFC1797_Iy2_shift_13 BUF1 $PINS O=FE_RN_4 I=FE_OFN965_Iy2_shift_13
XFE_OFC1796_Iy2_shift_13 INV1S $PINS O=FE_OFN967_Iy2_shift_13
+ I=FE_OFN965_Iy2_shift_13
XFE_OFC1794_Iy2_shift_13 BUF1 $PINS O=FE_OFN965_Iy2_shift_13
+ I=FE_OFN144_Iy2_shift_13
XFE_OFC1760_Iy2_shift_11 BUF1 $PINS O=n436 I=FE_OFN1295_Iy2_shift_11
XFE_OFC1759_Iy2_shift_11 INV1S $PINS O=FE_OFN1297_Iy2_shift_11
+ I=FE_OFN1295_Iy2_shift_11
XFE_OFC1756_Iy2_shift_11 INV1S $PINS O=FE_OFN1295_Iy2_shift_11 I=B[11]
XFE_OFC1673_Iy2_shift_8 INV1S $PINS O=FE_OFN1443_FE_DBTN134_Iy2_shift_8 I=B[8]
XFE_OFC1672_Iy2_shift_8 INV1S $PINS O=FE_OFN1442_FE_DBTN134_Iy2_shift_8
+ I=FE_OFN4348_n
XFE_OFC1615_Ix2_shift_9 INV1S $PINS O=FE_RN_2 I=A[9]
XFE_OFC1606_n3259 INV1S $PINS O=FE_OFN1411_FE_DBTN155_n3259
+ I=FE_OFN1413_FE_DBTN155_n3259
XFE_OFC1603_n3259 INV1S $PINS O=FE_OFN1413_FE_DBTN155_n3259 I=FE_OFN181_n3259
XFE_OFC1602_n3259 INV1S $PINS O=FE_DBTN155_n3259 I=FE_OFN181_n3259
XFE_OFC1596_Iy2_shift_9 INV1S $PINS O=FE_DBTN135_Iy2_shift_9 I=B[9]
XFE_OFC1595_Iy2_shift_9 INV1S $PINS O=FE_OFN1307_Iy2_shift_9 I=B[9]
XFE_OFC1594_Iy2_shift_9 BUF1 $PINS O=FE_RN_1 I=B[9]
XFE_OFC1540_n445 BUF1 $PINS O=FE_OFN1542_n445 I=n445
XFE_OFC1539_n432 BUF1 $PINS O=FE_OFN1541_n432 I=n432
XFE_OFC1523_n458 BUF1 $PINS O=FE_OFN1525_n458 I=n458
XFE_OFC1519_n308 BUF1 $PINS O=FE_OFN1521_n308 I=FE_OFN1278_Ix2_shift_7
XFE_OFC1443_FE_DBTN133_Iy2_shift_6 BUF1 $PINS
+ O=FE_OFN1445_FE_DBTN133_Iy2_shift_6 I=FE_DBTN133_Iy2_shift_6
XFE_OFC1442_FE_DBTN133_Iy2_shift_6 BUF1 $PINS
+ O=FE_OFN1444_FE_DBTN133_Iy2_shift_6 I=FE_DBTN133_Iy2_shift_6
XFE_OFC1095_Iy2_shift_14 BUF1 $PINS O=FE_OFN1097_Iy2_shift_14 I=FE_RN_11
XFE_OFC996_n315 BUF1 $PINS O=FE_OFN998_n315 I=n315
XFE_OFC840_Iy2_shift_0 INV1S $PINS O=FE_OFN842_Iy2_shift_0 I=FE_RN_14
XFE_OFC834_Iy2_shift_1 BUF1 $PINS O=FE_OFN836_Iy2_shift_1
+ I=FE_OFN4117_Iy2_shift_1
XFE_OFC249_i_reset_n_i BUF1 $PINS O=FE_OFN251_i_reset_n_i
+ I=FE_OFN96_i_reset_n_i
XFE_OFC220_i_reset_n_i INV1S $PINS O=FE_OFN222_i_reset_n_i
+ I=FE_OFN177_i_reset_n_i
XFE_OFC219_i_reset_n_i INV1S $PINS O=FE_OFN221_i_reset_n_i
+ I=FE_OFN177_i_reset_n_i
XFE_OFC212_i_reset_n_i BUF1 $PINS O=FE_OFN214_i_reset_n_i
+ I=FE_OFN80_i_reset_n_i
XFE_OFC175_i_reset_n_i INV1S $PINS O=FE_OFN177_i_reset_n_i
+ I=FE_OFN131_i_reset_n_i
XFE_OFC174_i_reset_n_i BUF1 $PINS O=FE_OFN176_i_reset_n_i
+ I=FE_OFN59_i_reset_n_i
XFE_OFC169_i_reset_n_i BUF1 $PINS O=FE_OFN171_i_reset_n_i
+ I=FE_OFN57_i_reset_n_i
XFE_OFC129_i_reset_n_i BUF1 $PINS O=FE_OFN131_i_reset_n_i
+ I=FE_OFN83_i_reset_n_i
XFE_OFC128_i_reset_n_i BUF1 $PINS O=FE_OFN130_i_reset_n_i
+ I=FE_OFN83_i_reset_n_i
XFE_OFC127_i_reset_n_i BUF1 $PINS O=FE_OFN129_i_reset_n_i
+ I=FE_OFN83_i_reset_n_i
XFE_OFC117_i_reset_n_i BUF1 $PINS O=FE_OFN119_i_reset_n_i
+ I=FE_OFN33_i_reset_n_i
XFE_OFC81_i_reset_n_i BUF1 $PINS O=FE_OFN83_i_reset_n_i I=FE_OFN20_i_reset_n_i
XFE_DBTC167_n1627 INV1S $PINS O=FE_DBTN167_n1627 I=B[4]
XFE_DBTC133_Iy2_shift_6 INV1S $PINS O=FE_DBTN133_Iy2_shift_6 I=B[6]
XFE_DBTC88_n349 INV1S $PINS O=FE_DBTN88_n349 I=n349
Xs1_P0_reg[15] QDFFRBN $PINS Q=s1_P0[15] D=N16 CK=clk_clone1
+ RB=FE_OFN33_i_reset_n_i
Xs1_P0_reg[14] QDFFRBN $PINS Q=s1_P0[14] D=N15 CK=clk_clone1
+ RB=FE_OFN119_i_reset_n_i
Xs1_P0_reg[13] QDFFRBN $PINS Q=s1_P0[13] D=N14 CK=clk_clone5
+ RB=FE_OFN222_i_reset_n_i
Xs1_P0_reg[12] QDFFRBN $PINS Q=s1_P0[12] D=N13 CK=clk_clone5
+ RB=FE_OFN221_i_reset_n_i
Xs1_P0_reg[11] QDFFRBN $PINS Q=s1_P0[11] D=N12 CK=clk_clone5
+ RB=FE_OFN221_i_reset_n_i
Xs1_P0_reg[10] QDFFRBN $PINS Q=s1_P0[10] D=N11 CK=clk_clone5
+ RB=FE_OFN131_i_reset_n_i
Xs1_P0_reg[9] QDFFRBN $PINS Q=s1_P0[9] D=N10 CK=clk_clone5
+ RB=FE_OFN131_i_reset_n_i
Xs1_P0_reg[7] QDFFRBN $PINS Q=N75 D=N8 CK=clk_clone5 RB=FE_OFN20_i_reset_n_i
Xs1_P0_reg[6] QDFFRBN $PINS Q=N74 D=N7 CK=clk_clone5 RB=FE_OFN20_i_reset_n_i
Xs1_P0_reg[5] QDFFRBN $PINS Q=FE_PHN3069_N73 D=N6 CK=clk_clone5
+ RB=FE_OFN176_i_reset_n_i
Xs1_P0_reg[4] QDFFRBN $PINS Q=N72 D=N5 CK=clk_clone5 RB=FE_OFN59_i_reset_n_i
Xs1_P0_reg[3] QDFFRBN $PINS Q=N71 D=N4 CK=clk_clone5 RB=FE_OFN176_i_reset_n_i
Xs1_P0_reg[2] QDFFRBN $PINS Q=FE_PHN2960_N70 D=N3 CK=clk_clone5
+ RB=FE_OFN176_i_reset_n_i
Xs1_P0_reg[1] QDFFRBN $PINS Q=FE_PHN3026_N69 D=N2 CK=clk_clone5
+ RB=FE_OFN15_i_reset_n_i
Xs1_P1_reg[15] QDFFRBN $PINS Q=s1_P1[15] D=N33 CK=clk_clone1
+ RB=FE_OFN82_i_reset_n_i
Xs1_P1_reg[14] QDFFRBN $PINS Q=s1_P1[14] D=N32 CK=clk_clone1
+ RB=FE_OFN96_i_reset_n_i
Xs1_P1_reg[13] QDFFRBN $PINS Q=s1_P1[13] D=N31 CK=clk_clone1
+ RB=FE_OFN251_i_reset_n_i
Xs1_P1_reg[12] QDFFRBN $PINS Q=s1_P1[12] D=N30 CK=clk_clone1
+ RB=FE_OFN171_i_reset_n_i
Xs1_P1_reg[11] QDFFRBN $PINS Q=s1_P1[11] D=N29 CK=clk_clone1
+ RB=FE_OFN82_i_reset_n_i
Xs1_P1_reg[10] QDFFRBN $PINS Q=s1_P1[10] D=N28 CK=clk_clone1
+ RB=FE_OFN57_i_reset_n_i
Xs1_P1_reg[9] QDFFRBN $PINS Q=s1_P1[9] D=N27 CK=clk_clone1
+ RB=FE_OFN57_i_reset_n_i
Xs1_P1_reg[8] QDFFRBN $PINS Q=s1_P1[8] D=N26 CK=clk_clone1
+ RB=FE_OFN119_i_reset_n_i
Xs1_P1_reg[7] QDFFRBN $PINS Q=s1_P1[7] D=N25 CK=clk_clone1
+ RB=FE_OFN33_i_reset_n_i
Xs1_P1_reg[6] QDFFRBN $PINS Q=s1_P1[6] D=N24 CK=clk_clone1
+ RB=FE_OFN119_i_reset_n_i
Xs1_P1_reg[5] QDFFRBN $PINS Q=s1_P1[5] D=N23 CK=clk_clone5
+ RB=FE_OFN130_i_reset_n_i
Xs1_P1_reg[4] QDFFRBN $PINS Q=s1_P1[4] D=N22 CK=clk_clone5
+ RB=FE_OFN130_i_reset_n_i
Xs1_P1_reg[3] QDFFRBN $PINS Q=s1_P1[3] D=N21 CK=clk_clone5
+ RB=FE_OFN130_i_reset_n_i
Xs1_P1_reg[2] QDFFRBN $PINS Q=s1_P1[2] D=N20 CK=clk_clone5
+ RB=FE_OFN83_i_reset_n_i
Xs1_P2_reg[15] QDFFRBN $PINS Q=s1_P2[15] D=N50 CK=clk_clone1
+ RB=FE_OFN96_i_reset_n_i
Xs1_P2_reg[14] QDFFRBN $PINS Q=s1_P2[14] D=N49 CK=clk_clone1
+ RB=FE_OFN251_i_reset_n_i
Xs1_P2_reg[13] QDFFRBN $PINS Q=s1_P2[13] D=N48 CK=clk_clone1
+ RB=FE_OFN251_i_reset_n_i
Xs1_P2_reg[12] QDFFRBN $PINS Q=s1_P2[12] D=N47 CK=clk_clone1
+ RB=FE_OFN251_i_reset_n_i
Xs1_P2_reg[11] QDFFRBN $PINS Q=s1_P2[11] D=N46 CK=clk_clone1
+ RB=FE_OFN82_i_reset_n_i
Xs1_P2_reg[10] QDFFRBN $PINS Q=s1_P2[10] D=N45 CK=clk_clone1
+ RB=FE_OFN57_i_reset_n_i
Xs1_P2_reg[9] QDFFRBN $PINS Q=s1_P2[9] D=N44 CK=clk_clone1
+ RB=FE_OFN57_i_reset_n_i
Xs1_P2_reg[8] QDFFRBN $PINS Q=s1_P2[8] D=N43 CK=clk_clone1
+ RB=FE_OFN33_i_reset_n_i
Xs1_P2_reg[7] QDFFRBN $PINS Q=s1_P2[7] D=N42 CK=clk_clone5
+ RB=FE_OFN222_i_reset_n_i
Xs1_P2_reg[6] QDFFRBN $PINS Q=s1_P2[6] D=N41 CK=clk_clone5
+ RB=FE_OFN222_i_reset_n_i
Xs1_P2_reg[5] QDFFRBN $PINS Q=s1_P2[5] D=N40 CK=clk_clone5
+ RB=FE_OFN222_i_reset_n_i
Xs1_P2_reg[4] QDFFRBN $PINS Q=s1_P2[4] D=N39 CK=clk_clone5
+ RB=FE_OFN222_i_reset_n_i
Xs1_P2_reg[3] QDFFRBN $PINS Q=s1_P2[3] D=N38 CK=clk_clone5
+ RB=FE_OFN131_i_reset_n_i
Xs1_P2_reg[2] QDFFRBN $PINS Q=s1_P2[2] D=N37 CK=clk_clone5
+ RB=FE_OFN131_i_reset_n_i
Xs1_P3_reg[15] QDFFRBN $PINS Q=s1_P3[15] D=N67 CK=clk RB=FE_OFN54_i_reset_n_i
Xs1_P3_reg[14] QDFFRBN $PINS Q=s1_P3[14] D=N66 CK=clk RB=FE_OFN79_i_reset_n_i
Xs1_P3_reg[13] QDFFRBN $PINS Q=s1_P3[13] D=N65 CK=clk RB=FE_OFN80_i_reset_n_i
Xs1_P3_reg[12] QDFFRBN $PINS Q=s1_P3[12] D=N64 CK=clk RB=FE_OFN80_i_reset_n_i
Xs1_P3_reg[11] QDFFRBN $PINS Q=s1_P3[11] D=N63 CK=clk_clone2
+ RB=FE_OFN80_i_reset_n_i
Xs1_P3_reg[10] QDFFRBN $PINS Q=s1_P3[10] D=N62 CK=clk_clone2
+ RB=FE_OFN214_i_reset_n_i
Xs1_P3_reg[9] QDFFRBN $PINS Q=s1_P3[9] D=N61 CK=clk_clone2
+ RB=FE_OFN214_i_reset_n_i
Xs1_P3_reg[8] QDFFRBN $PINS Q=s1_P3[8] D=N60 CK=clk_clone1
+ RB=FE_OFN96_i_reset_n_i
Xs1_P3_reg[7] QDFFRBN $PINS Q=s1_P3[7] D=N59 CK=clk_clone1
+ RB=FE_OFN96_i_reset_n_i
Xs1_P3_reg[6] QDFFRBN $PINS Q=s1_P3[6] D=N58 CK=clk_clone1
+ RB=FE_OFN82_i_reset_n_i
Xs1_P3_reg[5] QDFFRBN $PINS Q=s1_P3[5] D=N57 CK=clk_clone1
+ RB=FE_OFN251_i_reset_n_i
Xs1_P3_reg[4] QDFFRBN $PINS Q=s1_P3[4] D=N56 CK=clk_clone1
+ RB=FE_OFN251_i_reset_n_i
Xs1_P3_reg[3] QDFFRBN $PINS Q=s1_P3[3] D=N55 CK=clk_clone1
+ RB=FE_OFN82_i_reset_n_i
Xs1_P3_reg[2] QDFFRBN $PINS Q=s1_P3[2] D=N54 CK=clk_clone1
+ RB=FE_OFN171_i_reset_n_i
Xs1_P3_reg[0] QDFFRBN $PINS Q=s1_P3[0] D=N52 CK=clk_clone1
+ RB=FE_OFN33_i_reset_n_i
Xs2_result_reg[31] QDFFRBN $PINS Q=result[31] D=N99 CK=clk_clone2
+ RB=FE_OFN52_i_reset_n_i
Xs2_result_reg[30] QDFFRBN $PINS Q=result[30] D=N98 CK=clk_clone2
+ RB=FE_OFN52_i_reset_n_i
Xs2_result_reg[29] QDFFRBN $PINS Q=result[29] D=N97 CK=clk_clone2
+ RB=FE_OFN52_i_reset_n_i
Xs2_result_reg[28] QDFFRBN $PINS Q=result[28] D=N96 CK=clk_clone2
+ RB=FE_OFN75_i_reset_n_i
Xs2_result_reg[27] QDFFRBN $PINS Q=result[27] D=N95 CK=clk_clone2
+ RB=FE_OFN75_i_reset_n_i
Xs2_result_reg[26] QDFFRBN $PINS Q=result[26] D=N94 CK=clk_clone2
+ RB=FE_OFN95_i_reset_n_i
Xs2_result_reg[25] QDFFRBN $PINS Q=result[25] D=N93 CK=clk_clone2
+ RB=FE_OFN95_i_reset_n_i
Xs2_result_reg[24] QDFFRBN $PINS Q=result[24] D=N92 CK=clk_clone2
+ RB=FE_OFN95_i_reset_n_i
Xs2_result_reg[23] QDFFRBN $PINS Q=result[23] D=N91 CK=clk_clone2
+ RB=FE_OFN95_i_reset_n_i
Xs2_result_reg[22] QDFFRBN $PINS Q=result[22] D=N90 CK=clk_clone2
+ RB=FE_OFN55_i_reset_n_i
Xs2_result_reg[21] QDFFRBN $PINS Q=result[21] D=N89 CK=clk_clone1
+ RB=FE_OFN55_i_reset_n_i
Xs2_result_reg[20] QDFFRBN $PINS Q=result[20] D=N88 CK=clk_clone2
+ RB=FE_OFN55_i_reset_n_i
Xs2_result_reg[19] QDFFRBN $PINS Q=result[19] D=N87 CK=clk_clone1
+ RB=FE_OFN32_i_reset_n_i
Xs2_result_reg[17] QDFFRBN $PINS Q=result[17] D=N85 CK=clk_clone1
+ RB=FE_OFN32_i_reset_n_i
Xs2_result_reg[16] QDFFRBN $PINS Q=result[16] D=N84 CK=clk_clone1
+ RB=FE_OFN12_i_reset_n_i
Xs2_result_reg[15] QDFFRBN $PINS Q=result[15] D=N83 CK=clk_clone1
+ RB=FE_OFN12_i_reset_n_i
Xs2_result_reg[14] QDFFRBN $PINS Q=result[14] D=N82 CK=clk_clone1 RB=rst_n
Xs2_result_reg[13] QDFFRBN $PINS Q=result[13] D=N81 CK=clk_clone1 RB=rst_n
Xs2_result_reg[12] QDFFRBN $PINS Q=result[12] D=N80 CK=clk_clone1 RB=rst_n
Xs2_result_reg[11] QDFFRBN $PINS Q=result[11] D=N79 CK=clk_clone4
+ RB=FE_OFN18_i_reset_n_i
Xs2_result_reg[10] QDFFRBN $PINS Q=result[10] D=N78 CK=clk_clone5
+ RB=FE_OFN129_i_reset_n_i
Xs2_result_reg[9] QDFFRBN $PINS Q=result[9] D=N77 CK=clk_clone4
+ RB=FE_OFN18_i_reset_n_i
Xs2_result_reg[8] QDFFRBN $PINS Q=result[8] D=FE_PHN3093_N76 CK=clk_clone4
+ RB=FE_OFN3_i_reset_n_i
Xs2_result_reg[7] QDFFRBN $PINS Q=result[7] D=FE_PHN3101_N75 CK=clk_clone4
+ RB=FE_OFN3_i_reset_n_i
Xs2_result_reg[6] QDFFRBN $PINS Q=result[6] D=FE_PHN3092_N74 CK=clk_clone5
+ RB=FE_OFN34_i_reset_n_i
Xs2_result_reg[5] QDFFRBN $PINS Q=result[5] D=N73 CK=clk_clone5
+ RB=FE_OFN59_i_reset_n_i
Xs2_result_reg[4] QDFFRBN $PINS Q=result[4] D=FE_PHN3027_N72 CK=clk_clone5
+ RB=FE_OFN59_i_reset_n_i
Xs2_result_reg[2] QDFFRBN $PINS Q=result[2] D=N70 CK=clk_clone5
+ RB=FE_OFN176_i_reset_n_i
Xs2_result_reg[1] QDFFRBN $PINS Q=result[1] D=N69 CK=clk_clone3
+ RB=FE_OFN15_i_reset_n_i
Xs2_result_reg[0] QDFFRBN $PINS Q=result[0] D=N68 CK=clk_clone5
+ RB=FE_OFN176_i_reset_n_i
Xintadd_125/U5 FA1S $PINS S=intadd_125/SUM[0] CO=intadd_125/n4
+ A=intadd_125/B[0] B=intadd_125/A[0] CI=intadd_125/CI
Xintadd_125/U4 FA1S $PINS S=intadd_125/SUM[1] CO=intadd_125/n3
+ A=intadd_125/B[1] B=intadd_125/A[1] CI=intadd_125/n4
Xintadd_125/U3 FA1S $PINS S=intadd_125/SUM[2] CO=intadd_125/n2
+ A=intadd_125/B[2] B=intadd_125/A[2] CI=intadd_125/n3
Xintadd_125/U2 FA1S $PINS S=intadd_125/SUM[3] CO=intadd_125/n1
+ A=intadd_125/B[3] B=intadd_125/A[3] CI=intadd_125/n2
Xintadd_126/U5 FA1S $PINS S=intadd_126/SUM[0] CO=intadd_126/n4
+ A=intadd_126/B[0] B=intadd_126/A[0] CI=intadd_126/CI
Xintadd_126/U4 FA1S $PINS S=intadd_126/SUM[1] CO=intadd_126/n3
+ A=intadd_126/B[1] B=intadd_126/A[1] CI=intadd_126/n4
Xintadd_126/U3 FA1S $PINS S=intadd_126/SUM[2] CO=intadd_126/n2
+ A=intadd_126/B[2] B=intadd_126/A[2] CI=intadd_126/n3
Xintadd_126/U2 FA1S $PINS S=intadd_126/SUM[3] CO=intadd_126/n1
+ A=intadd_126/B[3] B=intadd_125/SUM[2] CI=intadd_126/n2
Xintadd_127/U5 FA1S $PINS S=intadd_127/SUM[0] CO=intadd_127/n4
+ A=intadd_127/B[0] B=intadd_127/A[0] CI=intadd_127/CI
Xintadd_127/U4 FA1S $PINS S=intadd_127/SUM[1] CO=intadd_127/n3
+ A=intadd_127/B[1] B=intadd_127/A[1] CI=intadd_127/n4
Xintadd_127/U3 FA1S $PINS S=intadd_127/SUM[2] CO=intadd_127/n2
+ A=intadd_125/SUM[0] B=intadd_127/A[2] CI=intadd_127/n3
Xintadd_127/U2 FA1S $PINS S=intadd_127/SUM[3] CO=intadd_127/n1
+ A=intadd_125/SUM[1] B=intadd_126/SUM[2] CI=intadd_127/n2
Xintadd_128/U5 FA1S $PINS S=intadd_128/SUM[0] CO=intadd_128/n4
+ A=intadd_128/B[0] B=intadd_128/A[0] CI=intadd_128/CI
Xintadd_128/U4 FA1S $PINS S=intadd_128/SUM[1] CO=intadd_128/n3
+ A=intadd_128/B[1] B=intadd_128/A[1] CI=intadd_128/n4
Xintadd_128/U3 FA1S $PINS S=intadd_128/SUM[2] CO=intadd_128/n2
+ A=intadd_128/B[2] B=intadd_128/A[2] CI=intadd_128/n3
Xintadd_128/U2 FA1S $PINS S=intadd_128/SUM[3] CO=intadd_128/n1
+ A=intadd_128/B[3] B=intadd_128/A[3] CI=intadd_128/n2
Xintadd_129/U5 FA1S $PINS S=intadd_129/SUM[0] CO=intadd_129/n4
+ A=intadd_129/B[0] B=intadd_129/A[0] CI=intadd_129/CI
Xintadd_129/U4 FA1S $PINS S=intadd_129/SUM[1] CO=intadd_129/n3
+ A=intadd_129/B[1] B=intadd_129/A[1] CI=intadd_129/n4
Xintadd_129/U3 FA1S $PINS S=intadd_129/SUM[2] CO=intadd_129/n2
+ A=intadd_129/B[2] B=intadd_129/A[2] CI=intadd_129/n3
Xintadd_129/U2 FA1S $PINS S=intadd_129/SUM[3] CO=intadd_129/n1
+ A=intadd_129/B[3] B=intadd_128/SUM[2] CI=intadd_129/n2
Xintadd_130/U5 FA1S $PINS S=intadd_130/SUM[0] CO=intadd_130/n4
+ A=intadd_130/B[0] B=intadd_130/A[0] CI=intadd_130/CI
Xintadd_130/U4 FA1S $PINS S=intadd_130/SUM[1] CO=intadd_130/n3
+ A=intadd_130/B[1] B=intadd_130/A[1] CI=intadd_130/n4
Xintadd_130/U3 FA1S $PINS S=intadd_130/SUM[2] CO=intadd_130/n2
+ A=intadd_128/SUM[0] B=intadd_130/A[2] CI=intadd_130/n3
Xintadd_130/U2 FA1S $PINS S=intadd_130/SUM[3] CO=intadd_130/n1
+ A=intadd_129/SUM[2] B=intadd_128/SUM[1] CI=intadd_130/n2
Xintadd_131/U5 FA1S $PINS S=intadd_131/SUM[0] CO=intadd_131/n4
+ A=intadd_131/B[0] B=intadd_131/A[0] CI=intadd_131/CI
Xintadd_131/U4 FA1S $PINS S=intadd_131/SUM[1] CO=intadd_131/n3
+ A=intadd_131/B[1] B=intadd_131/A[1] CI=intadd_131/n4
Xintadd_131/U3 FA1S $PINS S=intadd_131/SUM[2] CO=intadd_131/n2
+ A=intadd_131/B[2] B=intadd_131/A[2] CI=intadd_131/n3
Xintadd_131/U2 FA1S $PINS S=intadd_131/SUM[3] CO=intadd_131/n1
+ A=intadd_131/B[3] B=intadd_131/A[3] CI=intadd_131/n2
Xintadd_132/U5 FA1S $PINS S=intadd_132/SUM[0] CO=intadd_132/n4
+ A=intadd_132/B[0] B=intadd_132/A[0] CI=intadd_132/CI
Xintadd_132/U4 FA1S $PINS S=intadd_132/SUM[1] CO=intadd_132/n3
+ A=intadd_132/B[1] B=intadd_132/A[1] CI=intadd_132/n4
Xintadd_132/U3 FA1S $PINS S=intadd_132/SUM[2] CO=intadd_132/n2
+ A=intadd_132/B[2] B=intadd_132/A[2] CI=intadd_132/n3
Xintadd_132/U2 FA1S $PINS S=intadd_132/SUM[3] CO=intadd_132/n1
+ A=intadd_132/B[3] B=intadd_131/SUM[2] CI=intadd_132/n2
Xintadd_133/U5 FA1S $PINS S=intadd_133/SUM[0] CO=intadd_133/n4
+ A=intadd_133/B[0] B=intadd_133/A[0] CI=intadd_133/CI
Xintadd_133/U4 FA1S $PINS S=intadd_133/SUM[1] CO=intadd_133/n3
+ A=intadd_133/B[1] B=intadd_133/A[1] CI=intadd_133/n4
Xintadd_133/U3 FA1S $PINS S=intadd_133/SUM[2] CO=intadd_133/n2
+ A=intadd_131/SUM[0] B=intadd_133/A[2] CI=intadd_133/n3
Xintadd_133/U2 FA1S $PINS S=intadd_133/SUM[3] CO=intadd_133/n1
+ A=intadd_132/SUM[2] B=intadd_131/SUM[1] CI=intadd_133/n2
Xintadd_134/U4 FA1S $PINS S=intadd_125/A[2] CO=intadd_134/n3 A=intadd_134/B[0]
+ B=intadd_134/A[0] CI=intadd_134/CI
Xintadd_134/U3 FA1S $PINS S=intadd_125/A[3] CO=intadd_134/n2 A=intadd_134/B[1]
+ B=intadd_134/A[1] CI=intadd_134/n3
Xintadd_134/U2 FA1S $PINS S=intadd_134/SUM[2] CO=intadd_134/n1
+ A=intadd_134/B[2] B=intadd_134/A[2] CI=intadd_134/n2
Xintadd_135/U4 FA1S $PINS S=intadd_135/SUM[0] CO=intadd_135/n3
+ A=intadd_135/B[0] B=intadd_135/A[0] CI=intadd_135/CI
Xintadd_135/U3 FA1S $PINS S=intadd_135/SUM[1] CO=intadd_135/n2
+ A=intadd_126/SUM[0] B=intadd_135/A[1] CI=intadd_135/n3
Xintadd_135/U2 FA1S $PINS S=intadd_135/SUM[2] CO=intadd_135/n1
+ A=intadd_126/SUM[1] B=intadd_127/SUM[2] CI=intadd_135/n2
Xintadd_136/U4 FA1S $PINS S=intadd_136/SUM[0] CO=intadd_136/n3
+ A=intadd_136/B[0] B=intadd_136/A[0] CI=intadd_136/CI
Xintadd_136/U3 FA1S $PINS S=intadd_136/SUM[1] CO=intadd_136/n2
+ A=intadd_136/B[1] B=intadd_127/SUM[0] CI=intadd_136/n3
Xintadd_136/U2 FA1S $PINS S=intadd_136/SUM[2] CO=intadd_136/n1
+ A=intadd_127/SUM[1] B=intadd_135/SUM[1] CI=intadd_136/n2
Xintadd_137/U4 FA1S $PINS S=intadd_128/B[2] CO=intadd_137/n3 A=intadd_137/B[0]
+ B=intadd_137/A[0] CI=intadd_137/CI
Xintadd_137/U3 FA1S $PINS S=intadd_128/A[3] CO=intadd_137/n2 A=intadd_137/B[1]
+ B=intadd_137/A[1] CI=intadd_137/n3
Xintadd_137/U2 FA1S $PINS S=intadd_137/SUM[2] CO=intadd_137/n1
+ A=intadd_137/B[2] B=intadd_137/A[2] CI=intadd_137/n2
Xintadd_138/U4 FA1S $PINS S=intadd_138/SUM[0] CO=intadd_138/n3
+ A=intadd_138/B[0] B=intadd_138/A[0] CI=intadd_138/CI
Xintadd_138/U3 FA1S $PINS S=intadd_138/SUM[1] CO=intadd_138/n2
+ A=intadd_129/SUM[0] B=intadd_138/A[1] CI=intadd_138/n3
Xintadd_138/U2 FA1S $PINS S=intadd_138/SUM[2] CO=intadd_138/n1
+ A=intadd_130/SUM[2] B=intadd_129/SUM[1] CI=intadd_138/n2
Xintadd_139/U4 FA1S $PINS S=intadd_139/SUM[0] CO=intadd_139/n3
+ A=intadd_139/B[0] B=intadd_139/A[0] CI=intadd_139/CI
Xintadd_139/U3 FA1S $PINS S=intadd_139/SUM[1] CO=intadd_139/n2
+ A=intadd_130/SUM[0] B=intadd_139/A[1] CI=intadd_139/n3
Xintadd_139/U2 FA1S $PINS S=intadd_139/SUM[2] CO=intadd_139/n1
+ A=intadd_130/SUM[1] B=intadd_138/SUM[1] CI=intadd_139/n2
Xintadd_140/U4 FA1S $PINS S=intadd_131/B[2] CO=intadd_140/n3 A=intadd_140/B[0]
+ B=intadd_140/A[0] CI=intadd_140/CI
Xintadd_140/U3 FA1S $PINS S=intadd_131/A[3] CO=intadd_140/n2 A=intadd_140/B[1]
+ B=intadd_140/A[1] CI=intadd_140/n3
Xintadd_140/U2 FA1S $PINS S=intadd_140/SUM[2] CO=intadd_140/n1
+ A=intadd_140/B[2] B=intadd_140/A[2] CI=intadd_140/n2
Xintadd_141/U4 FA1S $PINS S=intadd_141/SUM[0] CO=intadd_141/n3
+ A=intadd_141/B[0] B=intadd_141/A[0] CI=intadd_141/CI
Xintadd_141/U3 FA1S $PINS S=intadd_141/SUM[1] CO=intadd_141/n2
+ A=intadd_132/SUM[0] B=intadd_141/A[1] CI=intadd_141/n3
Xintadd_141/U2 FA1S $PINS S=intadd_141/SUM[2] CO=intadd_141/n1
+ A=intadd_133/SUM[2] B=intadd_132/SUM[1] CI=intadd_141/n2
Xintadd_142/U4 FA1S $PINS S=intadd_142/SUM[0] CO=intadd_142/n3
+ A=intadd_142/B[0] B=intadd_142/A[0] CI=intadd_142/CI
Xintadd_142/U3 FA1S $PINS S=intadd_142/SUM[1] CO=intadd_142/n2
+ A=intadd_133/SUM[0] B=intadd_142/A[1] CI=intadd_142/n3
Xintadd_142/U2 FA1S $PINS S=intadd_142/SUM[2] CO=intadd_142/n1
+ A=intadd_133/SUM[1] B=intadd_141/SUM[1] CI=intadd_142/n2
Xintadd_120/U24 FA1S $PINS S=n470 CO=n471 A=N9 B=N18 CI=N35
Xintadd_120/U4 FA1 $PINS S=N96 CO=intadd_120/n3 A=intadd_120/B[20] B=s1_P3[11]
+ CI=intadd_120/n4
Xintadd_120/U3 FA1 $PINS S=N97 CO=intadd_120/n2 A=intadd_120/B[21] B=s1_P3[12]
+ CI=intadd_120/n3
Xintadd_121/U14 FA1S $PINS S=N37 CO=intadd_121/n13 A=intadd_121/B[0]
+ B=intadd_121/A[0] CI=intadd_121/CI
Xintadd_121/U13 FA1 $PINS S=N38 CO=intadd_121/n12 A=intadd_121/B[1]
+ B=intadd_121/A[1] CI=intadd_121/n13
Xintadd_121/U12 FA1 $PINS S=N39 CO=intadd_121/n11 A=intadd_121/B[2]
+ B=intadd_121/A[2] CI=intadd_121/n12
Xintadd_121/U11 FA1 $PINS S=N40 CO=intadd_121/n10 A=intadd_121/B[3]
+ B=intadd_121/A[3] CI=intadd_121/n11
Xintadd_121/U10 FA1 $PINS S=N41 CO=intadd_121/n9 A=intadd_121/B[4]
+ B=intadd_121/A[4] CI=intadd_121/n10
Xintadd_121/U9 FA1 $PINS S=N42 CO=intadd_121/n8 A=intadd_121/B[5]
+ B=intadd_142/SUM[2] CI=intadd_121/n9
Xintadd_121/U8 FA1 $PINS S=N43 CO=intadd_121/n7 A=intadd_142/n1
+ B=intadd_141/SUM[2] CI=intadd_121/n8
Xintadd_121/U7 FA1 $PINS S=N44 CO=intadd_121/n6 A=intadd_141/n1
+ B=intadd_133/SUM[3] CI=intadd_121/n7
Xintadd_121/U5 FA1 $PINS S=N46 CO=intadd_121/n4 A=intadd_132/n1
+ B=intadd_131/SUM[3] CI=intadd_121/n5
Xintadd_121/U4 FA1S $PINS S=N47 CO=intadd_121/n3 A=intadd_131/n1
+ B=intadd_140/SUM[2] CI=intadd_121/n4
Xintadd_121/U3 FA1S $PINS S=N48 CO=intadd_121/n2 A=intadd_121/B[11]
+ B=intadd_140/n1 CI=intadd_121/n3
Xintadd_122/U14 FA1S $PINS S=N20 CO=intadd_122/n13 A=intadd_122/B[0]
+ B=intadd_122/A[0] CI=intadd_122/CI
Xintadd_122/U13 FA1S $PINS S=N21 CO=intadd_122/n12 A=intadd_122/B[1]
+ B=intadd_122/A[1] CI=intadd_122/n13
Xintadd_122/U12 FA1S $PINS S=N22 CO=intadd_122/n11 A=intadd_122/B[2]
+ B=intadd_122/A[2] CI=intadd_122/n12
Xintadd_122/U11 FA1 $PINS S=N23 CO=intadd_122/n10 A=intadd_122/B[3]
+ B=intadd_122/A[3] CI=intadd_122/n11
Xintadd_122/U10 FA1 $PINS S=N24 CO=intadd_122/n9 A=intadd_122/B[4]
+ B=intadd_122/A[4] CI=intadd_122/n10
Xintadd_122/U9 FA1 $PINS S=N25 CO=intadd_122/n8 A=intadd_122/B[5]
+ B=intadd_139/SUM[2] CI=intadd_122/n9
Xintadd_122/U8 FA1 $PINS S=N26 CO=intadd_122/n7 A=intadd_139/n1
+ B=intadd_138/SUM[2] CI=intadd_122/n8
Xintadd_122/U7 FA1 $PINS S=N27 CO=intadd_122/n6 A=intadd_138/n1
+ B=intadd_130/SUM[3] CI=intadd_122/n7
Xintadd_122/U4 FA1S $PINS S=N30 CO=intadd_122/n3 A=intadd_128/n1
+ B=intadd_137/SUM[2] CI=intadd_122/n4
Xintadd_122/U3 FA1S $PINS S=N31 CO=intadd_122/n2 A=intadd_122/B[11]
+ B=intadd_137/n1 CI=intadd_122/n3
Xintadd_123/U13 FA1 $PINS S=N55 CO=intadd_123/n12 A=intadd_123/B[0]
+ B=intadd_123/A[0] CI=intadd_123/CI
Xintadd_123/U12 FA1 $PINS S=N56 CO=intadd_123/n11 A=intadd_123/B[1]
+ B=intadd_123/A[1] CI=intadd_123/n12
Xintadd_123/U11 FA1 $PINS S=N57 CO=intadd_123/n10 A=intadd_123/B[2]
+ B=intadd_123/A[2] CI=intadd_123/n11
Xintadd_123/U8 FA1 $PINS S=N60 CO=intadd_123/n7 A=intadd_123/B[5]
+ B=intadd_123/A[5] CI=intadd_123/n8
Xintadd_123/U7 FA1 $PINS S=N61 CO=intadd_123/n6 A=intadd_123/B[6]
+ B=intadd_123/A[6] CI=intadd_123/n7
Xintadd_123/U6 FA1 $PINS S=N62 CO=intadd_123/n5 A=intadd_123/B[7]
+ B=intadd_123/A[7] CI=intadd_123/n6
Xintadd_123/U5 FA1 $PINS S=N63 CO=intadd_123/n4 A=intadd_123/B[8]
+ B=intadd_123/A[8] CI=intadd_123/n5
Xintadd_124/U13 FA1S $PINS S=N3 CO=intadd_124/n12 A=intadd_124/B[0]
+ B=intadd_124/A[0] CI=intadd_124/CI
Xintadd_124/U12 FA1S $PINS S=N4 CO=intadd_124/n11 A=intadd_124/B[1]
+ B=intadd_124/A[1] CI=intadd_124/n12
Xintadd_124/U11 FA1S $PINS S=N5 CO=intadd_124/n10 A=intadd_124/B[2]
+ B=intadd_124/A[2] CI=intadd_124/n11
Xintadd_124/U10 FA1S $PINS S=N6 CO=intadd_124/n9 A=intadd_124/B[3]
+ B=intadd_124/A[3] CI=intadd_124/n10
Xintadd_124/U9 FA1S $PINS S=N7 CO=intadd_124/n8 A=intadd_124/B[4]
+ B=intadd_124/A[4] CI=intadd_124/n9
XR_85 QDFFRBN $PINS Q=intadd_120/n23 D=n471 CK=clk_clone5
+ RB=FE_OFN83_i_reset_n_i
XR_86 QDFFRBN $PINS Q=N76 D=n470 CK=clk_clone5 RB=FE_OFN129_i_reset_n_i
Xintadd_121/U2 FA1S $PINS S=N49 CO=intadd_121/n1 A=intadd_121/B[12]
+ B=intadd_121/A[12] CI=intadd_121/n2
Xintadd_124/U2 FA1S $PINS S=N14 CO=intadd_124/n1 A=intadd_134/n1
+ B=intadd_124/A[11] CI=intadd_124/n2
Xintadd_123/U2 FA1S $PINS S=N66 CO=intadd_123/n1 A=intadd_123/B[11]
+ B=intadd_123/A[11] CI=intadd_123/n2
Xintadd_122/U2 FA1S $PINS S=N32 CO=intadd_122/n1 A=intadd_122/B[12]
+ B=intadd_122/A[12] CI=intadd_122/n2
Xintadd_120/U6 FA1 $PINS S=N94 CO=intadd_120/n5 A=intadd_120/B[18] B=s1_P3[9]
+ CI=intadd_120/n6
Xintadd_122/U5 FA1 $PINS S=N29 CO=intadd_122/n4 A=intadd_129/n1
+ B=intadd_128/SUM[3] CI=intadd_122/n5
Xintadd_120/U10 FA1 $PINS S=N90 CO=intadd_120/n9 A=intadd_120/B[14]
+ B=intadd_120/A[14] CI=intadd_120/n10
Xintadd_120/U12 FA1 $PINS S=N88 CO=intadd_120/n11 A=intadd_120/B[12]
+ B=intadd_120/A[12] CI=intadd_120/n12
Xintadd_120/U14 FA1 $PINS S=N86 CO=intadd_120/n13 A=intadd_120/B[10]
+ B=intadd_120/A[10] CI=intadd_120/n14
Xintadd_120/U16 FA1 $PINS S=N84 CO=intadd_120/n15 A=intadd_120/B[8]
+ B=intadd_120/A[8] CI=intadd_120/n16
Xintadd_120/U18 FA1 $PINS S=N82 CO=intadd_120/n17 A=intadd_120/B[6]
+ B=intadd_120/A[6] CI=intadd_120/n18
Xintadd_120/U20 FA1 $PINS S=N80 CO=intadd_120/n19 A=intadd_120/B[4]
+ B=intadd_120/A[4] CI=intadd_120/n20
Xintadd_120/U21 FA1S $PINS S=N79 CO=intadd_120/n20 A=intadd_120/B[3]
+ B=intadd_120/A[3] CI=intadd_120/n21
Xintadd_122/U6 FA1 $PINS S=N28 CO=intadd_122/n5 A=intadd_130/n1
+ B=intadd_129/SUM[3] CI=intadd_122/n6
Xintadd_121/U6 FA1 $PINS S=N45 CO=intadd_121/n5 A=intadd_133/n1
+ B=intadd_132/SUM[3] CI=intadd_121/n6
Xintadd_124/U3 FA1 $PINS S=N13 CO=intadd_124/n2 A=intadd_125/n1
+ B=intadd_134/SUM[2] CI=intadd_124/n3
Xintadd_124/U4 FA1 $PINS S=N12 CO=intadd_124/n3 A=intadd_126/n1
+ B=intadd_125/SUM[3] CI=intadd_124/n4
Xintadd_124/U5 FA1 $PINS S=N11 CO=intadd_124/n4 A=intadd_127/n1
+ B=intadd_126/SUM[3] CI=intadd_124/n5
Xintadd_124/U7 FA1 $PINS S=N9 CO=intadd_124/n6 A=intadd_136/n1
+ B=intadd_135/SUM[2] CI=intadd_124/n7
Xintadd_124/U6 FA1 $PINS S=N10 CO=intadd_124/n5 A=intadd_135/n1
+ B=intadd_127/SUM[3] CI=intadd_124/n6
Xintadd_124/U8 FA1 $PINS S=N8 CO=intadd_124/n7 A=intadd_124/B[5]
+ B=intadd_136/SUM[2] CI=intadd_124/n8
Xintadd_120/U5 FA1 $PINS S=N95 CO=intadd_120/n4 A=intadd_120/B[19] B=s1_P3[10]
+ CI=intadd_120/n5
Xintadd_120/U7 FA1 $PINS S=N93 CO=intadd_120/n6 A=intadd_120/B[17]
+ B=intadd_120/A[17] CI=intadd_120/n7
Xintadd_120/U2 FA1 $PINS S=N98 CO=intadd_120/n1 A=s1_P3[13] B=intadd_120/A[22]
+ CI=intadd_120/n2
Xintadd_120/U13 FA1 $PINS S=N87 CO=intadd_120/n12 A=intadd_120/B[11]
+ B=intadd_120/A[11] CI=intadd_120/n13
Xintadd_120/U23 FA1S $PINS S=N77 CO=intadd_120/n22 A=intadd_120/B[1] B=s1_P1[1]
+ CI=intadd_120/n23
Xintadd_120/U19 FA1 $PINS S=N81 CO=intadd_120/n18 A=intadd_120/B[5]
+ B=intadd_120/A[5] CI=intadd_120/n19
Xintadd_120/U17 FA1 $PINS S=N83 CO=intadd_120/n16 A=intadd_120/B[7]
+ B=intadd_120/A[7] CI=intadd_120/n17
Xintadd_120/U15 FA1 $PINS S=N85 CO=intadd_120/n14 A=intadd_120/B[9]
+ B=intadd_120/A[9] CI=intadd_120/n15
Xintadd_120/U11 FA1 $PINS S=N89 CO=intadd_120/n10 A=intadd_120/B[13]
+ B=intadd_120/A[13] CI=intadd_120/n11
XU3 NR2 $PINS O=n445 I1=FE_DBTN88_n349 I2=n337
XU33 INV2 $PINS O=n245 I=FE_OFN842_Iy2_shift_0
XU34 MOAI1S $PINS O=n430 A1=n417 A2=n416 B1=n417 B2=n416
XU35 ND2S $PINS O=n110 I1=FE_OFN119_Ix2_shift_0 I2=B[2]
XU36 ND2S $PINS O=n119 I1=B[2] I2=FE_OFN117_Ix2_shift_1
XU38 ND2S $PINS O=n118 I1=FE_OFN119_Ix2_shift_0 I2=FE_OFN241_FE_DBTN38_n1438
XU39 ND2S $PINS O=n160 I1=B[0] I2=A[4]
XU40 ND2S $PINS O=n158 I1=B[0] I2=FE_OFN202_Ix2_shift_5
XU41 ND2S $PINS O=n132 I1=FE_OFN119_Ix2_shift_0 I2=FE_OFN120_Iy2_shift_1
XU42 ND2S $PINS O=n133 I1=FE_OFN117_Ix2_shift_1 I2=FE_OFN122_Iy2_shift_0
XU43 ND2S $PINS O=n218 I1=FE_OFN247_FE_DBTN20_Ix2_shift_12
+ I2=FE_OFN842_Iy2_shift_0
XU44 ND2S $PINS O=n104 I1=FE_OFN193_Ix2_shift_9 I2=FE_OFN842_Iy2_shift_0
XU45 ND2S $PINS O=n206 I1=A[13] I2=FE_OFN842_Iy2_shift_0
XU46 ND2S $PINS O=n97 I1=FE_OFN269_n I2=FE_OFN1685_Ix2_shift_1
XU47 ND2S $PINS O=n98 I1=FE_OFN209_Iy2_shift_9 I2=A[0]
XU48 ND2S $PINS O=n287 I1=B[12] I2=A[0]
XU50 ND2S $PINS O=n374 I1=n383 I2=n382
XU51 ND2S $PINS O=n412 I1=n417 I2=n416
XU52 ND2S $PINS O=intadd_137/A[1] I1=FE_OFN1588_Ix2_shift_15 I2=B[4]
XU53 ND3 $PINS O=n229 I1=FE_OFN189_Ix2_shift_10 I2=FE_OFN836_Iy2_shift_1
+ I3=n223
XU54 ND2S $PINS O=intadd_122/A[12] I1=A[15] I2=FE_OFN1209_n1623
XU56 FA1 $PINS S=N91 CO=intadd_120/n8 A=intadd_120/B[15] B=intadd_120/A[15]
+ CI=intadd_120/n9
XU57 MOAI1S $PINS O=n360 A1=n349 A2=n338 B1=n445 B2=n330
XU58 ND3 $PINS O=n298 I1=B[10] I2=A[1] I3=n292
XU59 ND2S $PINS O=n402 I1=FE_OFN4350_n I2=FE_OFN1653_n459
XU61 ND3 $PINS O=n124 I1=FE_OFN258_Ix2_shift_3 I2=FE_OFN122_Iy2_shift_0 I3=n170
XU63 ND2S $PINS O=n451 I1=FE_OFN4350_n I2=n432
XU64 ND2S $PINS O=n306 I1=FE_OFN965_Iy2_shift_13 I2=FE_OFN199_Ix2_shift_7
XU65 ND2S $PINS O=n100 I1=FE_OFN144_Iy2_shift_13 I2=A[1]
XU66 ND2S $PINS O=n275 I1=FE_OFN144_Iy2_shift_13 I2=FE_OFN118_Ix2_shift_0
XU67 ND2S $PINS O=n169 I1=FE_OFN258_Ix2_shift_3 I2=FE_OFN122_Iy2_shift_0
XU68 ND2S $PINS O=n102 I1=B[9] I2=FE_OFN200_Ix2_shift_7
XU69 ND2S $PINS O=n312 I1=FE_OFN173_FE_DBTN27_Iy2_shift_14
+ I2=FE_OFN199_Ix2_shift_7
XU70 ND2S $PINS O=intadd_121/A[12] I1=FE_OFN260_Iy2_shift_15
+ I2=FE_OFN199_Ix2_shift_7
XU71 ND2S $PINS O=n448 I1=FE_OFN182_n3259 I2=FE_OFN1483_FE_DBTN88_n349
XU72 ND2S $PINS O=n175 I1=FE_OFN198_Ix2_shift_7 I2=n189
XU73 ND3 $PINS O=n467 I1=n84 I2=FE_OFN193_Ix2_shift_9
+ I3=FE_OFN1442_FE_DBTN134_Iy2_shift_8
XU74 ND2S $PINS O=n106 I1=A[13] I2=FE_OFN836_Iy2_shift_1
XU75 ND2S $PINS O=n105 I1=FE_OFN174_FE_DBTN26_Ix2_shift_14
+ I2=FE_OFN842_Iy2_shift_0
XU76 ND2S $PINS O=n288 I1=FE_OFN206_Iy2_shift_11 I2=A[1]
XU77 ND3 $PINS O=n220 I1=FE_OFN4352_Ix2_shift_8 I2=FE_RN_7 I3=n227
XU78 ND2S $PINS O=n296 I1=FE_OFN209_Iy2_shift_9 I2=FE_OFN1685_Ix2_shift_1
XU79 ND2S $PINS O=n237 I1=FE_OFN143_Ix2_shift_13 I2=FE_OFN1209_n1623
XU80 ND2S $PINS O=n184 I1=A[12] I2=B[5]
XU81 ND2S $PINS O=n86 I1=B[10] I2=FE_OFN997_n166
XU82 ND2S $PINS O=n199 I1=A[12] I2=B[4]
XU83 ND2S $PINS O=n203 I1=FE_OFN247_FE_DBTN20_Ix2_shift_12 I2=FE_RN_12
XU84 ND2S $PINS O=n115 I1=B[1] I2=A[7]
XU85 ND2S $PINS O=n113 I1=A[7] I2=B[0]
XU86 ND2S $PINS O=n111 I1=A[6] I2=B[0]
XU87 ND2S $PINS O=n99 I1=FE_OFN173_FE_DBTN27_Iy2_shift_14
+ I2=FE_OFN118_Ix2_shift_0
XU88 ND2S $PINS O=n112 I1=B[1] I2=FE_OFN202_Ix2_shift_5
XU89 ND2S $PINS O=n268 I1=B[12] I2=A[4]
XU90 ND2S $PINS O=n116 I1=B[2] I2=A[6]
XU92 ND2S $PINS O=n109 I1=FE_OFN117_Ix2_shift_1 I2=FE_OFN120_Iy2_shift_1
XU95 ND2S $PINS O=n161 I1=FE_OFN120_Iy2_shift_1 I2=FE_OFN258_Ix2_shift_3
XU97 ND2S $PINS O=n84 I1=FE_RN_1 I2=FE_OFN1592_Ix2_shift_8
XU99 ND2S $PINS O=n264 I1=Iy2_shift_15 I2=FE_OFN246_FE_DBTN25_Ix2_shift_3
XU100 ND2S $PINS O=intadd_140/A[1] I1=Iy2_shift_15
+ I2=FE_OFN243_FE_DBTN31_Ix2_shift_4
XU101 ND2S $PINS O=n159 I1=FE_OFN120_Iy2_shift_1 I2=A[4]
XU102 ND2S $PINS O=n207 I1=FE_OFN247_FE_DBTN20_Ix2_shift_12
+ I2=FE_OFN836_Iy2_shift_1
XU103 ND2S $PINS O=n182 I1=FE_DBTN155_n3259 I2=B[6]
XU105 ND2S $PINS O=n270 I1=FE_OFN206_Iy2_shift_11 I2=A[4]
XU106 ND2S $PINS O=n272 I1=B[12] I2=FE_OFN204_Ix2_shift_3
XU107 ND2S $PINS O=n219 I1=A[11] I2=FE_OFN836_Iy2_shift_1
XU108 ND2S $PINS O=n194 I1=FE_OFN1588_Ix2_shift_15 I2=FE_RN_12
XU109 ND2S $PINS O=n80 I1=FE_OFN197_Ix2_shift_8 I2=FE_RN_12
XU110 ND2S $PINS O=n276 I1=B[12] I2=A[1]
XU112 ND2S $PINS O=n201 I1=A[11] I2=B[4]
XU113 ND2S $PINS O=n107 I1=FE_OFN174_FE_DBTN26_Ix2_shift_14 I2=FE_RN_7
XU114 ND2S $PINS O=n103 I1=FE_OFN197_Ix2_shift_8 I2=FE_OFN4117_Iy2_shift_1
XU116 ND2S $PINS O=n79 I1=FE_OFN189_Ix2_shift_10 I2=FE_OFN836_Iy2_shift_1
XU117 ND2S $PINS O=n226 I1=FE_OFN4352_Ix2_shift_8 I2=FE_RN_7
XU118 ND2S $PINS O=n108 I1=FE_OFN193_Ix2_shift_9 I2=FE_OFN1209_n1623
XU122 ND2S $PINS O=n251 I1=FE_OFN1295_Iy2_shift_11 I2=FE_DBTN166_n1640
XU130 ND2S $PINS O=n305 I1=FE_OFN173_FE_DBTN27_Iy2_shift_14 I2=FE_DBTN166_n1640
XU132 ND2S $PINS O=n253 I1=B[12] I2=A[5]
XU133 ND2S $PINS O=n101 I1=Iy2_shift_14 I2=FE_OFN1676_Ix2_shift_2
XU141 ND2S $PINS O=n242 I1=FE_OFN174_FE_DBTN26_Ix2_shift_14 I2=FE_OFN1209_n1623
XU142 ND2S $PINS O=n236 I1=A[14] I2=B[6]
XU146 ND2S $PINS O=n114 I1=B[1] I2=A[6]
XU150 ND2S $PINS O=intadd_120/A[16] I1=n127 I2=n89
XU151 ND2S $PINS O=intadd_120/B[17] I1=n128 I2=n90
XU152 ND2S $PINS O=n129 I1=n128 I2=n127
XU153 ND2S $PINS O=n89 I1=s1_P3[7] I2=n128
XU154 ND2S $PINS O=n127 I1=s1_P1[15] I2=s1_P2[15]
XU157 MOAI1S $PINS O=n459 A1=A[14]
+ A2=FE_OFN4162_FE_OFN1007_FE_DBTN149_Ix2_shift_13 B1=A[14]
+ B2=FE_OFN4162_FE_OFN1007_FE_DBTN149_Ix2_shift_13
XU197 INV1S $PINS O=n315 I=A[0]
XU198 MOAI1S $PINS O=FE_PHN3299_N99 A1=FE_PHN3238_intadd_120_A_22 A2=n82
+ B1=intadd_120/A[22] B2=n82
XU199 MOAI1 $PINS O=N15 A1=n175 A2=n88 B1=n175 B2=n88
XU201 NR2 $PINS O=n291 I1=FE_OFN1307_Iy2_shift_9
+ I2=FE_OFN1430_FE_DBTN141_Ix2_shift_2
XU203 ND2S $PINS O=n75 I1=FE_OFN269_n I2=FE_OFN258_Ix2_shift_3
XU204 MOAI1S $PINS O=n76 A1=n291 A2=n75 B1=n291 B2=n75
XU208 NR2 $PINS O=n297 I1=FE_OFN1443_FE_DBTN134_Iy2_shift_8
+ I2=FE_DBTN141_Ix2_shift_2
XU209 ND3 $PINS O=n289 I1=FE_OFN209_Iy2_shift_9 I2=n166 I3=n297
XU210 MOAI1S $PINS O=intadd_121/B[1] A1=n76 A2=n289 B1=n76 B2=n289
XU230 NR2 $PINS O=n223 I1=FE_OFN4171_FE_OFN1411_FE_DBTN155_n3259 I2=n245
XU231 INV1S $PINS O=n187 I=FE_OFN836_Iy2_shift_1
XU233 MOAI1S $PINS O=intadd_122/A[1] A1=n223 A2=n79 B1=n223 B2=n79
XU235 NR2 $PINS O=n222 I1=FE_OFN4280_FE_RN_2
+ I2=FE_OFN1447_FE_DBTN130_Iy2_shift_2
XU238 MOAI1S $PINS O=n81 A1=n222 A2=n80 B1=n222 B2=n80
XU239 NR2 $PINS O=n227 I1=FE_OFN4280_FE_RN_2 I2=n187
XU240 MOAI1S $PINS O=intadd_122/B[1] A1=n81 A2=n220 B1=n81 B2=n220
XU241 INV1S $PINS O=intadd_120/A[22] I=s1_P3[14]
XU244 MOAI1S $PINS O=n83 A1=FE_OFN1522_n340 A2=FE_OFN4282_FE_RN_2 B1=B[10]
+ B2=FE_OFN4282_FE_RN_2
XU245 NR2 $PINS O=n437 I1=FE_OFN1592_Ix2_shift_8 I2=FE_OFN4279_FE_RN_2
XU246 AOI22S $PINS O=n91 A1=FE_OFN1592_Ix2_shift_8 A2=n83 B1=n437
+ B2=FE_DBTN135_Iy2_shift_9
XU249 OA12 $PINS O=n92 A1=n467 B1=FE_OFN1442_FE_DBTN134_Iy2_shift_8 B2=n349
XU250 NR2 $PINS O=intadd_123/B[0] I1=n91 I2=n92
XU252 NR2 $PINS O=n121 I1=n110 I2=n109
XU253 MOAI1S $PINS O=n85 A1=n119 A2=n118 B1=n119 B2=n118
XU254 MOAI1S $PINS O=intadd_124/A[1] A1=n121 A2=n85 B1=n121 B2=n85
XU255 NR2 $PINS O=intadd_121/B[0] I1=n98 I2=n97
XU257 NR2 $PINS O=n292 I1=FE_OFN1297_Iy2_shift_11 I2=n315
XU258 MOAI1S $PINS O=intadd_121/A[1] A1=n292 A2=n86 B1=n292 B2=n86
XU260 NR2 $PINS O=n87 I1=FE_OFN967_Iy2_shift_13 I2=FE_OFN1678_Ix2_shift_2
XU262 AOI22S $PINS O=n266 A1=B[8] A2=FE_OFN200_Ix2_shift_7
+ B1=FE_OFN144_Iy2_shift_13 B2=FE_OFN1676_Ix2_shift_2
XU263 AO13S $PINS O=intadd_133/B[1] A1=n266 B1=FE_OFN199_Ix2_shift_7 B2=B[8]
+ B3=n87
XU264 NR2 $PINS O=n139 I1=FE_OFN1667_n1640 I2=FE_DBTN133_Iy2_shift_6
XU266 NR2 $PINS O=n138 I1=FE_OFN1721_n1623 I2=FE_DBTN143_Ix2_shift_5
XU268 NR2 $PINS O=n137 I1=FE_OFN1521_n308 I2=FE_RN_10
XU269 NR2 $PINS O=n135 I1=FE_OFN1520_n189 I2=FE_OFN1667_n1640
XU270 NR2 $PINS O=n134 I1=FE_OFN1521_n308 I2=FE_DBTN133_Iy2_shift_6
XU271 MAOI1 $PINS O=n88 A1=n174 A2=intadd_124/n1 B1=n174 B2=intadd_124/n1
XU272 AN2 $PINS O=intadd_120/A[2] I1=s1_P2[1] I2=s1_P0[9]
XU273 OR2 $PINS O=n128 I1=s1_P1[15] I2=s1_P2[15]
XU274 ND2S $PINS O=n90 I1=s1_P3[8] I2=n127
XU275 OAI22S $PINS O=N54 A1=n92 A2=intadd_123/B[0] B1=n91 B2=intadd_123/B[0]
XU277 MOAI1S $PINS O=n93 A1=FE_OFN1295_Iy2_shift_11 A2=FE_OFN4282_FE_RN_2
+ B1=FE_OFN1295_Iy2_shift_11 B2=FE_OFN4282_FE_RN_2
XU278 AOI22S $PINS O=n95 A1=FE_OFN1593_Ix2_shift_8 A2=n93 B1=n437 B2=n340
XU280 MOAI1S $PINS O=n440 A1=FE_OFN183_n3259 A2=FE_DBTN135_Iy2_shift_9
+ B1=FE_OFN182_n3259 B2=FE_DBTN135_Iy2_shift_9
XU281 MOAI1S $PINS O=n337 A1=A[10] A2=FE_OFN266_FE_OFN1554_n3259 B1=A[10]
+ B2=FE_OFN266_FE_OFN1554_n3259
XU282 MOAI1S $PINS O=n94 A1=FE_OFN182_n3259 A2=FE_OFN4361_n B1=FE_OFN182_n3259
+ B2=FE_OFN4361_n
XU283 AOI22S $PINS O=n96 A1=FE_OFN1483_FE_DBTN88_n349 A2=n440
+ B1=FE_OFN1542_n445 B2=n94
XU284 NR2P $PINS O=intadd_123/A[1] I1=n95 I2=n96
XU285 OAI22S $PINS O=intadd_123/A[0] A1=n96 A2=intadd_123/A[1] B1=n95
+ B2=intadd_123/A[1]
XU286 OAI22S $PINS O=N36 A1=n98 A2=intadd_121/B[0] B1=n97 B2=intadd_121/B[0]
XU287 NR2 $PINS O=intadd_141/B[0] I1=n276 I2=n275
XU288 NR2 $PINS O=intadd_133/A[1] I1=n100 I2=n99
XU289 OAI22S $PINS O=intadd_142/A[1] A1=n100 A2=intadd_133/A[1] B1=n99
+ B2=intadd_133/A[1]
XU290 NR2 $PINS O=intadd_131/A[1] I1=n102 I2=n101
XU291 OAI22S $PINS O=intadd_132/A[1] A1=n102 A2=intadd_131/A[1] B1=n101
+ B2=intadd_131/A[1]
XU293 NR2 $PINS O=intadd_122/B[0] I1=n104 I2=n103
XU294 OAI22S $PINS O=N19 A1=n104 A2=intadd_122/B[0] B1=n103 B2=intadd_122/B[0]
XU295 NR2 $PINS O=intadd_138/B[0] I1=n207 I2=n206
XU296 NR2 $PINS O=intadd_130/A[1] I1=n106 I2=n105
XU297 OAI22S $PINS O=intadd_139/A[1] A1=n106 A2=intadd_130/A[1] B1=n105
+ B2=intadd_130/A[1]
XU298 NR2 $PINS O=intadd_128/A[1] I1=n108 I2=n107
XU299 OAI22S $PINS O=intadd_129/A[1] A1=n108 A2=intadd_128/A[1] B1=n107
+ B2=intadd_128/A[1]
XU300 OAI22S $PINS O=intadd_124/A[0] A1=n110 A2=n121 B1=n109 B2=n121
XU301 NR2 $PINS O=intadd_135/A[0] I1=n159 I2=n158
XU302 NR2 $PINS O=intadd_127/B[1] I1=n112 I2=n111
XU303 OAI22S $PINS O=intadd_136/B[1] A1=n112 A2=intadd_127/B[1] B1=n111
+ B2=intadd_127/B[1]
XU304 NR2 $PINS O=n154 I1=n114 I2=n113
XU305 OAI22S $PINS O=intadd_127/A[1] A1=n114 A2=n154 B1=n113 B2=n154
XU306 NR2 $PINS O=intadd_125/B[1] I1=n116 I2=n115
XU307 OAI22S $PINS O=intadd_126/A[1] A1=n116 A2=intadd_125/B[1] B1=n115
+ B2=intadd_125/B[1]
XU308 NR2 $PINS O=n117 I1=s1_P0[9] I2=s1_P2[1]
XU309 NR2 $PINS O=intadd_120/B[1] I1=n117 I2=intadd_120/A[2]
XU310 MOAI1S $PINS O=n125 A1=n161 A2=n160 B1=n161 B2=n160
XU311 NR2 $PINS O=n170 I1=n187 I2=FE_OFN1677_Ix2_shift_2
XU312 NR2 $PINS O=n120 I1=n119 I2=n118
XU313 NR2 $PINS O=n123 I1=n121 I2=n120
XU314 INV1S $PINS O=intadd_124/A[2] I=n122
XU315 FA1S $PINS S=n122 CO=n126 A=n125 B=n124 CI=n123
XU316 INV1S $PINS O=intadd_124/B[3] I=n126
XU317 INV1S $PINS O=intadd_120/A[17] I=s1_P3[9]
XU318 MAO222 $PINS O=intadd_120/A[15] A1=s1_P2[14] B1=s1_P1[14] C1=s1_P3[6]
XU319 MAO222 $PINS O=intadd_120/A[14] A1=s1_P2[13] B1=s1_P1[13] C1=s1_P3[5]
XU320 MAO222 $PINS O=intadd_120/A[13] A1=s1_P2[12] B1=s1_P1[12] C1=s1_P3[4]
XU321 MAO222 $PINS O=intadd_120/A[12] A1=s1_P2[11] B1=s1_P1[11] C1=s1_P3[3]
XU322 MAO222 $PINS O=intadd_120/A[11] A1=s1_P2[10] B1=s1_P1[10] C1=s1_P3[2]
XU323 MAO222 $PINS O=intadd_120/A[10] A1=s1_P2[9] B1=s1_P1[9] C1=s1_P3[1]
XU324 MAO222 $PINS O=intadd_120/A[9] A1=s1_P2[8] B1=s1_P1[8] C1=s1_P3[0]
XU325 MAO222 $PINS O=intadd_120/A[8] A1=s1_P1[7] B1=s1_P0[15] C1=s1_P2[7]
XU326 MAO222 $PINS O=intadd_120/A[7] A1=s1_P1[6] B1=s1_P0[14] C1=s1_P2[6]
XU327 MAO222 $PINS O=intadd_120/A[6] A1=s1_P1[5] B1=s1_P0[13] C1=s1_P2[5]
XU328 MAO222 $PINS O=intadd_120/A[5] A1=s1_P1[4] B1=s1_P0[12] C1=s1_P2[4]
XU329 MAO222 $PINS O=intadd_120/A[4] A1=s1_P1[3] B1=s1_P0[11] C1=s1_P2[3]
XU330 MAO222 $PINS O=intadd_120/A[3] A1=s1_P1[2] B1=s1_P0[10] C1=s1_P2[2]
XU331 INV1S $PINS O=intadd_120/B[21] I=s1_P3[13]
XU332 INV1S $PINS O=intadd_120/B[20] I=s1_P3[12]
XU333 INV1S $PINS O=intadd_120/B[19] I=s1_P3[11]
XU334 INV1S $PINS O=intadd_120/B[18] I=s1_P3[10]
XU335 XNR2HS $PINS O=intadd_120/B[16] I1=n129 I2=s1_P3[8]
XU336 XNR2HS $PINS O=intadd_120/B[15] I1=n129 I2=s1_P3[7]
XU337 XOR3 $PINS O=intadd_120/B[14] I1=s1_P3[6] I2=s1_P2[14] I3=s1_P1[14]
XU338 XOR3 $PINS O=intadd_120/B[13] I1=s1_P3[5] I2=s1_P2[13] I3=s1_P1[13]
XU339 XOR3 $PINS O=intadd_120/B[12] I1=s1_P3[4] I2=s1_P2[12] I3=s1_P1[12]
XU340 XOR3 $PINS O=intadd_120/B[11] I1=s1_P3[3] I2=s1_P2[11] I3=s1_P1[11]
XU341 XOR3 $PINS O=intadd_120/B[10] I1=s1_P3[2] I2=s1_P2[10] I3=s1_P1[10]
XU342 XOR3 $PINS O=intadd_120/B[9] I1=s1_P3[1] I2=s1_P2[9] I3=s1_P1[9]
XU343 XOR3 $PINS O=intadd_120/B[8] I1=s1_P3[0] I2=s1_P2[8] I3=s1_P1[8]
XU344 XOR3 $PINS O=intadd_120/B[7] I1=s1_P2[7] I2=s1_P1[7] I3=s1_P0[15]
XU345 XOR3 $PINS O=intadd_120/B[6] I1=s1_P2[6] I2=s1_P1[6] I3=s1_P0[14]
XU346 XOR3 $PINS O=intadd_120/B[5] I1=s1_P2[5] I2=s1_P1[5] I3=s1_P0[13]
XU347 XOR3 $PINS O=intadd_120/B[4] I1=s1_P2[4] I2=s1_P1[4] I3=s1_P0[12]
XU348 XOR3 $PINS O=intadd_120/B[3] I1=s1_P2[3] I2=s1_P1[3] I3=s1_P0[11]
XU349 XOR3 $PINS O=intadd_120/B[2] I1=s1_P2[2] I2=s1_P1[2] I3=s1_P0[10]
XU350 NR2 $PINS O=N1 I1=n245 I2=FE_OFN998_n315
XU351 NR2 $PINS O=intadd_124/CI I1=n133 I2=n132
XU352 AOI12HS $PINS O=N2 A1=intadd_124/CI B1=n133 B2=n132
XU353 FA1S $PINS S=intadd_124/A[11] CO=n174 A=n136 B=n135 CI=n134
XU354 FA1S $PINS S=intadd_134/A[2] CO=n136 A=n139 B=n138 CI=n137
XU355 NR2 $PINS O=n142 I1=FE_OFN1667_n1640 I2=FE_RN_10
XU356 NR2 $PINS O=n141 I1=FE_OFN1721_n1623 I2=Ix2_shift_4
XU357 NR2 $PINS O=n140 I1=FE_OFN1521_n308 I2=FE_DBTN167_n1627
XU358 FA1S $PINS S=intadd_134/A[1] CO=intadd_134/B[2] A=n142 B=n141 CI=n140
XU359 NR2 $PINS O=intadd_134/B[1] I1=FE_DBTN143_Ix2_shift_5
+ I2=FE_OFN1445_FE_DBTN133_Iy2_shift_6
XU360 NR2 $PINS O=intadd_134/A[0] I1=FE_OFN1667_n1640 I2=FE_DBTN167_n1627
XU361 NR2 $PINS O=intadd_134/B[0] I1=FE_RN_13 I2=FE_OFN1721_n1623
XU362 NR2 $PINS O=intadd_134/CI I1=FE_RN_8 I2=FE_OFN1521_n308
XU363 NR2 $PINS O=intadd_125/A[0] I1=FE_OFN1688_Ix2_shift_1 I2=FE_OFN1721_n1623
XU364 NR2 $PINS O=intadd_125/B[0] I1=FE_OFN1283_Ix2_shift_4
+ I2=FE_OFN272_FE_DBTN167_n1627
XU365 NR2 $PINS O=intadd_125/CI I1=FE_OFN1202_n1438 I2=FE_DBTN143_Ix2_shift_5
XU366 NR2 $PINS O=n145 I1=FE_OFN1283_Ix2_shift_4 I2=FE_OFN1246_n4486
XU367 NR2 $PINS O=n144 I1=FE_OFN1287_Ix2_shift_3
+ I2=FE_OFN1445_FE_DBTN133_Iy2_shift_6
XU368 NR2 $PINS O=n143 I1=FE_DBTN143_Ix2_shift_5 I2=FE_OFN272_FE_DBTN167_n1627
XU369 FA1S $PINS S=intadd_126/A[2] CO=intadd_125/B[2] A=n145 B=n144 CI=n143
XU370 NR2 $PINS O=intadd_126/A[0] I1=FE_OFN1687_Ix2_shift_1
+ I2=FE_OFN1445_FE_DBTN133_Iy2_shift_6
XU371 NR2 $PINS O=intadd_126/B[0] I1=n315 I2=FE_OFN1721_n1623
XU372 NR2 $PINS O=intadd_126/CI I1=FE_OFN1448_FE_DBTN130_Iy2_shift_2
+ I2=FE_DBTN143_Ix2_shift_5
XU373 NR2 $PINS O=n148 I1=FE_RN_8 I2=FE_OFN1667_n1640
XU374 NR2 $PINS O=n147 I1=FE_OFN1430_FE_DBTN141_Ix2_shift_2 I2=FE_OFN1721_n1623
XU375 NR2 $PINS O=n146 I1=FE_OFN1448_FE_DBTN130_Iy2_shift_2 I2=FE_OFN1521_n308
XU376 FA1S $PINS S=intadd_126/B[2] CO=n151 A=n148 B=n147 CI=n146
XU377 NR2 $PINS O=n150 I1=FE_OFN1283_Ix2_shift_4
+ I2=FE_OFN1445_FE_DBTN133_Iy2_shift_6
XU378 NR2 $PINS O=n149 I1=FE_DBTN143_Ix2_shift_5 I2=FE_OFN1246_n4486
XU379 FA1S $PINS S=intadd_126/B[3] CO=intadd_125/B[3] A=n151 B=n150 CI=n149
XU380 NR2 $PINS O=n153 I1=FE_DBTN141_Ix2_shift_2
+ I2=FE_OFN1445_FE_DBTN133_Iy2_shift_6
XU381 NR2 $PINS O=n152 I1=FE_OFN1287_Ix2_shift_3 I2=FE_OFN1246_n4486
XU382 FA1S $PINS S=intadd_127/A[2] CO=intadd_125/A[1] A=n154 B=n153 CI=n152
XU383 NR2 $PINS O=intadd_127/A[0] I1=FE_OFN1687_Ix2_shift_1 I2=FE_OFN1246_n4486
XU384 NR2 $PINS O=intadd_127/B[0] I1=n315 I2=FE_OFN1445_FE_DBTN133_Iy2_shift_6
XU385 NR2 $PINS O=intadd_127/CI I1=FE_OFN1448_FE_DBTN130_Iy2_shift_2
+ I2=FE_OFN1283_Ix2_shift_4
XU386 NR2 $PINS O=n157 I1=FE_DBTN141_Ix2_shift_2 I2=FE_OFN1246_n4486
XU387 NR2 $PINS O=n156 I1=FE_OFN1202_n1438 I2=FE_OFN1283_Ix2_shift_4
XU388 NR2 $PINS O=n155 I1=FE_OFN1287_Ix2_shift_3 I2=FE_OFN272_FE_DBTN167_n1627
XU389 FA1S $PINS S=intadd_135/A[1] CO=intadd_126/B[1] A=n157 B=n156 CI=n155
XU390 NR2 $PINS O=intadd_135/B[0] I1=FE_OFN1677_Ix2_shift_2
+ I2=FE_OFN272_FE_DBTN167_n1627
XU391 NR2 $PINS O=intadd_135/CI I1=FE_OFN1202_n1438 I2=FE_OFN1287_Ix2_shift_3
XU392 NR2 $PINS O=intadd_136/A[0] I1=FE_OFN1202_n1438 I2=FE_OFN1677_Ix2_shift_2
XU393 NR2 $PINS O=intadd_136/B[0] I1=FE_OFN998_n315 I2=FE_OFN1246_n4486
XU394 NR2 $PINS O=intadd_136/CI I1=FE_OFN1448_FE_DBTN130_Iy2_shift_2
+ I2=FE_OFN1287_Ix2_shift_3
XU395 OAI22S $PINS O=n165 A1=n159 A2=intadd_135/A[0] B1=n158 B2=intadd_135/A[0]
XU396 NR2 $PINS O=n164 I1=FE_OFN1687_Ix2_shift_1 I2=FE_OFN272_FE_DBTN167_n1627
XU397 NR2 $PINS O=n163 I1=n161 I2=n160
XU398 FA1S $PINS S=intadd_124/A[4] CO=intadd_124/B[5] A=intadd_136/SUM[1]
+ B=n162 CI=intadd_135/SUM[0]
XU399 FA1S $PINS S=n168 CO=n162 A=n165 B=n164 CI=n163
XU400 NR2 $PINS O=n173 I1=FE_OFN1687_Ix2_shift_1 I2=FE_OFN1202_n1438
XU401 NR2 $PINS O=n172 I1=FE_OFN998_n315 I2=FE_OFN272_FE_DBTN167_n1627
XU402 NR2 $PINS O=n171 I1=FE_OFN1448_FE_DBTN130_Iy2_shift_2
+ I2=FE_OFN1677_Ix2_shift_2
XU403 FA1S $PINS S=intadd_124/A[3] CO=intadd_124/B[4] A=n168 B=n167
+ CI=intadd_136/SUM[0]
XU404 NR2 $PINS O=intadd_124/B[0] I1=FE_OFN1677_Ix2_shift_2 I2=n245
XU405 MOAI1S $PINS O=intadd_124/B[1] A1=n170 A2=n169 B1=n170 B2=n169
XU406 FA1S $PINS S=intadd_124/B[2] CO=n167 A=n173 B=n172 CI=n171
XU407 NR2 $PINS O=n176 I1=n174 I2=intadd_124/n1
XU408 NR2 $PINS O=N16 I1=n176 I2=n175
XU409 NR2 $PINS O=n238 I1=Ix2_shift_15 I2=FE_OFN1634_n4486
XU410 INV1S $PINS O=intadd_137/A[2] I=n177
XU411 NR2 $PINS O=intadd_137/A[0] I1=FE_OFN4171_FE_OFN1411_FE_DBTN155_n3259
+ I2=FE_OFN1720_n1623
XU413 NR2 $PINS O=intadd_137/B[0]
+ I1=FE_OFN4159_FE_OFN1007_FE_DBTN149_Ix2_shift_13 I2=FE_OFN1634_n4486
XU415 NR2 $PINS O=intadd_137/CI I1=Ix2_shift_14 I2=FE_OFN271_FE_DBTN167_n1627
XU417 NR2 $PINS O=n180 I1=Ix2_shift_12 I2=FE_OFN1720_n1623
XU418 NR2 $PINS O=n179 I1=FE_OFN4159_FE_OFN1007_FE_DBTN149_Ix2_shift_13
+ I2=FE_OFN1444_FE_DBTN133_Iy2_shift_6
XU419 NR2 $PINS O=n178 I1=Ix2_shift_14 I2=FE_OFN1634_n4486
XU420 FA1S $PINS S=intadd_137/B[1] CO=intadd_137/B[2] A=n180 B=n179 CI=n178
XU421 NR2 $PINS O=n183 I1=Ix2_shift_15 I2=FE_OFN1447_FE_DBTN130_Iy2_shift_2
XU422 INV1S $PINS O=intadd_128/A[2] I=n181
XU423 NR2 $PINS O=intadd_128/A[0]
+ I1=FE_OFN4159_FE_OFN1007_FE_DBTN149_Ix2_shift_13 I2=FE_OFN1205_n1438
XU424 NR2 $PINS O=intadd_128/B[0] I1=FE_OFN4171_FE_OFN1411_FE_DBTN155_n3259
+ I2=FE_OFN1634_n4486
XU426 NR2 $PINS O=intadd_128/CI I1=FE_RN_9 I2=FE_OFN1444_FE_DBTN133_Iy2_shift_6
XU427 FA1S $PINS S=n185 CO=n181 A=n184 B=n183 CI=n182
XU428 INV1S $PINS O=intadd_129/A[2] I=n185
XU429 NR2 $PINS O=n198 I1=Ix2_shift_15 I2=n187
XU430 AOI22S $PINS O=n197 A1=A[8] A2=FE_OFN1209_n1623 B1=A[13] B2=FE_RN_7
XU431 INV1S $PINS O=intadd_129/B[2] I=n186
XU432 NR2 $PINS O=intadd_129/A[0] I1=FE_RN_2
+ I2=FE_OFN1444_FE_DBTN133_Iy2_shift_6
XU433 NR2 $PINS O=intadd_129/B[0] I1=FE_RN_9 I2=FE_OFN1245_n4486
XU434 NR2 $PINS O=intadd_129/CI I1=Ix2_shift_14 I2=n187
XU435 NR2 $PINS O=n202 I1=Ix2_shift_15 I2=n245
XU436 INV1S $PINS O=intadd_129/B[1] I=n188
XU437 NR2 $PINS O=n192 I1=FE_RN_9 I2=FE_OFN1720_n1623
XU438 NR2 $PINS O=n191 I1=FE_OFN4159_FE_OFN1007_FE_DBTN149_Ix2_shift_13
+ I2=FE_OFN271_FE_DBTN167_n1627
XU439 NR2 $PINS O=n190 I1=Ix2_shift_14 I2=FE_OFN1205_n1438
XU440 NR2 $PINS O=n195 I1=Ix2_shift_12 I2=FE_OFN1444_FE_DBTN133_Iy2_shift_6
XU441 FA1S $PINS S=intadd_128/B[1] CO=n193 A=n192 B=n191 CI=n190
XU442 FA1S $PINS S=intadd_129/B[3] CO=intadd_128/B[3] A=n195 B=n194 CI=n193
XU443 NR2 $PINS O=n196 I1=FE_OFN4159_FE_OFN1007_FE_DBTN149_Ix2_shift_13
+ I2=FE_OFN1447_FE_DBTN130_Iy2_shift_2
XU444 AO13S $PINS O=intadd_130/B[1] A1=n197 B1=FE_OFN1209_n1623
+ B2=FE_OFN1273_Ix2_shift_8 B3=n196
XU445 NR2 $PINS O=intadd_130/A[0] I1=n410 I2=FE_OFN1444_FE_DBTN133_Iy2_shift_6
XU446 NR2 $PINS O=intadd_130/B[0] I1=FE_OFN4279_FE_RN_2 I2=FE_OFN1245_n4486
XU447 NR2 $PINS O=intadd_130/CI I1=Ix2_shift_12
+ I2=FE_OFN1447_FE_DBTN130_Iy2_shift_2
XU448 FA1S $PINS S=n200 CO=n186 A=n199 B=n198 CI=n197
XU449 INV1S $PINS O=intadd_130/A[2] I=n200
XU450 NR2 $PINS O=intadd_138/A[0] I1=FE_OFN1420_FE_DBTN147_Ix2_shift_10
+ I2=FE_OFN271_FE_DBTN167_n1627
XU451 NR2 $PINS O=intadd_138/CI I1=FE_OFN4171_FE_OFN1411_FE_DBTN155_n3259
+ I2=FE_OFN1205_n1438
XU452 FA1S $PINS S=n204 CO=n188 A=n203 B=n202 CI=n201
XU453 INV1S $PINS O=intadd_138/A[1] I=n204
XU454 NR2 $PINS O=intadd_139/A[0] I1=n410 I2=FE_OFN1245_n4486
XU455 NR2 $PINS O=intadd_139/B[0] I1=FE_OFN1420_FE_DBTN147_Ix2_shift_10
+ I2=FE_OFN1205_n1438
XU456 NR2 $PINS O=intadd_139/CI I1=FE_OFN4171_FE_OFN1411_FE_DBTN155_n3259
+ I2=FE_OFN1447_FE_DBTN130_Iy2_shift_2
XU457 OAI22S $PINS O=n215 A1=n207 A2=intadd_138/B[0] B1=n206 B2=intadd_138/B[0]
XU458 NR2 $PINS O=n214 I1=n219 I2=n218
XU459 NR2 $PINS O=n213 I1=FE_OFN4280_FE_RN_2 I2=FE_OFN271_FE_DBTN167_n1627
XU460 FA1S $PINS S=intadd_122/A[4] CO=intadd_122/B[5] A=n209
+ B=intadd_139/SUM[1] CI=intadd_138/SUM[0]
XU461 NR2 $PINS O=n235 I1=FE_OFN1591_Ix2_shift_8 I2=FE_OFN271_FE_DBTN167_n1627
XU462 NR2 $PINS O=n234 I1=FE_OFN4280_FE_RN_2 I2=FE_OFN1205_n1438
XU463 NR2 $PINS O=n233 I1=FE_OFN1420_FE_DBTN147_Ix2_shift_10
+ I2=FE_OFN1447_FE_DBTN130_Iy2_shift_2
XU464 FA1S $PINS S=n216 CO=n209 A=n215 B=n214 CI=n213
XU465 FA1S $PINS S=intadd_122/A[3] CO=intadd_122/B[4] A=n217 B=n216
+ CI=intadd_139/SUM[0]
XU466 MOAI1S $PINS O=n231 A1=n219 A2=n218 B1=n219 B2=n218
XU467 INV1S $PINS O=n221 I=n220
XU468 AOI13HS $PINS O=n230 A1=n221 B1=FE_RN_12 B2=FE_OFN4352_Ix2_shift_8
+ B3=n222
XU469 INV1S $PINS O=intadd_122/B[3] I=n225
XU470 MOAI1 $PINS O=intadd_122/A[0] A1=n227 A2=n226 B1=n227 B2=n226
XU471 NR2 $PINS O=intadd_122/CI I1=FE_OFN1420_FE_DBTN147_Ix2_shift_10 I2=n245
XU472 FA1S $PINS S=n232 CO=n225 A=n231 B=n230 CI=n229
XU473 INV1S $PINS O=intadd_122/A[2] I=n232
XU474 FA1S $PINS S=intadd_122/B[2] CO=n217 A=n235 B=n234 CI=n233
XU475 FA1S $PINS S=n177 CO=n243 A=n238 B=n237 CI=n236
XU476 NR2 $PINS O=n241 I1=Ix2_shift_15 I2=FE_OFN1444_FE_DBTN133_Iy2_shift_6
XU477 INV1S $PINS O=intadd_122/B[11] I=n240
XU478 FA1S $PINS S=n240 CO=n244 A=n243 B=n242 CI=n241
XU479 INV1S $PINS O=intadd_122/B[12] I=n244
XU480 NR2 $PINS O=N18 I1=FE_OFN1591_Ix2_shift_8 I2=n245
XU481 INV1S $PINS O=N33 I=intadd_122/n1
XU483 NR2 $PINS O=n307 I1=FE_OFN1089_Iy2_shift_15
+ I2=FE_OFN1426_FE_DBTN143_Ix2_shift_5
XU484 INV1S $PINS O=intadd_140/A[2] I=n246
XU485 NR2 $PINS O=intadd_140/A[0] I1=FE_OFN1297_Iy2_shift_11
+ I2=FE_OFN1278_Ix2_shift_7
XU486 NR2 $PINS O=intadd_140/B[0] I1=FE_OFN967_Iy2_shift_13
+ I2=FE_OFN1426_FE_DBTN143_Ix2_shift_5
XU487 NR2 $PINS O=intadd_140/CI I1=FE_RN_11 I2=FE_OFN203_Ix2_shift_4
XU489 NR2 $PINS O=n249 I1=FE_OFN1216_n1668 I2=FE_OFN1278_Ix2_shift_7
XU490 NR2 $PINS O=n248 I1=FE_OFN967_Iy2_shift_13 I2=FE_OFN273_FE_DBTN166_n1640
XU491 NR2 $PINS O=n247 I1=FE_RN_11 I2=FE_OFN1426_FE_DBTN143_Ix2_shift_5
XU492 FA1S $PINS S=intadd_140/B[1] CO=intadd_140/B[2] A=n249 B=n248 CI=n247
XU493 NR2 $PINS O=n252 I1=FE_OFN1196_FE_DBTN12_Iy2_shift_15
+ I2=FE_OFN1678_Ix2_shift_2
XU494 INV1S $PINS O=intadd_131/A[2] I=n250
XU495 NR2 $PINS O=intadd_131/A[0] I1=FE_OFN967_Iy2_shift_13 I2=FE_RN_13
XU496 NR2 $PINS O=intadd_131/B[0] I1=FE_OFN1297_Iy2_shift_11
+ I2=FE_OFN1426_FE_DBTN143_Ix2_shift_5
XU497 NR2 $PINS O=intadd_131/CI I1=n340 I2=FE_OFN273_FE_DBTN166_n1640
XU498 FA1S $PINS S=n254 CO=n250 A=n253 B=n252 CI=n251
XU499 INV1S $PINS O=intadd_132/A[2] I=n254
XU500 NR2 $PINS O=n267 I1=FE_OFN1196_FE_DBTN12_Iy2_shift_15
+ I2=FE_OFN1688_Ix2_shift_1
XU501 INV1S $PINS O=intadd_132/B[2] I=n255
XU502 NR2 $PINS O=intadd_132/A[0] I1=FE_OFN1307_Iy2_shift_9
+ I2=FE_OFN273_FE_DBTN166_n1640
XU503 NR2 $PINS O=intadd_132/B[0] I1=FE_OFN207_Iy2_shift_10
+ I2=FE_OFN1427_FE_DBTN143_Ix2_shift_5
XU504 NR2 $PINS O=intadd_132/CI I1=FE_RN_11 I2=FE_OFN1688_Ix2_shift_1
XU505 NR2 $PINS O=n271 I1=FE_OFN1196_FE_DBTN12_Iy2_shift_15 I2=n315
XU506 INV1S $PINS O=intadd_132/B[1] I=n257
XU507 NR2 $PINS O=n262 I1=n340 I2=FE_OFN1278_Ix2_shift_7
XU508 NR2 $PINS O=n261 I1=FE_OFN967_Iy2_shift_13 I2=FE_OFN203_Ix2_shift_4
XU509 NR2 $PINS O=n260 I1=FE_OFN1096_Iy2_shift_14 I2=FE_OFN1607_Ix2_shift_3
XU510 NR2 $PINS O=n265 I1=FE_OFN1524_n434 I2=FE_OFN273_FE_DBTN166_n1640
XU511 FA1S $PINS S=intadd_131/B[1] CO=n263 A=n262 B=n261 CI=n260
XU512 FA1S $PINS S=intadd_132/B[3] CO=intadd_131/B[3] A=n265 B=n264 CI=n263
XU513 NR2 $PINS O=intadd_133/A[0] I1=FE_OFN1443_FE_DBTN134_Iy2_shift_8
+ I2=FE_OFN273_FE_DBTN166_n1640
XU514 NR2 $PINS O=intadd_133/B[0] I1=FE_OFN1307_Iy2_shift_9
+ I2=FE_OFN1427_FE_DBTN143_Ix2_shift_5
XU515 NR2 $PINS O=intadd_133/CI I1=FE_OFN1216_n1668 I2=FE_OFN1678_Ix2_shift_2
XU516 FA1S $PINS S=n269 CO=n255 A=n268 B=n267 CI=n266
XU517 INV1S $PINS O=intadd_133/A[2] I=n269
XU518 NR2 $PINS O=intadd_141/A[0] I1=FE_OFN207_Iy2_shift_10 I2=Ix2_shift_4
XU519 NR2 $PINS O=intadd_141/CI I1=FE_OFN1297_Iy2_shift_11 I2=FE_RN_13
XU520 FA1S $PINS S=n273 CO=n257 A=n272 B=n271 CI=n270
XU521 INV1S $PINS O=intadd_141/A[1] I=n273
XU522 NR2 $PINS O=intadd_142/A[0] I1=FE_OFN1443_FE_DBTN134_Iy2_shift_8
+ I2=FE_OFN1427_FE_DBTN143_Ix2_shift_5
XU523 NR2 $PINS O=intadd_142/B[0] I1=FE_OFN1302_Iy2_shift_10 I2=FE_RN_13
XU524 NR2 $PINS O=intadd_142/CI I1=FE_OFN1297_Iy2_shift_11
+ I2=FE_OFN1678_Ix2_shift_2
XU525 OAI22S $PINS O=n284 A1=n276 A2=intadd_141/B[0] B1=n275 B2=intadd_141/B[0]
XU526 NR2 $PINS O=n283 I1=n288 I2=n287
XU527 NR2 $PINS O=n282 I1=FE_OFN1307_Iy2_shift_9 I2=Ix2_shift_4
XU528 FA1S $PINS S=intadd_121/A[4] CO=intadd_121/B[5] A=n277
+ B=intadd_142/SUM[1] CI=intadd_141/SUM[0]
XU529 NR2 $PINS O=n304 I1=FE_OFN1443_FE_DBTN134_Iy2_shift_8 I2=Ix2_shift_4
XU530 NR2 $PINS O=n303 I1=FE_OFN1307_Iy2_shift_9 I2=FE_RN_13
XU531 NR2 $PINS O=n302 I1=FE_OFN1302_Iy2_shift_10
+ I2=FE_OFN1430_FE_DBTN141_Ix2_shift_2
XU532 FA1S $PINS S=n285 CO=n277 A=n284 B=n283 CI=n282
XU533 FA1S $PINS S=intadd_121/A[3] CO=intadd_121/B[4] A=n286 B=n285
+ CI=intadd_142/SUM[0]
XU534 MOAI1S $PINS O=n300 A1=n288 A2=n287 B1=n288 B2=n287
XU535 INV1S $PINS O=n290 I=n289
XU536 AOI13HS $PINS O=n299 A1=n290 B1=B[8] B2=n291 B3=FE_OFN204_Ix2_shift_3
XU537 INV1S $PINS O=intadd_121/B[3] I=n293
XU538 MOAI1S $PINS O=intadd_121/A[0] A1=n297 A2=n296 B1=n297 B2=n296
XU539 NR2 $PINS O=intadd_121/CI I1=FE_OFN1302_Iy2_shift_10 I2=n315
XU540 FA1S $PINS S=n301 CO=n293 A=n300 B=n299 CI=n298
XU541 INV1S $PINS O=intadd_121/A[2] I=n301
XU542 FA1S $PINS S=intadd_121/B[2] CO=n286 A=n304 B=n303 CI=n302
XU543 FA1S $PINS S=n246 CO=n313 A=n307 B=n306 CI=n305
XU544 NR2 $PINS O=n311 I1=FE_OFN1089_Iy2_shift_15 I2=FE_OFN273_FE_DBTN166_n1640
XU545 INV1S $PINS O=intadd_121/B[11] I=n310
XU546 FA1S $PINS S=n310 CO=n314 A=n313 B=n312 CI=n311
XU547 INV1S $PINS O=intadd_121/B[12] I=n314
XU548 NR2 $PINS O=N35 I1=FE_OFN1443_FE_DBTN134_Iy2_shift_8 I2=FE_OFN998_n315
XU551 OA222 $PINS O=n458 A1=FE_OFN256_Ix2_shift_13 A2=A[15]
+ B1=FE_OFN4162_FE_OFN1007_FE_DBTN149_Ix2_shift_13 B2=A[14]
+ C1=FE_OFN263_FE_OFN1078_Ix2_shift_15 C2=FE_OFN161_Ix2_shift_14
XU552 AOI22S $PINS O=n322 A1=FE_OFN1097_Iy2_shift_14 A2=FE_OFN157_Ix2_shift_15
+ B1=FE_OFN173_FE_DBTN27_Iy2_shift_14 B2=FE_OFN1588_Ix2_shift_15
XU554 MOAI1S $PINS O=n457 A1=FE_OFN1642_Iy2_shift_15 A2=FE_OFN158_Ix2_shift_15
+ B1=FE_OFN1642_Iy2_shift_15 B2=FE_OFN158_Ix2_shift_15
XU555 AOI22S $PINS O=intadd_123/A[10] A1=n458 A2=n322 B1=n459 B2=n457
XU556 INV1S $PINS O=intadd_123/A[11] I=intadd_123/A[10]
XU559 MOAI1S $PINS O=n432 A1=A[12] A2=FE_OFN4172_FE_OFN1411_FE_DBTN155_n3259
+ B1=A[12] B2=FE_OFN4172_FE_OFN1411_FE_DBTN155_n3259
XU560 MOAI1S $PINS O=n323 A1=FE_OFN1089_Iy2_shift_15 A2=FE_OFN142_Ix2_shift_13
+ B1=FE_OFN1089_Iy2_shift_15 B2=FE_OFN142_Ix2_shift_13
XU561 OA222 $PINS O=n425 A1=FE_OFN183_n3259 A2=FE_OFN142_Ix2_shift_13
+ B1=FE_OFN4172_FE_OFN1411_FE_DBTN155_n3259 B2=A[12]
+ C1=FE_OFN4160_FE_OFN1007_FE_DBTN149_Ix2_shift_13 C2=Ix2_shift_12
XU562 MOAI1S $PINS O=n331 A1=FE_OFN142_Ix2_shift_13 A2=FE_OFN1097_Iy2_shift_14
+ B1=FE_OFN142_Ix2_shift_13 B2=FE_OFN1097_Iy2_shift_14
XU563 AOI22S $PINS O=n328 A1=FE_OFN1541_n432 A2=n323 B1=FE_OFN1540_n425 B2=n331
XU565 MOAI1S $PINS O=n329 A1=FE_RN_4 A2=FE_OFN158_Ix2_shift_15 B1=FE_RN_4
+ B2=FE_OFN157_Ix2_shift_15
XU566 AOI22S $PINS O=n326 A1=n459 A2=n322 B1=n458 B2=n329
XU567 OA12 $PINS O=n325 A1=n323 B1=FE_OFN1541_n432 B2=FE_OFN1540_n425
XU568 INV1S $PINS O=intadd_123/B[10] I=n324
XU569 FA1S $PINS S=n327 CO=n324 A=n328 B=n326 CI=n325
XU570 INV1S $PINS O=intadd_123/A[9] I=n327
XU571 INV1S $PINS O=n455 I=n328
XU572 MOAI1S $PINS O=n332 A1=n434 A2=FE_OFN4163_FE_OFN1078_Ix2_shift_15 B1=n434
+ B2=FE_OFN4163_FE_OFN1078_Ix2_shift_15
XU573 AOI22S $PINS O=n454 A1=n459 A2=n329 B1=FE_OFN1525_n458 B2=n332
XU574 MOAI1S $PINS O=n338 A1=FE_OFN268_FE_OFN1554_n3259
+ A2=FE_OFN1642_Iy2_shift_15 B1=FE_OFN268_FE_OFN1554_n3259
+ B2=FE_OFN1642_Iy2_shift_15
XU575 MOAI1S $PINS O=n348 A1=FE_OFN4173_FE_OFN1411_FE_DBTN155_n3259
+ A2=FE_OFN1097_Iy2_shift_14 B1=FE_OFN4173_FE_OFN1411_FE_DBTN155_n3259
+ B2=FE_OFN1097_Iy2_shift_14
XU576 INV1S $PINS O=n330 I=n348
XU577 INV1S $PINS O=n336 I=n360
XU578 MOAI1S $PINS O=n339 A1=FE_RN_4
+ A2=FE_OFN4162_FE_OFN1007_FE_DBTN149_Ix2_shift_13 B1=FE_RN_4
+ B2=FE_OFN4162_FE_OFN1007_FE_DBTN149_Ix2_shift_13
XU579 AOI22S $PINS O=n335 A1=FE_OFN1541_n432 A2=n331 B1=FE_OFN1540_n425 B2=n339
XU580 MOAI1S $PINS O=n341 A1=n436 A2=FE_OFN157_Ix2_shift_15 B1=n436
+ B2=FE_OFN157_Ix2_shift_15
XU581 AOI22S $PINS O=n334 A1=FE_OFN1653_n459 A2=n332 B1=FE_OFN1525_n458 B2=n341
XU582 INV1S $PINS O=intadd_123/B[9] I=n333
XU583 FA1S $PINS S=n345 CO=n453 A=n336 B=n335 CI=n334
XU584 OAI22S $PINS O=n344 A1=n349 A2=n338 B1=n337 B2=n338
XU585 MOAI1S $PINS O=n352 A1=n434
+ A2=FE_OFN4162_FE_OFN1007_FE_DBTN149_Ix2_shift_13 B1=n434
+ B2=FE_OFN4160_FE_OFN1007_FE_DBTN149_Ix2_shift_13
XU586 AOI22S $PINS O=n359 A1=FE_OFN1541_n432 A2=n339 B1=FE_OFN1540_n425 B2=n352
XU587 AOI22S $PINS O=n351 A1=n340 A2=FE_OFN176_FE_DBTN21_Ix2_shift_15
+ B1=FE_OFN1522_n340 B2=FE_OFN1588_Ix2_shift_15
XU588 AOI22S $PINS O=n358 A1=FE_OFN1653_n459 A2=n341 B1=FE_OFN1525_n458 B2=n351
XU589 INV1S $PINS O=intadd_123/A[8] I=n342
XU590 FA1S $PINS S=n346 CO=n342 A=n345 B=n344 CI=n343
XU591 INV1S $PINS O=intadd_123/A[7] I=n346
XU592 MOAI1S $PINS O=n369 A1=FE_RN_4 A2=FE_OFN4173_FE_OFN1411_FE_DBTN155_n3259
+ B1=FE_RN_4 B2=FE_OFN4173_FE_OFN1411_FE_DBTN155_n3259
XU593 MOAI1S $PINS O=n367 A1=n349 A2=n348 B1=n445 B2=n369
XU594 MOAI1S $PINS O=n372 A1=FE_OFN1588_Ix2_shift_15 A2=FE_DBTN135_Iy2_shift_9
+ B1=FE_OFN1588_Ix2_shift_15 B2=FE_DBTN135_Iy2_shift_9
XU595 AO22 $PINS O=n365 A1=FE_OFN1653_n459 A2=n351 B1=FE_OFN1525_n458 B2=n372
XU596 NR2 $PINS O=n366 I1=n367 I2=n365
XU597 MOAI1S $PINS O=n373 A1=n436
+ A2=FE_OFN4160_FE_OFN1007_FE_DBTN149_Ix2_shift_13 B1=n436
+ B2=FE_OFN4160_FE_OFN1007_FE_DBTN149_Ix2_shift_13
XU598 AOI22S $PINS O=n376 A1=FE_OFN1541_n432 A2=n352 B1=n425 B2=n373
XU599 MOAI1S $PINS O=n357 A1=FE_OFN4174_FE_OFN1263_Ix2_shift_9
+ A2=FE_OFN260_Iy2_shift_15 B1=FE_OFN4174_FE_OFN1263_Ix2_shift_9
+ B2=FE_OFN260_Iy2_shift_15
XU600 NR2 $PINS O=n354 I1=FE_OFN195_Ix2_shift_8 I2=FE_OFN191_Ix2_shift_9
XU601 NR2 $PINS O=n375 I1=n357 I2=n354
XU602 MXL2HS $PINS OB=n356 S=FE_OFN1653_n459 A=Ix2_shift_14 B=FE_OFN4361_n
XU603 NR2 $PINS O=n383 I1=FE_OFN176_FE_DBTN21_Ix2_shift_15 I2=n356
XU604 MOAI1S $PINS O=n382 A1=n410 A2=n357 B1=n437 B2=FE_OFN1097_Iy2_shift_14
XU605 FA1S $PINS S=n362 CO=n343 A=n360 B=n359 CI=n358
XU606 INV1S $PINS O=intadd_123/B[7] I=n361
XU607 FA1S $PINS S=n364 CO=n361 A=n366 B=n363 CI=n362
XU608 INV1S $PINS O=intadd_123/A[6] I=n364
XU609 OAI22S $PINS O=n380 A1=n367 A2=n366 B1=n365 B2=n366
XU610 MOAI1S $PINS O=n390 A1=FE_OFN266_FE_OFN1554_n3259 A2=FE_OFN1524_n434
+ B1=FE_OFN266_FE_OFN1554_n3259 B2=FE_OFN1524_n434
XU611 AOI22S $PINS O=n393 A1=FE_DBTN88_n349 A2=n369 B1=FE_OFN1542_n445 B2=n390
XU612 MOAI1S $PINS O=n371 A1=FE_OFN4350_n A2=FE_OFN176_FE_DBTN21_Ix2_shift_15
+ B1=FE_OFN4350_n B2=FE_OFN176_FE_DBTN21_Ix2_shift_15
XU613 AOI22S $PINS O=n392 A1=FE_OFN1653_n459 A2=n372 B1=FE_OFN1525_n458 B2=n371
XU614 MOAI1S $PINS O=n399 A1=FE_OFN1522_n340
+ A2=FE_OFN1007_FE_DBTN149_Ix2_shift_13 B1=FE_OFN1522_n340
+ B2=FE_OFN1007_FE_DBTN149_Ix2_shift_13
XU615 AOI22S $PINS O=n391 A1=FE_OFN1541_n432 A2=n373 B1=n425 B2=n399
XU616 FA1S $PINS S=n378 CO=n363 A=n376 B=n375 CI=n374
XU617 INV1S $PINS O=intadd_123/B[6] I=n377
XU618 FA1S $PINS S=n381 CO=n377 A=n380 B=n379 CI=n378
XU619 INV1S $PINS O=intadd_123/A[5] I=n381
XU620 MOAI1S $PINS O=n397 A1=n383 A2=n382 B1=n383 B2=n382
XU621 MOAI1S $PINS O=n387 A1=FE_OFN4174_FE_OFN1263_Ix2_shift_9 A2=FE_RN_11
+ B1=FE_OFN4174_FE_OFN1263_Ix2_shift_9 B2=FE_RN_11
XU622 AOI22S $PINS O=n401 A1=FE_OFN195_Ix2_shift_8 A2=n387 B1=n437
+ B2=FE_OFN967_Iy2_shift_13
XU623 MOAI1S $PINS O=n420 A1=n436 A2=FE_OFN4173_FE_OFN1411_FE_DBTN155_n3259
+ B1=n436 B2=FE_OFN4173_FE_OFN1411_FE_DBTN155_n3259
XU624 AOI22S $PINS O=n400 A1=FE_OFN1483_FE_DBTN88_n349 A2=n390
+ B1=FE_OFN1542_n445 B2=n420
XU625 FA1S $PINS S=n395 CO=n379 A=n393 B=n392 CI=n391
XU626 INV1S $PINS O=intadd_123/B[5] I=n394
XU627 FA1S $PINS S=n398 CO=n394 A=n397 B=n396 CI=n395
XU628 INV1S $PINS O=intadd_123/A[4] I=n398
XU629 MOAI1S $PINS O=n426 A1=FE_RN_1 A2=FE_OFN1007_FE_DBTN149_Ix2_shift_13
+ B1=FE_RN_1 B2=FE_OFN1007_FE_DBTN149_Ix2_shift_13
XU630 AOI22S $PINS O=n414 A1=n432 A2=n399 B1=n425 B2=n426
XU631 FA1S $PINS S=n413 CO=n396 A=n402 B=n401 CI=n400
XU633 MXL2HS $PINS OB=n405 S=n432 A=Ix2_shift_12 B=FE_OFN4361_n
XU634 NR2 $PINS O=n417 I1=FE_OFN4161_FE_OFN1007_FE_DBTN149_Ix2_shift_13 I2=n405
XU635 MOAI1S $PINS O=n409 A1=FE_OFN4174_FE_OFN1263_Ix2_shift_9
+ A2=FE_OFN965_Iy2_shift_13 B1=FE_OFN4174_FE_OFN1263_Ix2_shift_9
+ B2=FE_OFN965_Iy2_shift_13
XU636 MOAI1S $PINS O=n416 A1=n410 A2=n409 B1=n437 B2=FE_OFN1524_n434
XU637 INV1S $PINS O=intadd_123/B[4] I=n411
XU638 FA1S $PINS S=n415 CO=n411 A=n414 B=n413 CI=n412
XU639 INV1S $PINS O=intadd_123/A[3] I=n415
XU640 MOAI1S $PINS O=n441 A1=FE_OFN1522_n340 A2=FE_OFN1411_FE_DBTN155_n3259
+ B1=FE_OFN1522_n340 B2=FE_OFN1411_FE_DBTN155_n3259
XU641 AOI22S $PINS O=n429 A1=FE_OFN1483_FE_DBTN88_n349 A2=n420
+ B1=FE_OFN1542_n445 B2=n441
XU642 MOAI1S $PINS O=n424 A1=FE_OFN4350_n
+ A2=FE_OFN4161_FE_OFN1007_FE_DBTN149_Ix2_shift_13 B1=FE_OFN4350_n
+ B2=FE_OFN4161_FE_OFN1007_FE_DBTN149_Ix2_shift_13
XU643 AOI22S $PINS O=n428 A1=n432 A2=n426 B1=n425 B2=n424
XU644 INV1S $PINS O=intadd_123/B[3] I=n427
XU645 FA1S $PINS S=n431 CO=n427 A=n430 B=n429 CI=n428
XU646 INV1S $PINS O=intadd_123/A[2] I=n431
XU647 MOAI1S $PINS O=n438 A1=FE_OFN4176_FE_OFN1263_Ix2_shift_9
+ A2=FE_OFN1524_n434 B1=FE_OFN4176_FE_OFN1263_Ix2_shift_9 B2=FE_OFN1524_n434
XU648 AOI22S $PINS O=n450 A1=FE_OFN195_Ix2_shift_8 A2=n438 B1=n437
+ B2=FE_OFN1297_Iy2_shift_11
XU649 AOI22S $PINS O=n449 A1=FE_OFN1483_FE_DBTN88_n349 A2=n441
+ B1=FE_OFN1542_n445 B2=n440
XU650 INV1S $PINS O=intadd_123/B[2] I=n442
XU651 MOAI1S $PINS O=intadd_123/CI A1=n448 A2=FE_OFN4348_n B1=FE_OFN182_n3259
+ B2=FE_OFN1542_n445
XU652 FA1S $PINS S=n452 CO=n442 A=n451 B=n450 CI=n449
XU653 INV1S $PINS O=intadd_123/B[1] I=n452
XU654 FA1S $PINS S=n456 CO=n333 A=n455 B=n454 CI=n453
XU655 INV1S $PINS O=intadd_123/B[8] I=n456
XU656 OAI12HS $PINS O=intadd_123/B[11] A1=n457 B1=n459 B2=n458
XU657 NR2 $PINS O=N52 I1=n410 I2=FE_OFN1442_FE_DBTN134_Iy2_shift_8
XU658 NR2 $PINS O=n469 I1=N52 I2=FE_OFN4282_FE_RN_2
XU659 MOAI1S $PINS O=n466 A1=FE_RN_1 A2=FE_OFN4279_FE_RN_2 B1=FE_RN_1
+ B2=FE_OFN4279_FE_RN_2
XU660 AN2 $PINS O=n468 I1=n466 I2=FE_OFN1523_n410
XU661 OA12 $PINS O=N53 A1=n467 B1=n469 B2=n468
XU662 INV1S $PINS O=N67 I=intadd_123/n1
XU663 FA1S $PINS S=N78 CO=intadd_120/n21 A=intadd_120/B[2] B=intadd_120/A[2]
+ CI=intadd_120/n22
XU664 FA1 $PINS S=N92 CO=intadd_120/n7 A=intadd_120/B[16] B=intadd_120/A[16]
+ CI=intadd_120/n8
XU665 FA1S $PINS S=N65 CO=intadd_123/n2 A=intadd_123/B[10] B=intadd_123/A[10]
+ CI=intadd_123/n3
XU666 FA1 $PINS S=N64 CO=intadd_123/n3 A=intadd_123/B[9] B=intadd_123/A[9]
+ CI=intadd_123/n4
XU667 FA1 $PINS S=N59 CO=intadd_123/n8 A=intadd_123/B[4] B=intadd_123/A[4]
+ CI=intadd_123/n9
XU668 FA1 $PINS S=N58 CO=intadd_123/n9 A=intadd_123/B[3] B=intadd_123/A[3]
+ CI=intadd_123/n10
Xs1_P0_reg[0] QDFFRBS $PINS Q=FE_PHN3118_N68 D=N1 CK=clk_clone5
+ RB=FE_OFN176_i_reset_n_i
Xs1_P1_reg[1] QDFFRBS $PINS Q=s1_P1[1] D=N19 CK=clk_clone5
+ RB=FE_OFN83_i_reset_n_i
Xs1_P2_reg[1] QDFFRBS $PINS Q=s1_P2[1] D=N36 CK=clk_clone5
+ RB=FE_OFN131_i_reset_n_i
Xs1_P3_reg[1] QDFFRBS $PINS Q=s1_P3[1] D=N53 CK=clk_clone1
+ RB=FE_OFN171_i_reset_n_i
Xs2_result_reg[18] QDFFRBS $PINS Q=result[18] D=N86 CK=clk_clone1
+ RB=FE_OFN32_i_reset_n_i
Xs2_result_reg[3] QDFFRBS $PINS Q=result[3] D=FE_PHN3060_N71 CK=clk_clone5
+ RB=FE_OFN59_i_reset_n_i
.ENDS

.SUBCKT mult_pipe_2 rst_n A[15] A[14] A[13] A[12] A[11] A[10] A[9] A[8] A[7]
+ A[6] A[5] A[4] A[3] A[2] A[1] A[0] B[15] B[14] B[13] B[12] B[11] B[10] B[9]
+ B[8] B[7] B[6] B[5] B[4] B[3] B[2] B[1] B[0] result[31] result[30] result[29]
+ result[28] result[27] result[26] result[25] result[24] result[23] result[22]
+ result[21] result[20] result[19] result[18] result[17] result[16] result[15]
+ result[14] result[13] result[12] result[11] result[10] result[9] result[8]
+ result[7] result[6] result[5] result[4] result[3] result[2] result[1]
+ result[0] IxIy_shift_4 IyIt_shift_7 IyIt_shift_15 n4484 IxIy_shift_5 n4488
+ FE_OFN108_i_reset_n_i FE_OFN93_i_reset_n_i FE_OFN74_i_reset_n_i
+ FE_OFN70_i_reset_n_i FE_OFN51_i_reset_n_i FE_OFN48_i_reset_n_i
+ FE_OFN47_i_reset_n_i FE_OFN29_i_reset_n_i FE_OFN27_i_reset_n_i
+ FE_OFN25_i_reset_n_i FE_OFN9_i_reset_n_i FE_OFN8_i_reset_n_i
+ FE_OFN7_i_reset_n_i FE_OFN127_IxIy_shift_1 FE_OFN132_IxIy_shift_0
+ FE_OFN180_n2891 FE_OFN219_IxIy_shift_4 FE_OFN222_IxIy_shift_3 FE_OFN252_n2620
+ FE_OFN254_IxIy_shift_7 FE_OFN259_IxIy_shift_12 clk_clone1 clk
XFE_PHC3200_N99 BUF1CK $PINS O=FE_PHN3200_N99 I=N99
XFE_PHC3098_N74 DELB $PINS O=FE_PHN3098_N74 I=N74
XFE_PHC3097_N75 DELB $PINS O=FE_PHN3097_N75 I=N75
XFE_PHC3095_N71 DELB $PINS O=FE_PHN3095_N71 I=N71
XFE_PHC3089_N76 DELB $PINS O=FE_PHN3089_N76 I=N76
XFE_PHC3086_N69 DELB $PINS O=FE_PHN3086_N69 I=N69
XFE_PHC3079_N73 DELB $PINS O=FE_PHN3079_N73 I=N73
XFE_PHC3077_N70 DELB $PINS O=FE_PHN3077_N70 I=N70
XFE_PHC3065_N72 DELB $PINS O=FE_PHN3065_N72 I=N72
XFE_PHC3009_N68 DELB $PINS O=FE_PHN3009_N68 I=N68
XFE_RC_41_0 XOR2HS $PINS O=n393 I1=FE_OFN1214_n1659
+ I2=FE_OFN1167_FE_DBTN126_IxIy_shift_13
XFE_RC_125_0 INV1S $PINS O=FE_RN_64_0 I=intadd_98/n7
XFE_RC_124_0 INV1S $PINS O=FE_RN_65_0 I=intadd_118/n1
XFE_RC_122_0 ND2 $PINS O=FE_RN_67_0 I1=FE_RN_65_0 I2=intadd_110/SUM[3]
XFE_RC_121_0 OAI12HS $PINS O=FE_RN_68_0 A1=FE_RN_67_0 B1=FE_RN_65_0
+ B2=intadd_110/SUM[3]
XFE_RC_120_0 ND2S $PINS O=FE_RN_69_0 I1=FE_RN_68_0 I2=FE_RN_64_0
XFE_RC_119_0 ND2 $PINS O=FE_RN_70_0 I1=intadd_118/n1 I2=intadd_110/SUM[3]
XFE_RC_118_0 ND2 $PINS O=FE_RN_71_0 I1=FE_RN_70_0 I2=FE_RN_76_0
XFE_RC_117_0 ND2 $PINS O=FE_RN_72_0 I1=FE_RN_71_0 I2=intadd_98/n7
XFE_RC_116_0 ND2 $PINS O=N44 I1=FE_RN_72_0 I2=FE_RN_69_0
XFE_RC_115_0 INV1S $PINS O=FE_RN_73_0 I=intadd_110/SUM[3]
XFE_RC_112_0 OR2B1S $PINS O=FE_RN_76_0 I1=intadd_110/SUM[3] B1=FE_RN_65_0
XFE_RC_111_0 ND2 $PINS O=FE_RN_77_0 I1=FE_RN_76_0 I2=intadd_98/n7
XFE_RC_110_0 OAI12H $PINS O=intadd_98/n6 A1=FE_RN_77_0 B1=FE_RN_65_0
+ B2=FE_RN_73_0
XFE_RC_94_0 INV1S $PINS O=FE_RN_38_0 I=intadd_98/n6
XFE_RC_93_0 INV1S $PINS O=FE_RN_39_0 I=intadd_110/n1
XFE_RC_91_0 ND2S $PINS O=FE_RN_41_0 I1=FE_RN_39_0 I2=intadd_109/SUM[3]
XFE_RC_90_0 OAI12HS $PINS O=FE_RN_42_0 A1=FE_RN_41_0 B1=FE_RN_39_0
+ B2=intadd_109/SUM[3]
XFE_RC_89_0 ND2S $PINS O=FE_RN_43_0 I1=FE_RN_42_0 I2=FE_RN_38_0
XFE_RC_88_0 ND2S $PINS O=FE_RN_44_0 I1=intadd_110/n1 I2=intadd_109/SUM[3]
XFE_RC_87_0 ND2 $PINS O=FE_RN_45_0 I1=FE_RN_44_0 I2=FE_RN_50_0
XFE_RC_86_0 ND2 $PINS O=FE_RN_46_0 I1=FE_RN_45_0 I2=intadd_98/n6
XFE_RC_85_0 ND2 $PINS O=N45 I1=FE_RN_46_0 I2=FE_RN_43_0
XFE_RC_84_0 INV1S $PINS O=FE_RN_47_0 I=intadd_109/SUM[3]
XFE_RC_81_0 OR2B1S $PINS O=FE_RN_50_0 I1=intadd_109/SUM[3] B1=FE_RN_39_0
XFE_RC_80_0 ND2 $PINS O=FE_RN_51_0 I1=FE_RN_50_0 I2=intadd_98/n6
XFE_RC_79_0 OAI12H $PINS O=intadd_98/n5 A1=FE_RN_51_0 B1=FE_RN_39_0
+ B2=FE_RN_47_0
XFE_OFC2929_n2891 BUF1 $PINS O=FE_OFN4364_n I=FE_OFN2726_n2891
XFE_OFC2906_FE_DBTN126_IxIy_shift_13 BUF1 $PINS O=FE_OFN4341_n
+ I=FE_OFN1167_FE_DBTN126_IxIy_shift_13
XFE_OFC2905_FE_DBTN152_n3310 BUF1 $PINS O=FE_OFN4340_n
+ I=FE_OFN1160_FE_DBTN152_n3310
XFE_OFC2904_FE_DBTN152_n3310 BUF1 $PINS O=FE_OFN4339_n
+ I=FE_OFN1160_FE_DBTN152_n3310
XFE_OFC2897_FE_DBTN152_n3310 BUF1 $PINS O=FE_OFN4332_FE_DBTN152_n3310
+ I=FE_DBTN152_n3310
XFE_OFC2896_FE_DBTN152_n3310 BUF2CK $PINS O=FE_OFN4331_FE_DBTN152_n3310
+ I=FE_DBTN152_n3310
XFE_OFC2735_n437 BUF1CK $PINS O=FE_OFN2735_n437 I=n437
XFE_OFC2891_n190 BUF1 $PINS O=FE_OFN4326_n190 I=n190
XFE_OFC2888_FE_DBTN123_IxIy_shift_10 BUF1 $PINS O=FE_OFN4323_n
+ I=FE_OFN1454_FE_DBTN123_IxIy_shift_10
XFE_OFC2874_IyIt_shift_0 BUF2 $PINS O=FE_OFN4309_n I=FE_OFN878_IyIt_shift_0
XFE_OFC2855_FE_DBTN160_n2620 BUF1 $PINS O=FE_OFN4290_n I=FE_OFN4289_n
XFE_OFC2854_FE_DBTN160_n2620 BUF1 $PINS O=FE_OFN4289_n
+ I=FE_OFN1148_FE_DBTN160_n2620
XFE_OFC2853_FE_DBTN126_IxIy_shift_13 BUF1 $PINS O=FE_OFN4288_n
+ I=FE_OFN1169_FE_DBTN126_IxIy_shift_13
XFE_OFC2852_FE_DBTN126_IxIy_shift_13 BUF1 $PINS O=FE_OFN4287_n
+ I=FE_OFN1169_FE_DBTN126_IxIy_shift_13
XFE_OFC2726_n2891 BUF1CK $PINS O=FE_OFN2726_n2891 I=FE_OFN1223_n2891
XFE_OFC2835_n64 BUF1 $PINS O=FE_OFN4270_n64 I=n64
XFE_OFC2794_FE_OFN1118_IxIy_shift_8 BUF1 $PINS
+ O=FE_OFN4229_FE_OFN1118_IxIy_shift_8 I=FE_OFN4228_FE_OFN1118_IxIy_shift_8
XFE_OFC2793_FE_OFN1118_IxIy_shift_8 BUF1 $PINS
+ O=FE_OFN4228_FE_OFN1118_IxIy_shift_8 I=FE_OFN1118_IxIy_shift_8
XFE_OFC2789_FE_OFN1221_n2891 BUF1 $PINS O=FE_OFN4224_FE_OFN1221_n2891
+ I=FE_OFN4223_FE_OFN1221_n2891
XFE_OFC2788_FE_OFN1221_n2891 BUF1 $PINS O=FE_OFN4223_FE_OFN1221_n2891
+ I=FE_OFN1221_n2891
XFE_OFC2785_FE_OFN1381_IyIt_shift_8 BUF1 $PINS
+ O=FE_OFN4220_FE_OFN1381_IyIt_shift_8 I=FE_OFN1381_IyIt_shift_8
XFE_OFC2784_FE_OFN1381_IyIt_shift_8 BUF1 $PINS
+ O=FE_OFN4219_FE_OFN1381_IyIt_shift_8 I=FE_OFN1381_IyIt_shift_8
XFE_OFC2620_IyIt_shift_0 BUF1 $PINS O=FE_OFN878_IyIt_shift_0 I=B[0]
XFE_OFC2588_IyIt_shift_8 BUF1 $PINS O=FE_OFN4122_IyIt_shift_8
+ I=FE_OFN1379_IyIt_shift_8
XFE_OFC2587_IyIt_shift_8 BUF1 $PINS O=FE_OFN1379_IyIt_shift_8 I=B[8]
XFE_OFC2487_IyIt_shift_7 BUF1 $PINS O=FE_OFN1758_IyIt_shift_7
+ I=FE_OFN1141_IyIt_shift_7
XFE_OFC2486_IyIt_shift_7 BUF1 $PINS O=FE_OFN1192_FE_DBTN14_IyIt_shift_7
+ I=FE_RN_3
XFE_OFC2484_IyIt_shift_7 BUF1 $PINS O=FE_OFN1141_IyIt_shift_7 I=IyIt_shift_7
XFE_OFC2483_IyIt_shift_7 INV1S $PINS O=FE_RN_3 I=IyIt_shift_7
XFE_OFC2395_IyIt_shift_3 INV1S $PINS O=FE_OFN1476_FE_DBTN92_IyIt_shift_3
+ I=FE_DBTN92_IyIt_shift_3
XFE_OFC2394_IyIt_shift_3 INV1S $PINS O=FE_OFN1477_FE_DBTN92_IyIt_shift_3
+ I=FE_DBTN92_IyIt_shift_3
XFE_OFC2393_IyIt_shift_3 INV2 $PINS O=FE_DBTN92_IyIt_shift_3 I=B[3]
XFE_OFC2392_IyIt_shift_3 INV1S $PINS O=FE_OFN1386_IyIt_shift_3 I=B[3]
XFE_OFC2328_IyIt_shift_1 INV2 $PINS O=FE_OFN1705_IyIt_shift_1
+ I=FE_OFN1702_IyIt_shift_1
XFE_OFC2326_IyIt_shift_1 INV1S $PINS O=FE_OFN1703_IyIt_shift_1
+ I=FE_OFN873_IyIt_shift_1
XFE_OFC2325_IyIt_shift_1 BUF2 $PINS O=FE_OFN1702_IyIt_shift_1
+ I=FE_OFN873_IyIt_shift_1
XFE_OFC2322_IyIt_shift_1 INV1S $PINS O=FE_OFN874_IyIt_shift_1
+ I=FE_OFN873_IyIt_shift_1
XFE_OFC2321_IyIt_shift_1 INV1S $PINS O=n179 I=FE_OFN873_IyIt_shift_1
XFE_OFC2320_IyIt_shift_1 INV3 $PINS O=FE_OFN873_IyIt_shift_1 I=B[1]
XFE_OFC2303_n1659 BUF2 $PINS O=FE_OFN1696_n1659 I=FE_OFN1694_n1659
XFE_OFC2302_n1659 INV1S $PINS O=FE_OFN1695_n1659 I=FE_OFN1694_n1659
XFE_OFC2301_n1659 INV2 $PINS O=FE_OFN1694_n1659 I=FE_OFN1693_n1659
XFE_OFC2300_n1659 INV1S $PINS O=FE_OFN1693_n1659 I=FE_OFN1214_n1659
XFE_OFC2297_n1659 INV1S $PINS O=FE_OFN1214_n1659 I=B[10]
XFE_OFC2258_n424 BUF1 $PINS O=FE_OFN1682_n424 I=FE_OFN1544_n424
XFE_OFC2257_n424 BUF1 $PINS O=FE_OFN1544_n424 I=n424
XFE_OFC2143_IxIy_shift_14 INV1S $PINS O=FE_OFN1651_IxIy_shift_14 I=n346
XFE_OFC2141_IxIy_shift_14 BUF1 $PINS O=n346 I=FE_OFN973_IxIy_shift_14
XFE_OFC2139_IxIy_shift_14 BUF1 $PINS O=FE_OFN973_IxIy_shift_14 I=A[14]
XFE_OFC2121_IxIy_shift_3 INV1S $PINS O=FE_OFN1458_FE_DBTN120_IxIy_shift_3
+ I=FE_OFN1457_FE_DBTN120_IxIy_shift_3
XFE_OFC2120_IxIy_shift_3 INV1S $PINS O=FE_OFN1456_FE_DBTN120_IxIy_shift_3
+ I=FE_OFN1457_FE_DBTN120_IxIy_shift_3
XFE_OFC2119_IxIy_shift_3 INV1S $PINS O=FE_OFN1457_FE_DBTN120_IxIy_shift_3
+ I=FE_RN_2
XFE_OFC2117_IxIy_shift_3 INV1S $PINS O=FE_RN_2 I=A[3]
XFE_OFC2098_n1653 BUF1 $PINS O=FE_OFN1645_n1653 I=FE_DBTN163_n1653
XFE_OFC2097_n1653 BUF1 $PINS O=FE_OFN1644_n1653 I=FE_DBTN163_n1653
XFE_OFC2096_n1653 INV1S $PINS O=FE_OFN278_FE_DBTN163_n1653 I=FE_DBTN163_n1653
XFE_OFC2095_n1653 INV1S $PINS O=FE_DBTN163_n1653 I=A[6]
XFE_OFC1999_IxIy_shift_0 INV1S $PINS O=FE_OFN1623_IxIy_shift_0
+ I=FE_DBTN117_IxIy_shift_0
XFE_OFC1998_IxIy_shift_0 INV1S $PINS O=FE_OFN886_FE_DBTN117_IxIy_shift_0
+ I=FE_DBTN117_IxIy_shift_0
XFE_OFC1997_IxIy_shift_0 BUF2 $PINS O=FE_DBTN117_IxIy_shift_0
+ I=FE_OFN132_IxIy_shift_0
XFE_OFC1979_IxIy_shift_12 INV1S $PINS O=FE_OFN1616_IxIy_shift_12
+ I=FE_OFN1615_IxIy_shift_12
XFE_OFC1978_IxIy_shift_12 INV2 $PINS O=FE_OFN1615_IxIy_shift_12
+ I=FE_OFN259_IxIy_shift_12
XFE_OFC1974_IxIy_shift_12 INV1S $PINS O=FE_OFN980_IxIy_shift_12 I=A[12]
XFE_OFC1921_n1651 BUF1 $PINS O=FE_OFN1602_n1651 I=FE_OFN275_FE_DBTN165_n1651
XFE_OFC1920_n1651 BUF1 $PINS O=FE_OFN275_FE_DBTN165_n1651 I=FE_DBTN165_n1651
XFE_OFC1919_n1651 INV1S $PINS O=FE_OFN274_FE_DBTN165_n1651 I=FE_DBTN165_n1651
XFE_OFC1918_n1651 INV1S $PINS O=FE_DBTN165_n1651 I=A[2]
XFE_OFC1861_IxIy_shift_13 BUF1 $PINS O=FE_OFN1167_FE_DBTN126_IxIy_shift_13
+ I=FE_OFN4288_n
XFE_OFC1860_IxIy_shift_13 INV1S $PINS O=FE_OFN1169_FE_DBTN126_IxIy_shift_13
+ I=FE_DBTN126_IxIy_shift_13
XFE_OFC1858_IxIy_shift_13 BUF1 $PINS O=FE_OFN1171_FE_DBTN126_IxIy_shift_13
+ I=FE_DBTN126_IxIy_shift_13
XFE_OFC1856_IxIy_shift_13 INV1S $PINS O=FE_DBTN126_IxIy_shift_13 I=A[13]
XFE_OFC1844_n4484 BUF1 $PINS O=FE_OFN1240_n4484 I=FE_OFN1241_n4484
XFE_OFC1843_n4484 BUF1 $PINS O=FE_RN_1 I=FE_OFN1241_n4484
XFE_OFC1842_n4484 BUF1 $PINS O=FE_OFN1498_FE_DBTN29_n4484 I=n4484
XFE_OFC1840_n4484 INV2 $PINS O=FE_OFN1241_n4484 I=n4484
XFE_OFC1826_IxIy_shift_7 BUF1 $PINS O=FE_OFN1125_IxIy_shift_7
+ I=FE_OFN254_IxIy_shift_7
XFE_OFC1824_IxIy_shift_7 BUF1 $PINS O=FE_OFN1389_n252 I=A[7]
XFE_OFC1816_IxIy_shift_1 BUF1 $PINS O=FE_OFN852_IxIy_shift_1
+ I=FE_OFN127_IxIy_shift_1
XFE_OFC1815_IxIy_shift_1 INV1S $PINS O=n64 I=FE_OFN127_IxIy_shift_1
XFE_OFC1747_n2620 INV1S $PINS O=FE_OFN1147_FE_DBTN160_n2620 I=A[15]
XFE_OFC1746_n2620 INV1S $PINS O=FE_OFN1148_FE_DBTN160_n2620 I=A[15]
XFE_OFC1745_n2620 BUF1 $PINS O=FE_DBTN160_n2620 I=A[15]
XFE_OFC1736_IxIy_shift_8 INV2 $PINS O=n190 I=FE_OFN4228_FE_OFN1118_IxIy_shift_8
XFE_OFC1735_IxIy_shift_8 INV1S $PINS O=FE_OFN1118_IxIy_shift_8
+ I=FE_OFN1119_IxIy_shift_8
XFE_OFC1731_IxIy_shift_8 INV1S $PINS O=FE_OFN1119_IxIy_shift_8 I=A[8]
XFE_OFC1686_IyIt_shift_8 INV2 $PINS O=FE_OFN1381_IyIt_shift_8
+ I=FE_OFN4122_IyIt_shift_8
XFE_OFC1684_IyIt_shift_8 BUF1 $PINS O=FE_OFN1472_FE_DBTN98_IyIt_shift_8
+ I=FE_OFN4122_IyIt_shift_8
XFE_OFC1662_IxIy_shift_10 BUF1 $PINS O=FE_OFN1325_IxIy_shift_10 I=A[10]
XFE_OFC1661_IxIy_shift_10 INV1S $PINS O=FE_OFN1454_FE_DBTN123_IxIy_shift_10
+ I=A[10]
XFE_OFC1632_n3310 INV1S $PINS O=FE_DBTN152_n3310 I=A[9]
XFE_OFC1630_n3310 BUF1 $PINS O=FE_OFN1160_FE_DBTN152_n3310 I=A[9]
XFE_OFC1587_n2891 BUF1 $PINS O=FE_DBTN157_n2891 I=FE_OFN1221_n2891
XFE_OFC1585_n2891 BUF1 $PINS O=FE_OFN1223_n2891 I=FE_OFN1407_FE_DBTN157_n2891
XFE_OFC1584_n2891 INV1S $PINS O=FE_OFN1221_n2891 I=FE_OFN1407_FE_DBTN157_n2891
XFE_OFC1578_n2891 INV1S $PINS O=FE_OFN1407_FE_DBTN157_n2891 I=A[11]
XFE_OFC1541_n417 BUF1 $PINS O=FE_OFN1543_n417 I=n417
XFE_OFC1526_n451 BUF1 $PINS O=FE_OFN1528_n451 I=n451
XFE_OFC1525_n450 BUF1 $PINS O=FE_OFN1527_n450 I=n450
XFE_OFC1482_FE_DBTN87_n340 BUF1 $PINS O=FE_OFN1484_FE_DBTN87_n340
+ I=FE_DBTN87_n340
XFE_OFC1389_n462 BUF2 $PINS O=FE_OFN1391_n462 I=n462
XFE_OFC1388_n327 BUF1 $PINS O=FE_OFN1390_n327 I=n327
XFE_OFC1373_IyIt_shift_11 BUF2CK $PINS O=FE_OFN1375_IyIt_shift_11
+ I=FE_OFN1373_IyIt_shift_11
XFE_OFC1372_IyIt_shift_11 BUF1 $PINS O=FE_OFN1374_IyIt_shift_11
+ I=FE_OFN1373_IyIt_shift_11
XFE_OFC1371_IyIt_shift_11 BUF1 $PINS O=FE_OFN1373_IyIt_shift_11 I=B[11]
XFE_OFC1339_IxIy_shift_4 BUF1 $PINS O=FE_OFN1341_IxIy_shift_4
+ I=FE_OFN219_IxIy_shift_4
XFE_OFC1333_IxIy_shift_5 BUF1 $PINS O=FE_OFN1335_IxIy_shift_5
+ I=FE_OFN1334_IxIy_shift_5
XFE_OFC1332_IxIy_shift_5 BUF2 $PINS O=FE_OFN1334_IxIy_shift_5 I=IxIy_shift_5
XFE_OFC1255_n4488 INV1S $PINS O=FE_OFN1257_n4488 I=FE_OFN1255_n4488
XFE_OFC1254_n4488 INV1S $PINS O=FE_OFN1256_n4488 I=FE_OFN1255_n4488
XFE_OFC1253_n4488 INV1S $PINS O=FE_OFN1255_n4488 I=n4488
XFE_OFC1185_FE_DBTN22_IyIt_shift_15 BUF1 $PINS
+ O=FE_OFN1187_FE_DBTN22_IyIt_shift_15 I=FE_OFN1185_FE_DBTN22_IyIt_shift_15
XFE_OFC1183_FE_DBTN22_IyIt_shift_15 BUF1 $PINS
+ O=FE_OFN1185_FE_DBTN22_IyIt_shift_15 I=B[15]
XFE_OFC1172_FE_DBTN94_IyIt_shift_5 BUF1 $PINS
+ O=FE_OFN1174_FE_DBTN94_IyIt_shift_5 I=FE_DBTN94_IyIt_shift_5
XFE_OFC1171_FE_DBTN94_IyIt_shift_5 BUF1CK $PINS
+ O=FE_OFN1173_FE_DBTN94_IyIt_shift_5 I=FE_DBTN94_IyIt_shift_5
XFE_OFC1136_IyIt_shift_9 BUF1 $PINS O=FE_OFN1138_IyIt_shift_9
+ I=FE_OFN1137_IyIt_shift_9
XFE_OFC1135_IyIt_shift_9 BUF1 $PINS O=FE_OFN1137_IyIt_shift_9 I=B[9]
XFE_OFC1133_IyIt_shift_12 BUF1 $PINS O=FE_OFN1135_IyIt_shift_12 I=B[12]
XFE_OFC1130_IyIt_shift_13 BUF1CK $PINS O=FE_OFN1132_IyIt_shift_13
+ I=FE_OFN1130_IyIt_shift_13
XFE_OFC1129_IyIt_shift_13 BUF1 $PINS O=FE_OFN1131_IyIt_shift_13
+ I=FE_OFN1130_IyIt_shift_13
XFE_OFC1128_IyIt_shift_13 BUF1CK $PINS O=FE_OFN1130_IyIt_shift_13 I=B[13]
XFE_OFC1125_IyIt_shift_15 BUF1 $PINS O=FE_OFN1127_IyIt_shift_15 I=IyIt_shift_15
XFE_OFC1024_FE_DBTN101_IyIt_shift_14 INV1S $PINS
+ O=FE_OFN1026_FE_DBTN101_IyIt_shift_14 I=FE_OFN1024_FE_DBTN101_IyIt_shift_14
XFE_OFC1023_FE_DBTN101_IyIt_shift_14 INV1S $PINS
+ O=FE_OFN1025_FE_DBTN101_IyIt_shift_14 I=FE_OFN1024_FE_DBTN101_IyIt_shift_14
XFE_OFC1022_FE_DBTN101_IyIt_shift_14 INV1S $PINS
+ O=FE_OFN1024_FE_DBTN101_IyIt_shift_14 I=FE_DBTN101_IyIt_shift_14
XFE_OFC992_IyIt_shift_14 BUF1 $PINS O=FE_OFN994_IyIt_shift_14 I=B[14]
XFE_OFC291_FE_DBTN96_IyIt_shift_6 BUF1 $PINS O=FE_OFN293_FE_DBTN96_IyIt_shift_6
+ I=FE_DBTN96_IyIt_shift_6
XFE_OFC290_FE_DBTN96_IyIt_shift_6 BUF1CK $PINS
+ O=FE_OFN292_FE_DBTN96_IyIt_shift_6 I=FE_DBTN96_IyIt_shift_6
XFE_OFC242_i_reset_n_i BUF1 $PINS O=FE_OFN244_i_reset_n_i
+ I=FE_OFN93_i_reset_n_i
XFE_OFC162_i_reset_n_i BUF1 $PINS O=FE_OFN164_i_reset_n_i
+ I=FE_OFN114_i_reset_n_i
XFE_OFC147_i_reset_n_i BUF1 $PINS O=FE_OFN149_i_reset_n_i
+ I=FE_OFN48_i_reset_n_i
XFE_OFC146_i_reset_n_i BUF1 $PINS O=FE_OFN148_i_reset_n_i
+ I=FE_OFN98_i_reset_n_i
XFE_OFC143_i_reset_n_i BUF1 $PINS O=FE_OFN145_i_reset_n_i
+ I=FE_OFN47_i_reset_n_i
XFE_OFC112_i_reset_n_i BUF1 $PINS O=FE_OFN114_i_reset_n_i
+ I=FE_OFN29_i_reset_n_i
XFE_OFC96_i_reset_n_i BUF1 $PINS O=FE_OFN98_i_reset_n_i I=FE_OFN59_i_reset_n_i
XFE_OFC58_i_reset_n_i BUF1 $PINS O=FE_OFN59_i_reset_n_i I=FE_OFN8_i_reset_n_i
XFE_DBTC101_IyIt_shift_14 INV1S $PINS O=FE_DBTN101_IyIt_shift_14
+ I=FE_OFN994_IyIt_shift_14
XFE_DBTC96_IyIt_shift_6 INV1S $PINS O=FE_DBTN96_IyIt_shift_6 I=B[6]
XFE_DBTC94_IyIt_shift_5 INV1S $PINS O=FE_DBTN94_IyIt_shift_5 I=B[5]
XFE_DBTC87_n340 INV1S $PINS O=FE_DBTN87_n340 I=n340
Xs1_P0_reg[9] QDFFRBN $PINS Q=s1_P0[9] D=N10 CK=clk RB=FE_OFN74_i_reset_n_i
Xs1_P0_reg[7] QDFFRBN $PINS Q=N75 D=N8 CK=clk RB=FE_OFN93_i_reset_n_i
Xs1_P0_reg[6] QDFFRBN $PINS Q=N74 D=N7 CK=clk RB=FE_OFN93_i_reset_n_i
Xs1_P0_reg[5] QDFFRBN $PINS Q=N73 D=N6 CK=clk RB=FE_OFN108_i_reset_n_i
Xs1_P0_reg[4] QDFFRBN $PINS Q=N72 D=N5 CK=clk RB=FE_OFN108_i_reset_n_i
Xs1_P0_reg[3] QDFFRBN $PINS Q=N71 D=N4 CK=clk RB=FE_OFN108_i_reset_n_i
Xs1_P0_reg[2] QDFFRBN $PINS Q=N70 D=N3 CK=clk RB=FE_OFN93_i_reset_n_i
Xs1_P0_reg[1] QDFFRBN $PINS Q=N69 D=N2 CK=clk RB=FE_OFN108_i_reset_n_i
Xs1_P0_reg[0] QDFFRBN $PINS Q=N68 D=N1 CK=clk RB=FE_OFN244_i_reset_n_i
Xs1_P1_reg[1] QDFFRBN $PINS Q=s1_P1[1] D=N19 CK=clk RB=FE_OFN74_i_reset_n_i
Xs1_P2_reg[15] QDFFRBN $PINS Q=s1_P2[15] D=N50 CK=clk_clone1
+ RB=FE_OFN98_i_reset_n_i
Xs1_P2_reg[1] QDFFRBN $PINS Q=s1_P2[1] D=N36 CK=clk RB=FE_OFN51_i_reset_n_i
Xs1_P3_reg[15] QDFFRBN $PINS Q=s1_P3[15] D=N67 CK=clk_clone1
+ RB=FE_OFN148_i_reset_n_i
Xs1_P3_reg[14] QDFFRBN $PINS Q=s1_P3[14] D=N66 CK=clk_clone1
+ RB=FE_OFN148_i_reset_n_i
Xs1_P3_reg[13] QDFFRBN $PINS Q=s1_P3[13] D=N65 CK=clk_clone1
+ RB=FE_OFN148_i_reset_n_i
Xs1_P3_reg[12] QDFFRBN $PINS Q=s1_P3[12] D=N64 CK=clk_clone1
+ RB=FE_OFN148_i_reset_n_i
Xs1_P3_reg[11] QDFFRBN $PINS Q=s1_P3[11] D=N63 CK=clk_clone1
+ RB=FE_OFN148_i_reset_n_i
Xs1_P3_reg[10] QDFFRBN $PINS Q=s1_P3[10] D=N62 CK=clk_clone1
+ RB=FE_OFN148_i_reset_n_i
Xs1_P3_reg[9] QDFFRBN $PINS Q=s1_P3[9] D=N61 CK=clk_clone1
+ RB=FE_OFN98_i_reset_n_i
Xs1_P3_reg[8] QDFFRBN $PINS Q=s1_P3[8] D=N60 CK=clk_clone1
+ RB=FE_OFN98_i_reset_n_i
Xs1_P3_reg[7] QDFFRBN $PINS Q=s1_P3[7] D=N59 CK=clk_clone1
+ RB=FE_OFN98_i_reset_n_i
Xs2_result_reg[31] QDFFRBN $PINS Q=result[31] D=FE_PHN3200_N99 CK=clk_clone1
+ RB=FE_OFN149_i_reset_n_i
Xs2_result_reg[30] QDFFRBN $PINS Q=result[30] D=N98 CK=clk_clone1
+ RB=FE_OFN149_i_reset_n_i
Xs2_result_reg[28] QDFFRBN $PINS Q=result[28] D=N96 CK=clk_clone1
+ RB=FE_OFN149_i_reset_n_i
Xs2_result_reg[27] QDFFRBN $PINS Q=result[27] D=N95 CK=clk_clone1
+ RB=FE_OFN48_i_reset_n_i
Xs2_result_reg[26] QDFFRBN $PINS Q=result[26] D=N94 CK=clk_clone1
+ RB=FE_OFN48_i_reset_n_i
Xs2_result_reg[25] QDFFRBN $PINS Q=result[25] D=N93 CK=clk_clone1
+ RB=FE_OFN48_i_reset_n_i
Xs2_result_reg[24] QDFFRBN $PINS Q=result[24] D=N92 CK=clk_clone1
+ RB=FE_OFN27_i_reset_n_i
Xs2_result_reg[23] QDFFRBN $PINS Q=result[23] D=N91 CK=clk_clone1
+ RB=FE_OFN27_i_reset_n_i
Xs2_result_reg[22] QDFFRBN $PINS Q=result[22] D=N90 CK=clk_clone1
+ RB=FE_OFN27_i_reset_n_i
Xs2_result_reg[21] QDFFRBN $PINS Q=result[21] D=N89 CK=clk_clone1
+ RB=FE_OFN8_i_reset_n_i
Xs2_result_reg[20] QDFFRBN $PINS Q=result[20] D=N88 CK=clk_clone1
+ RB=FE_OFN27_i_reset_n_i
Xs2_result_reg[19] QDFFRBN $PINS Q=result[19] D=N87 CK=clk_clone1
+ RB=FE_OFN8_i_reset_n_i
Xs2_result_reg[18] QDFFRBN $PINS Q=result[18] D=N86 CK=clk_clone1
+ RB=FE_OFN70_i_reset_n_i
Xs2_result_reg[17] QDFFRBN $PINS Q=result[17] D=N85 CK=clk_clone1
+ RB=FE_OFN70_i_reset_n_i
Xs2_result_reg[16] QDFFRBN $PINS Q=result[16] D=N84 CK=clk_clone1
+ RB=FE_OFN145_i_reset_n_i
Xs2_result_reg[15] QDFFRBN $PINS Q=result[15] D=N83 CK=clk
+ RB=FE_OFN145_i_reset_n_i
Xs2_result_reg[13] QDFFRBN $PINS Q=result[13] D=N81 CK=clk
+ RB=FE_OFN25_i_reset_n_i
Xs2_result_reg[12] QDFFRBN $PINS Q=result[12] D=N80 CK=clk
+ RB=FE_OFN25_i_reset_n_i
Xs2_result_reg[11] QDFFRBN $PINS Q=result[11] D=N79 CK=clk
+ RB=FE_OFN25_i_reset_n_i
Xs2_result_reg[10] QDFFRBN $PINS Q=result[10] D=N78 CK=clk
+ RB=FE_OFN7_i_reset_n_i
Xs2_result_reg[9] QDFFRBN $PINS Q=result[9] D=N77 CK=clk RB=FE_OFN7_i_reset_n_i
Xs2_result_reg[8] QDFFRBN $PINS Q=result[8] D=FE_PHN3089_N76 CK=clk
+ RB=FE_OFN244_i_reset_n_i
Xs2_result_reg[7] QDFFRBN $PINS Q=result[7] D=FE_PHN3097_N75 CK=clk
+ RB=FE_OFN244_i_reset_n_i
Xs2_result_reg[6] QDFFRBN $PINS Q=result[6] D=FE_PHN3098_N74 CK=clk
+ RB=FE_OFN7_i_reset_n_i
Xs2_result_reg[5] QDFFRBN $PINS Q=result[5] D=FE_PHN3079_N73 CK=clk RB=rst_n
Xs2_result_reg[4] QDFFRBN $PINS Q=result[4] D=FE_PHN3065_N72 CK=clk
+ RB=FE_OFN108_i_reset_n_i
Xs2_result_reg[3] QDFFRBN $PINS Q=result[3] D=FE_PHN3095_N71 CK=clk RB=rst_n
Xs2_result_reg[2] QDFFRBN $PINS Q=result[2] D=FE_PHN3077_N70 CK=clk
+ RB=FE_OFN93_i_reset_n_i
Xs2_result_reg[1] QDFFRBN $PINS Q=result[1] D=FE_PHN3086_N69 CK=clk
+ RB=FE_OFN7_i_reset_n_i
Xs2_result_reg[0] QDFFRBN $PINS Q=result[0] D=FE_PHN3009_N68 CK=clk
+ RB=FE_OFN7_i_reset_n_i
Xintadd_99/U14 FA1S $PINS S=N20 CO=intadd_99/n13 A=intadd_99/B[0]
+ B=intadd_99/A[0] CI=intadd_99/CI
Xintadd_99/U13 FA1 $PINS S=N21 CO=intadd_99/n12 A=intadd_99/B[1]
+ B=intadd_99/A[1] CI=intadd_99/n13
Xintadd_99/U12 FA1 $PINS S=N22 CO=intadd_99/n11 A=intadd_99/B[2]
+ B=intadd_99/A[2] CI=intadd_99/n12
Xintadd_99/U11 FA1 $PINS S=N23 CO=intadd_99/n10 A=intadd_99/B[3]
+ B=intadd_99/A[3] CI=intadd_99/n11
Xintadd_99/U10 FA1 $PINS S=N24 CO=intadd_99/n9 A=intadd_99/B[4]
+ B=intadd_99/A[4] CI=intadd_99/n10
Xintadd_99/U9 FA1 $PINS S=N25 CO=intadd_99/n8 A=intadd_99/B[5] B=intadd_99/A[5]
+ CI=intadd_99/n9
Xintadd_99/U8 FA1 $PINS S=N26 CO=intadd_99/n7 A=intadd_116/n1 B=intadd_99/A[6]
+ CI=intadd_99/n8
Xintadd_99/U7 FA1 $PINS S=N27 CO=intadd_99/n6 A=intadd_115/n1 B=intadd_99/A[7]
+ CI=intadd_99/n7
Xintadd_99/U6 FA1 $PINS S=N28 CO=intadd_99/n5 A=intadd_107/n1 B=intadd_99/A[8]
+ CI=intadd_99/n6
Xintadd_99/U5 FA1 $PINS S=N29 CO=intadd_99/n4 A=intadd_106/n1 B=intadd_99/A[9]
+ CI=intadd_99/n5
Xintadd_99/U4 FA1 $PINS S=N30 CO=intadd_99/n3 A=intadd_105/n1 B=intadd_99/A[10]
+ CI=intadd_99/n4
Xintadd_99/U3 FA1 $PINS S=N31 CO=intadd_99/n2 A=intadd_99/B[11] B=intadd_114/n1
+ CI=intadd_99/n3
Xintadd_99/U2 FA1 $PINS S=N32 CO=intadd_99/n1 A=intadd_99/B[12]
+ B=intadd_99/A[12] CI=intadd_99/n2
Xintadd_102/U5 FA1S $PINS S=intadd_102/SUM[0] CO=intadd_102/n4
+ A=intadd_102/B[0] B=intadd_102/A[0] CI=intadd_102/CI
Xintadd_102/U4 FA1S $PINS S=intadd_102/SUM[1] CO=intadd_102/n3
+ A=intadd_102/B[1] B=intadd_102/A[1] CI=intadd_102/n4
Xintadd_102/U3 FA1S $PINS S=intadd_102/SUM[2] CO=intadd_102/n2
+ A=intadd_102/B[2] B=intadd_102/A[2] CI=intadd_102/n3
Xintadd_102/U2 FA1S $PINS S=intadd_102/SUM[3] CO=intadd_102/n1
+ A=intadd_102/B[3] B=intadd_102/A[3] CI=intadd_102/n2
Xintadd_103/U5 FA1S $PINS S=intadd_103/SUM[0] CO=intadd_103/n4
+ A=intadd_103/B[0] B=intadd_103/A[0] CI=intadd_103/CI
Xintadd_103/U4 FA1S $PINS S=intadd_103/SUM[1] CO=intadd_103/n3
+ A=intadd_103/B[1] B=intadd_103/A[1] CI=intadd_103/n4
Xintadd_103/U3 FA1S $PINS S=intadd_103/SUM[2] CO=intadd_103/n2
+ A=intadd_103/B[2] B=intadd_103/A[2] CI=intadd_103/n3
Xintadd_103/U2 FA1S $PINS S=intadd_103/SUM[3] CO=intadd_103/n1
+ A=intadd_103/B[3] B=intadd_102/SUM[2] CI=intadd_103/n2
Xintadd_104/U5 FA1S $PINS S=intadd_104/SUM[0] CO=intadd_104/n4
+ A=intadd_104/B[0] B=intadd_104/A[0] CI=intadd_104/CI
Xintadd_104/U4 FA1S $PINS S=intadd_104/SUM[1] CO=intadd_104/n3
+ A=intadd_104/B[1] B=intadd_104/A[1] CI=intadd_104/n4
Xintadd_104/U3 FA1S $PINS S=intadd_104/SUM[2] CO=intadd_104/n2
+ A=intadd_102/SUM[0] B=intadd_104/A[2] CI=intadd_104/n3
Xintadd_104/U2 FA1S $PINS S=intadd_104/SUM[3] CO=intadd_104/n1
+ A=intadd_102/SUM[1] B=intadd_103/SUM[2] CI=intadd_104/n2
Xintadd_105/U5 FA1S $PINS S=intadd_105/SUM[0] CO=intadd_105/n4
+ A=intadd_105/B[0] B=intadd_105/A[0] CI=intadd_105/CI
Xintadd_105/U4 FA1S $PINS S=intadd_105/SUM[1] CO=intadd_105/n3
+ A=intadd_105/B[1] B=intadd_105/A[1] CI=intadd_105/n4
Xintadd_105/U3 FA1S $PINS S=intadd_105/SUM[2] CO=intadd_105/n2
+ A=intadd_105/B[2] B=intadd_105/A[2] CI=intadd_105/n3
Xintadd_105/U2 FA1S $PINS S=intadd_99/A[9] CO=intadd_105/n1 A=intadd_105/B[3]
+ B=intadd_105/A[3] CI=intadd_105/n2
Xintadd_106/U5 FA1S $PINS S=intadd_106/SUM[0] CO=intadd_106/n4
+ A=intadd_106/B[0] B=intadd_106/A[0] CI=intadd_106/CI
Xintadd_106/U4 FA1S $PINS S=intadd_106/SUM[1] CO=intadd_106/n3
+ A=intadd_106/B[1] B=intadd_106/A[1] CI=intadd_106/n4
Xintadd_106/U3 FA1S $PINS S=intadd_106/SUM[2] CO=intadd_106/n2
+ A=intadd_106/B[2] B=intadd_106/A[2] CI=intadd_106/n3
Xintadd_106/U2 FA1S $PINS S=intadd_99/A[8] CO=intadd_106/n1 A=intadd_106/B[3]
+ B=intadd_105/SUM[2] CI=intadd_106/n2
Xintadd_107/U5 FA1S $PINS S=intadd_107/SUM[0] CO=intadd_107/n4
+ A=intadd_107/B[0] B=intadd_107/A[0] CI=intadd_107/CI
Xintadd_107/U4 FA1S $PINS S=intadd_107/SUM[1] CO=intadd_107/n3
+ A=intadd_107/B[1] B=intadd_107/A[1] CI=intadd_107/n4
Xintadd_107/U3 FA1S $PINS S=intadd_107/SUM[2] CO=intadd_107/n2
+ A=intadd_105/SUM[0] B=intadd_107/A[2] CI=intadd_107/n3
Xintadd_107/U2 FA1S $PINS S=intadd_99/A[7] CO=intadd_107/n1 A=intadd_106/SUM[2]
+ B=intadd_105/SUM[1] CI=intadd_107/n2
Xintadd_108/U5 FA1S $PINS S=intadd_108/SUM[0] CO=intadd_108/n4
+ A=intadd_108/B[0] B=intadd_108/A[0] CI=intadd_108/CI
Xintadd_108/U4 FA1S $PINS S=intadd_108/SUM[1] CO=intadd_108/n3
+ A=intadd_108/B[1] B=intadd_108/A[1] CI=intadd_108/n4
Xintadd_108/U3 FA1S $PINS S=intadd_108/SUM[2] CO=intadd_108/n2
+ A=intadd_108/B[2] B=intadd_108/A[2] CI=intadd_108/n3
Xintadd_109/U5 FA1S $PINS S=intadd_109/SUM[0] CO=intadd_109/n4
+ A=intadd_109/B[0] B=intadd_109/A[0] CI=intadd_109/CI
Xintadd_109/U4 FA1S $PINS S=intadd_109/SUM[1] CO=intadd_109/n3
+ A=intadd_109/B[1] B=intadd_109/A[1] CI=intadd_109/n4
Xintadd_109/U3 FA1S $PINS S=intadd_109/SUM[2] CO=intadd_109/n2
+ A=intadd_109/B[2] B=intadd_109/A[2] CI=intadd_109/n3
Xintadd_110/U5 FA1S $PINS S=intadd_110/SUM[0] CO=intadd_110/n4
+ A=intadd_110/B[0] B=intadd_110/A[0] CI=intadd_110/CI
Xintadd_110/U4 FA1S $PINS S=intadd_110/SUM[1] CO=intadd_110/n3
+ A=intadd_110/B[1] B=intadd_110/A[1] CI=intadd_110/n4
Xintadd_110/U3 FA1S $PINS S=intadd_110/SUM[2] CO=intadd_110/n2
+ A=intadd_108/SUM[0] B=intadd_110/A[2] CI=intadd_110/n3
Xintadd_111/U4 FA1S $PINS S=intadd_102/A[2] CO=intadd_111/n3 A=intadd_111/B[0]
+ B=intadd_111/A[0] CI=intadd_111/CI
Xintadd_111/U3 FA1S $PINS S=intadd_102/A[3] CO=intadd_111/n2 A=intadd_111/B[1]
+ B=intadd_111/A[1] CI=intadd_111/n3
Xintadd_111/U2 FA1S $PINS S=intadd_111/SUM[2] CO=intadd_111/n1
+ A=intadd_111/B[2] B=intadd_111/A[2] CI=intadd_111/n2
Xintadd_112/U4 FA1S $PINS S=intadd_112/SUM[0] CO=intadd_112/n3
+ A=intadd_112/B[0] B=intadd_112/A[0] CI=intadd_112/CI
Xintadd_112/U3 FA1S $PINS S=intadd_112/SUM[1] CO=intadd_112/n2
+ A=intadd_103/SUM[0] B=intadd_112/A[1] CI=intadd_112/n3
Xintadd_112/U2 FA1S $PINS S=intadd_112/SUM[2] CO=intadd_112/n1
+ A=intadd_103/SUM[1] B=intadd_104/SUM[2] CI=intadd_112/n2
Xintadd_113/U4 FA1S $PINS S=intadd_113/SUM[0] CO=intadd_113/n3
+ A=intadd_113/B[0] B=intadd_113/A[0] CI=intadd_113/CI
Xintadd_113/U3 FA1S $PINS S=intadd_113/SUM[1] CO=intadd_113/n2
+ A=intadd_113/B[1] B=intadd_104/SUM[0] CI=intadd_113/n3
Xintadd_113/U2 FA1S $PINS S=intadd_113/SUM[2] CO=intadd_113/n1
+ A=intadd_104/SUM[1] B=intadd_112/SUM[1] CI=intadd_113/n2
Xintadd_114/U4 FA1S $PINS S=intadd_105/B[2] CO=intadd_114/n3 A=intadd_114/B[0]
+ B=intadd_114/A[0] CI=intadd_114/CI
Xintadd_114/U3 FA1S $PINS S=intadd_105/A[3] CO=intadd_114/n2 A=intadd_114/B[1]
+ B=intadd_114/A[1] CI=intadd_114/n3
Xintadd_114/U2 FA1S $PINS S=intadd_99/A[10] CO=intadd_114/n1 A=intadd_114/B[2]
+ B=intadd_114/A[2] CI=intadd_114/n2
Xintadd_115/U4 FA1S $PINS S=intadd_115/SUM[0] CO=intadd_115/n3
+ A=intadd_115/B[0] B=intadd_115/A[0] CI=intadd_115/CI
Xintadd_115/U3 FA1S $PINS S=intadd_115/SUM[1] CO=intadd_115/n2
+ A=intadd_106/SUM[0] B=intadd_115/A[1] CI=intadd_115/n3
Xintadd_115/U2 FA1S $PINS S=intadd_99/A[6] CO=intadd_115/n1 A=intadd_107/SUM[2]
+ B=intadd_106/SUM[1] CI=intadd_115/n2
Xintadd_116/U4 FA1S $PINS S=intadd_116/SUM[0] CO=intadd_116/n3
+ A=intadd_116/B[0] B=intadd_116/A[0] CI=intadd_116/CI
Xintadd_116/U3 FA1S $PINS S=intadd_116/SUM[1] CO=intadd_116/n2
+ A=intadd_107/SUM[0] B=intadd_116/A[1] CI=intadd_116/n3
Xintadd_116/U2 FA1S $PINS S=intadd_99/A[5] CO=intadd_116/n1 A=intadd_107/SUM[1]
+ B=intadd_115/SUM[1] CI=intadd_116/n2
Xintadd_117/U4 FA1S $PINS S=intadd_108/B[2] CO=intadd_117/n3 A=intadd_117/B[0]
+ B=intadd_117/A[0] CI=intadd_117/CI
Xintadd_117/U3 FA1S $PINS S=intadd_108/A[3] CO=intadd_117/n2 A=intadd_117/B[1]
+ B=intadd_117/A[1] CI=intadd_117/n3
Xintadd_117/U2 FA1S $PINS S=intadd_117/SUM[2] CO=intadd_117/n1
+ A=intadd_117/B[2] B=intadd_117/A[2] CI=intadd_117/n2
Xintadd_118/U4 FA1S $PINS S=intadd_118/SUM[0] CO=intadd_118/n3
+ A=intadd_118/B[0] B=intadd_118/A[0] CI=intadd_118/CI
Xintadd_118/U3 FA1S $PINS S=intadd_118/SUM[1] CO=intadd_118/n2
+ A=intadd_109/SUM[0] B=intadd_118/A[1] CI=intadd_118/n3
Xintadd_119/U4 FA1S $PINS S=intadd_119/SUM[0] CO=intadd_119/n3
+ A=intadd_119/B[0] B=intadd_119/A[0] CI=intadd_119/CI
Xintadd_97/U24 FA1S $PINS S=n471 CO=n472 A=N9 B=N18 CI=N35
Xintadd_97/U4 FA1 $PINS S=N96 CO=intadd_97/n3 A=intadd_97/B[20] B=s1_P3[11]
+ CI=intadd_97/n4
Xintadd_97/U3 FA1 $PINS S=N97 CO=intadd_97/n2 A=intadd_97/B[21] B=s1_P3[12]
+ CI=intadd_97/n3
Xintadd_98/U14 FA1 $PINS S=N37 CO=intadd_98/n13 A=intadd_98/B[0]
+ B=intadd_98/A[0] CI=intadd_98/CI
Xintadd_98/U13 FA1 $PINS S=N38 CO=intadd_98/n12 A=intadd_98/B[1]
+ B=intadd_98/A[1] CI=intadd_98/n13
Xintadd_98/U12 FA1 $PINS S=N39 CO=intadd_98/n11 A=intadd_98/B[2]
+ B=intadd_98/A[2] CI=intadd_98/n12
Xintadd_98/U9 FA1 $PINS S=N42 CO=intadd_98/n8 A=intadd_98/B[5]
+ B=intadd_119/SUM[2] CI=intadd_98/n9
Xintadd_98/U5 FA1 $PINS S=N46 CO=intadd_98/n4 A=intadd_109/n1
+ B=intadd_108/SUM[3] CI=intadd_98/n5
Xintadd_98/U3 FA1 $PINS S=N48 CO=intadd_98/n2 A=intadd_98/B[11] B=intadd_117/n1
+ CI=intadd_98/n3
Xintadd_98/U2 FA1 $PINS S=N49 CO=intadd_98/n1 A=intadd_98/B[12]
+ B=intadd_98/A[12] CI=intadd_98/n2
Xintadd_100/U11 FA1 $PINS S=N57 CO=intadd_100/n10 A=intadd_100/B[2]
+ B=intadd_100/A[2] CI=intadd_100/n11
Xintadd_100/U9 FA1 $PINS S=N59 CO=intadd_100/n8 A=intadd_100/B[4]
+ B=intadd_100/A[4] CI=intadd_100/n9
Xintadd_100/U7 FA1 $PINS S=N61 CO=intadd_100/n6 A=intadd_100/B[6]
+ B=intadd_100/A[6] CI=intadd_100/n7
Xintadd_100/U6 FA1 $PINS S=N62 CO=intadd_100/n5 A=intadd_100/B[7]
+ B=intadd_100/A[7] CI=intadd_100/n6
Xintadd_101/U13 FA1 $PINS S=N3 CO=intadd_101/n12 A=intadd_101/B[0]
+ B=intadd_101/A[0] CI=intadd_101/CI
Xintadd_101/U11 FA1 $PINS S=N5 CO=intadd_101/n10 A=intadd_101/B[2]
+ B=intadd_101/A[2] CI=intadd_101/n11
Xintadd_101/U9 FA1 $PINS S=N7 CO=intadd_101/n8 A=intadd_101/B[4]
+ B=intadd_101/A[4] CI=intadd_101/n9
XR_58 QDFFRBN $PINS Q=intadd_97/B[14] D=n497 CK=clk_clone1
+ RB=FE_OFN59_i_reset_n_i
XR_59 QDFFRBN $PINS Q=intadd_97/A[14] D=n496 CK=clk_clone1
+ RB=FE_OFN59_i_reset_n_i
XR_60 QDFFRBN $PINS Q=intadd_97/B[13] D=n495 CK=clk RB=FE_OFN8_i_reset_n_i
XR_61 QDFFRBN $PINS Q=intadd_97/A[13] D=n494 CK=clk_clone1
+ RB=FE_OFN8_i_reset_n_i
XR_62 QDFFRBN $PINS Q=intadd_97/B[12] D=n493 CK=clk RB=rst_n
XR_63 QDFFRBN $PINS Q=intadd_97/A[12] D=n492 CK=clk RB=rst_n
XR_64 QDFFRBN $PINS Q=intadd_97/B[11] D=n491 CK=clk RB=FE_OFN164_i_reset_n_i
XR_65 QDFFRBN $PINS Q=intadd_97/A[11] D=n490 CK=clk RB=FE_OFN164_i_reset_n_i
XR_66 QDFFRBN $PINS Q=intadd_97/B[10] D=n489 CK=clk RB=FE_OFN164_i_reset_n_i
XR_67 QDFFRBN $PINS Q=intadd_97/A[10] D=n488 CK=clk RB=FE_OFN164_i_reset_n_i
XR_68 QDFFRBN $PINS Q=intadd_97/B[9] D=n487 CK=clk RB=FE_OFN164_i_reset_n_i
XR_69 QDFFRBN $PINS Q=intadd_97/A[9] D=n486 CK=clk RB=FE_OFN164_i_reset_n_i
XR_70 QDFFRBN $PINS Q=intadd_97/B[8] D=n485 CK=clk RB=FE_OFN114_i_reset_n_i
XR_71 QDFFRBN $PINS Q=intadd_97/A[8] D=n484 CK=clk RB=FE_OFN114_i_reset_n_i
XR_73 QDFFRBN $PINS Q=intadd_97/A[7] D=n482 CK=clk RB=FE_OFN114_i_reset_n_i
XR_74 QDFFRBN $PINS Q=intadd_97/B[6] D=n481 CK=clk RB=FE_OFN29_i_reset_n_i
XR_75 QDFFRBN $PINS Q=intadd_97/A[6] D=n480 CK=clk RB=FE_OFN29_i_reset_n_i
XR_76 QDFFRBN $PINS Q=intadd_97/B[5] D=n479 CK=clk RB=FE_OFN9_i_reset_n_i
XR_77 QDFFRBN $PINS Q=intadd_97/A[5] D=n478 CK=clk RB=FE_OFN51_i_reset_n_i
XR_78 QDFFRBN $PINS Q=intadd_97/B[4] D=n477 CK=clk RB=FE_OFN51_i_reset_n_i
XR_79 QDFFRBN $PINS Q=intadd_97/A[4] D=n476 CK=clk RB=FE_OFN51_i_reset_n_i
XR_80 QDFFRBN $PINS Q=intadd_97/B[3] D=n475 CK=clk RB=FE_OFN74_i_reset_n_i
XR_81 QDFFRBN $PINS Q=intadd_97/A[3] D=n474 CK=clk RB=FE_OFN74_i_reset_n_i
XR_82 QDFFRBN $PINS Q=intadd_97/B[2] D=n473 CK=clk RB=FE_OFN51_i_reset_n_i
XR_83 QDFFRBN $PINS Q=intadd_97/n23 D=n472 CK=clk RB=FE_OFN74_i_reset_n_i
XR_84 QDFFRBN $PINS Q=N76 D=n471 CK=clk RB=FE_OFN244_i_reset_n_i
Xintadd_98/U11 FA1 $PINS S=N40 CO=intadd_98/n10 A=intadd_98/B[3]
+ B=intadd_98/A[3] CI=intadd_98/n11
Xintadd_109/U2 FA1S $PINS S=intadd_109/SUM[3] CO=intadd_109/n1
+ A=intadd_109/B[3] B=intadd_108/SUM[2] CI=intadd_109/n2
Xintadd_108/U2 FA1S $PINS S=intadd_108/SUM[3] CO=intadd_108/n1
+ A=intadd_108/B[3] B=intadd_108/A[3] CI=intadd_108/n2
Xintadd_119/U2 FA1S $PINS S=intadd_119/SUM[2] CO=intadd_119/n1
+ A=intadd_110/SUM[1] B=intadd_118/SUM[1] CI=intadd_119/n2
Xintadd_118/U2 FA1S $PINS S=intadd_118/SUM[2] CO=intadd_118/n1
+ A=intadd_110/SUM[2] B=intadd_109/SUM[1] CI=intadd_118/n2
Xintadd_110/U2 FA1S $PINS S=intadd_110/SUM[3] CO=intadd_110/n1
+ A=intadd_109/SUM[2] B=intadd_108/SUM[1] CI=intadd_110/n2
Xintadd_97/U6 FA1 $PINS S=N94 CO=intadd_97/n5 A=intadd_97/B[18] B=s1_P3[9]
+ CI=intadd_97/n6
Xintadd_97/U8 FA1 $PINS S=N92 CO=intadd_97/n7 A=intadd_97/B[16]
+ B=intadd_97/A[16] CI=intadd_97/n8
Xintadd_97/U13 FA1 $PINS S=N87 CO=intadd_97/n12 A=intadd_97/B[11]
+ B=intadd_97/A[11] CI=intadd_97/n13
Xintadd_97/U15 FA1 $PINS S=N85 CO=intadd_97/n14 A=intadd_97/B[9]
+ B=intadd_97/A[9] CI=intadd_97/n15
Xintadd_97/U17 FA1 $PINS S=N83 CO=intadd_97/n16 A=intadd_97/B[7]
+ B=intadd_97/A[7] CI=intadd_97/n17
Xintadd_97/U19 FA1 $PINS S=N81 CO=intadd_97/n18 A=intadd_97/B[5]
+ B=intadd_97/A[5] CI=intadd_97/n19
Xintadd_97/U21 FA1S $PINS S=N79 CO=intadd_97/n20 A=intadd_97/B[3]
+ B=intadd_97/A[3] CI=intadd_97/n21
Xintadd_97/U22 FA1S $PINS S=N78 CO=intadd_97/n21 A=intadd_97/B[2]
+ B=intadd_97/A[2] CI=intadd_97/n22
Xintadd_101/U3 FA1 $PINS S=N13 CO=intadd_101/n2 A=intadd_102/n1
+ B=intadd_111/SUM[2] CI=intadd_101/n3
Xintadd_101/U5 FA1 $PINS S=N11 CO=intadd_101/n4 A=intadd_104/n1
+ B=intadd_103/SUM[3] CI=intadd_101/n5
Xintadd_101/U6 FA1 $PINS S=N10 CO=intadd_101/n5 A=intadd_112/n1
+ B=intadd_104/SUM[3] CI=intadd_101/n6
Xintadd_101/U8 FA1 $PINS S=N8 CO=intadd_101/n7 A=intadd_101/B[5]
+ B=intadd_113/SUM[2] CI=intadd_101/n8
Xintadd_97/U5 FA1 $PINS S=N95 CO=intadd_97/n4 A=intadd_97/B[19] B=s1_P3[10]
+ CI=intadd_97/n5
Xintadd_97/U2 FA1 $PINS S=N98 CO=intadd_97/n1 A=s1_P3[13] B=intadd_97/A[22]
+ CI=intadd_97/n2
Xintadd_101/U2 FA1 $PINS S=N14 CO=intadd_101/n1 A=intadd_111/n1
+ B=intadd_101/A[11] CI=intadd_101/n2
Xintadd_101/U12 FA1 $PINS S=N4 CO=intadd_101/n11 A=intadd_101/B[1]
+ B=intadd_101/A[1] CI=intadd_101/n12
Xintadd_100/U5 FA1 $PINS S=N63 CO=intadd_100/n4 A=intadd_100/B[8]
+ B=intadd_100/A[8] CI=intadd_100/n5
Xintadd_97/U7 FA1 $PINS S=N93 CO=intadd_97/n6 A=intadd_97/B[17]
+ B=intadd_97/A[17] CI=intadd_97/n7
Xintadd_97/U20 FA1 $PINS S=N80 CO=intadd_97/n19 A=intadd_97/B[4]
+ B=intadd_97/A[4] CI=intadd_97/n20
Xintadd_101/U7 FA1 $PINS S=N9 CO=intadd_101/n6 A=intadd_113/n1
+ B=intadd_112/SUM[2] CI=intadd_101/n7
Xintadd_100/U12 FA1 $PINS S=N56 CO=intadd_100/n11 A=intadd_100/B[1]
+ B=intadd_100/A[1] CI=intadd_100/n12
Xintadd_98/U8 FA1 $PINS S=N43 CO=intadd_98/n7 A=intadd_119/n1
+ B=intadd_118/SUM[2] CI=intadd_98/n8
Xintadd_101/U4 FA1 $PINS S=N12 CO=intadd_101/n3 A=intadd_103/n1
+ B=intadd_102/SUM[3] CI=intadd_101/n4
Xintadd_119/U3 FA1S $PINS S=intadd_119/SUM[1] CO=intadd_119/n2
+ A=intadd_110/SUM[0] B=intadd_119/A[1] CI=intadd_119/n3
Xintadd_97/U18 FA1 $PINS S=N82 CO=intadd_97/n17 A=intadd_97/B[6]
+ B=intadd_97/A[6] CI=intadd_97/n18
Xintadd_97/U16 FA1 $PINS S=N84 CO=intadd_97/n15 A=intadd_97/B[8]
+ B=intadd_97/A[8] CI=intadd_97/n16
Xintadd_97/U14 FA1 $PINS S=N86 CO=intadd_97/n13 A=intadd_97/B[10]
+ B=intadd_97/A[10] CI=intadd_97/n14
Xintadd_100/U13 FA1 $PINS S=N55 CO=intadd_100/n12 A=intadd_100/B[0]
+ B=intadd_100/A[0] CI=intadd_100/CI
Xintadd_100/U10 FA1 $PINS S=N58 CO=intadd_100/n9 A=intadd_100/B[3]
+ B=intadd_100/A[3] CI=intadd_100/n10
Xintadd_98/U10 FA1 $PINS S=N41 CO=intadd_98/n9 A=intadd_98/B[4]
+ B=intadd_98/A[4] CI=intadd_98/n10
Xintadd_98/U4 FA1 $PINS S=N47 CO=intadd_98/n3 A=intadd_108/n1
+ B=intadd_117/SUM[2] CI=intadd_98/n4
Xintadd_100/U8 FA1 $PINS S=N60 CO=intadd_100/n7 A=intadd_100/B[5]
+ B=intadd_100/A[5] CI=intadd_100/n8
Xintadd_101/U10 FA1 $PINS S=N6 CO=intadd_101/n9 A=intadd_101/B[3]
+ B=intadd_101/A[3] CI=intadd_101/n10
Xintadd_97/U12 FA1 $PINS S=N88 CO=intadd_97/n11 A=intadd_97/B[12]
+ B=intadd_97/A[12] CI=intadd_97/n12
XU7 ND3 $PINS O=n216 I1=A[8] I2=FE_OFN1498_FE_DBTN29_n4484 I3=n73
XU21 MOAI1S $PINS O=n325 A1=FE_OFN1325_IxIy_shift_10 A2=FE_OFN2726_n2891
+ B1=FE_OFN1325_IxIy_shift_10 B2=FE_OFN2726_n2891
XU25 MOAI1S $PINS O=n422 A1=n409 A2=n408 B1=n409 B2=n408
XU26 ND2S $PINS O=n107 I1=A[1] I2=B[0]
XU27 ND2S $PINS O=n214 I1=FE_OFN980_IxIy_shift_12 I2=FE_OFN4309_n
XU28 ND2S $PINS O=n98 I1=A[8] I2=FE_OFN1705_IyIt_shift_1
XU30 ND2S $PINS O=n154 I1=FE_OFN878_IyIt_shift_0 I2=A[4]
XU31 ND2S $PINS O=n200 I1=FE_DBTN126_IxIy_shift_13 I2=FE_OFN4309_n
XU32 ND2S $PINS O=n215 I1=FE_OFN180_n2891 I2=FE_OFN1705_IyIt_shift_1
XU33 INV1S $PINS O=n180 I=FE_OFN4309_n
XU34 MOAI1 $PINS O=N99 A1=intadd_97/A[22] A2=n77 B1=intadd_97/A[22] B2=n77
XU35 MOAI1S $PINS O=n63 A1=n218 A2=n62 B1=n218 B2=n62
XU36 MOAI1S $PINS O=n352 A1=n340 A2=n326 B1=n437 B2=n318
XU37 ND2S $PINS O=n404 I1=n409 I2=n408
XU38 ND2S $PINS O=n368 I1=n377 I2=n376
XU39 ND3 $PINS O=n163 I1=A[3] I2=FE_OFN878_IyIt_shift_0 I3=n156
XU41 NR2 $PINS O=n138 I1=n113 I2=n112
XU42 ND2S $PINS O=n293 I1=FE_OFN1130_IyIt_shift_13 I2=FE_OFN1125_IxIy_shift_7
XU43 ND2S $PINS O=n440 I1=FE_OFN1407_FE_DBTN157_n2891
+ I2=FE_OFN1484_FE_DBTN87_n340
XU44 ND2S $PINS O=n443 I1=FE_OFN1379_IyIt_shift_8 I2=n424
XU45 ND2S $PINS O=n95 I1=FE_OFN1132_IyIt_shift_13 I2=n64
XU46 ND2S $PINS O=n68 I1=FE_OFN1132_IyIt_shift_13 I2=FE_DBTN117_IxIy_shift_0
XU47 ND3 $PINS O=n285 I1=FE_OFN1695_n1659 I2=FE_OFN4270_n64 I3=n281
XU48 ND2S $PINS O=n396 I1=FE_OFN4122_IyIt_shift_8 I2=n451
XU49 ND3 $PINS O=n224 I1=A[10] I2=FE_OFN1705_IyIt_shift_1 I3=n219
XU52 ND2S $PINS O=n74 I1=A[10] I2=FE_OFN1705_IyIt_shift_1
XU53 ND2S $PINS O=n67 I1=FE_OFN1695_n1659 I2=FE_OFN4270_n64
XU54 ND2S $PINS O=n92 I1=FE_OFN1472_FE_DBTN98_IyIt_shift_8 I2=FE_OFN4270_n64
XU55 ND2S $PINS O=n65 I1=FE_OFN1138_IyIt_shift_9 I2=n64
XU56 ND2S $PINS O=n100 I1=FE_OFN973_IxIy_shift_14 I2=FE_OFN4309_n
XU57 ND2S $PINS O=n101 I1=FE_DBTN126_IxIy_shift_13 I2=FE_OFN1705_IyIt_shift_1
XU58 ND2S $PINS O=n276 I1=FE_OFN1375_IyIt_shift_11 I2=n64
XU59 ND2S $PINS O=n97 I1=FE_OFN1138_IyIt_shift_9 I2=FE_OFN1125_IxIy_shift_7
XU60 ND2S $PINS O=n106 I1=A[0] I2=n179
XU61 ND2S $PINS O=n108 I1=A[1] I2=FE_OFN874_IyIt_shift_1
XU62 ND2S $PINS O=n143 I1=FE_OFN4309_n I2=A[5]
XU63 ND2 $PINS O=n144 I1=FE_OFN1703_IyIt_shift_1 I2=A[4]
XU64 ND2S $PINS O=n110 I1=A[6] I2=FE_OFN878_IyIt_shift_0
XU65 ND2S $PINS O=n111 I1=FE_OFN1703_IyIt_shift_1 I2=A[5]
XU66 ND2S $PINS O=n112 I1=FE_OFN254_IxIy_shift_7 I2=FE_OFN878_IyIt_shift_0
XU67 ND2S $PINS O=n114 I1=FE_OFN1703_IyIt_shift_1 I2=FE_OFN254_IxIy_shift_7
XU68 ND2S $PINS O=n80 I1=A[3] I2=FE_OFN878_IyIt_shift_0
XU69 ND2S $PINS O=n155 I1=FE_OFN1703_IyIt_shift_1 I2=A[3]
XU70 ND2S $PINS O=intadd_98/A[12] I1=FE_OFN1187_FE_DBTN22_IyIt_shift_15
+ I2=FE_OFN1125_IxIy_shift_7
XU71 ND2S $PINS O=n299 I1=FE_OFN994_IyIt_shift_14 I2=FE_OFN1125_IxIy_shift_7
XU72 ND2S $PINS O=n263 I1=FE_OFN1135_IyIt_shift_12 I2=A[4]
XU73 ND2S $PINS O=n275 I1=FE_OFN1135_IyIt_shift_12 I2=FE_DBTN117_IxIy_shift_0
XU74 ND2S $PINS O=n268 I1=FE_OFN1135_IyIt_shift_12
+ I2=FE_OFN1457_FE_DBTN120_IxIy_shift_3
XU75 ND2S $PINS O=n266 I1=FE_OFN1375_IyIt_shift_11 I2=A[4]
XU77 ND2S $PINS O=n69 I1=FE_OFN1135_IyIt_shift_12 I2=n64
XU78 ND2S $PINS O=n76 I1=FE_OFN1138_IyIt_shift_9
+ I2=FE_OFN4229_FE_OFN1118_IxIy_shift_8
XU79 ND2S $PINS O=n246 I1=FE_OFN1375_IyIt_shift_11
+ I2=FE_OFN278_FE_DBTN163_n1653
XU80 ND2S $PINS O=n248 I1=FE_OFN1135_IyIt_shift_12 I2=A[5]
XU81 ND2S $PINS O=n259 I1=FE_OFN1187_FE_DBTN22_IyIt_shift_15
+ I2=FE_OFN1457_FE_DBTN120_IxIy_shift_3
XU82 ND2S $PINS O=intadd_117/A[1] I1=FE_OFN1187_FE_DBTN22_IyIt_shift_15 I2=A[4]
XU83 ND2S $PINS O=n195 I1=FE_OFN1407_FE_DBTN157_n2891 I2=B[4]
XU84 ND2S $PINS O=n197 I1=FE_OFN259_IxIy_shift_12 I2=FE_DBTN92_IyIt_shift_3
XU85 ND2S $PINS O=n103 I1=A[9] I2=FE_OFN1141_IyIt_shift_7
XU86 ND2S $PINS O=n193 I1=FE_OFN259_IxIy_shift_12 I2=B[4]
XU88 ND2S $PINS O=n157 I1=A[0] I2=FE_OFN1386_IyIt_shift_3
XU89 ND2S $PINS O=n62 I1=FE_OFN1118_IxIy_shift_8 I2=FE_DBTN92_IyIt_shift_3
XU90 ND2S $PINS O=n174 I1=FE_OFN1407_FE_DBTN157_n2891 I2=B[6]
XU91 ND2S $PINS O=n176 I1=FE_OFN259_IxIy_shift_12 I2=B[5]
XU93 ND2S $PINS O=n187 I1=FE_OFN252_n2620 I2=FE_DBTN92_IyIt_shift_3
XU94 ND2S $PINS O=n93 I1=FE_OFN1138_IyIt_shift_9 I2=FE_DBTN117_IxIy_shift_0
XU103 ND2S $PINS O=n292 I1=FE_OFN994_IyIt_shift_14
+ I2=FE_OFN278_FE_DBTN163_n1653
XU105 ND2S $PINS O=n454 I1=FE_OFN254_IxIy_shift_7 I2=FE_OFN1141_IyIt_shift_7
XU109 ND2S $PINS O=n231 I1=FE_OFN973_IxIy_shift_14 I2=B[6]
XU110 ND2S $PINS O=n232 I1=FE_DBTN126_IxIy_shift_13 I2=FE_OFN1758_IyIt_shift_7
XU111 ND2S $PINS O=n237 I1=n346 I2=FE_OFN1758_IyIt_shift_7
XU112 ND2S $PINS O=intadd_99/A[12] I1=A[15] I2=FE_OFN1758_IyIt_shift_7
XU114 ND2S $PINS O=n60 I1=FE_OFN1472_FE_DBTN98_IyIt_shift_8
+ I2=FE_OFN1457_FE_DBTN120_IxIy_shift_3
XU116 ND2S $PINS O=n96 I1=FE_OFN994_IyIt_shift_14 I2=FE_OFN274_FE_DBTN165_n1651
XU117 ND2S $PINS O=n94 I1=FE_OFN994_IyIt_shift_14 I2=FE_DBTN117_IxIy_shift_0
XU120 ND2S $PINS O=n113 I1=FE_OFN1703_IyIt_shift_1 I2=A[6]
XU128 ND2S $PINS O=intadd_114/A[1] I1=FE_OFN252_n2620 I2=B[4]
XU134 ND2S $PINS O=intadd_97/B[17] I1=n84 I2=n83
XU135 ND2S $PINS O=intadd_97/A[16] I1=n81 I2=n82
XU136 FA1S $PINS S=N77 CO=intadd_97/n22 A=intadd_97/B[1] B=s1_P1[1]
+ CI=intadd_97/n23
XU137 ND2S $PINS O=n78 I1=n83 I2=n82
XU138 ND2S $PINS O=n81 I1=s1_P3[7] I2=n83
XU139 ND2S $PINS O=n82 I1=s1_P1[15] I2=s1_P2[15]
XU142 INV1S $PINS O=n327 I=FE_OFN1135_IyIt_shift_12
XU164 NR2P $PINS O=n437 I1=FE_DBTN87_n340 I2=n325
XU165 INV2 $PINS O=n462 I=FE_OFN1138_IyIt_shift_9
XU168 MOAI1 $PINS O=n451 A1=n346 A2=FE_OFN4288_n B1=n346 B2=FE_OFN4288_n
XU169 MOAI1S $PINS O=n424 A1=FE_OFN1616_IxIy_shift_12 A2=FE_OFN1221_n2891
+ B1=FE_OFN1616_IxIy_shift_12 B2=FE_OFN1221_n2891
XU181 NR2 $PINS O=n132 I1=FE_OFN1477_FE_DBTN92_IyIt_shift_3 I2=FE_OFN1645_n1653
XU183 MOAI1 $PINS O=n77 A1=s1_P3[15] A2=intadd_97/n1 B1=s1_P3[15]
+ B2=intadd_97/n1
XU185 FA1 $PINS S=n497 CO=n498 A=N58 B=N32 CI=N49
XU186 NR2 $PINS O=intadd_109/A[0] I1=FE_OFN1391_n462 I2=FE_DBTN163_n1653
XU188 INV1S $PINS O=n253 I=FE_OFN1132_IyIt_shift_13
XU189 NR2 $PINS O=n59 I1=n253 I2=FE_OFN1602_n1651
XU192 AOI22S $PINS O=n261 A1=FE_OFN1472_FE_DBTN98_IyIt_shift_8
+ A2=FE_OFN1125_IxIy_shift_7 B1=FE_OFN1132_IyIt_shift_13
+ B2=FE_OFN274_FE_DBTN165_n1651
XU193 AO13S $PINS O=intadd_110/B[1] A1=n261 B1=FE_OFN1125_IxIy_shift_7
+ B2=FE_OFN1472_FE_DBTN98_IyIt_shift_8 B3=n59
XU194 NR2 $PINS O=n280 I1=FE_OFN1391_n462 I2=FE_OFN1602_n1651
XU196 MOAI1S $PINS O=n61 A1=n280 A2=n60 B1=n280 B2=n60
XU199 NR2 $PINS O=n66 I1=FE_OFN1381_IyIt_shift_8 I2=FE_OFN1602_n1651
XU200 ND3 $PINS O=n277 I1=FE_OFN1138_IyIt_shift_9 I2=n64 I3=n66
XU201 MOAI1S $PINS O=intadd_98/B[1] A1=n61 A2=n277 B1=n61 B2=n277
XU203 NR2 $PINS O=n218 I1=FE_OFN4331_FE_DBTN152_n3310 I2=FE_OFN1241_n4484
XU206 NR2 $PINS O=n73 I1=FE_OFN4331_FE_DBTN152_n3310 I2=FE_OFN1702_IyIt_shift_1
XU207 MOAI1S $PINS O=intadd_99/B[1] A1=n63 A2=n216 B1=n63 B2=n216
XU208 NR2 $PINS O=intadd_108/A[1] I1=n97 I2=n96
XU209 OR2 $PINS O=n83 I1=s1_P1[15] I2=s1_P2[15]
XU210 MOAI1S $PINS O=intadd_97/B[15] A1=s1_P3[7] A2=n78 B1=s1_P3[7] B2=n78
XU212 NR2 $PINS O=intadd_110/A[1] I1=n95 I2=n94
XU213 MOAI1S $PINS O=intadd_98/A[0] A1=n66 A2=n65 B1=n66 B2=n65
XU214 INV2 $PINS O=n428 I=FE_OFN1375_IyIt_shift_11
XU216 NR2 $PINS O=n281 I1=n428 I2=FE_OFN1623_IxIy_shift_0
XU217 MOAI1S $PINS O=intadd_98/A[1] A1=n281 A2=n67 B1=n281 B2=n67
XU218 NR2 $PINS O=intadd_118/B[0] I1=n69 I2=n68
XU219 NR2 $PINS O=n291 I1=FE_OFN4220_FE_OFN1381_IyIt_shift_8
+ I2=FE_OFN1341_IxIy_shift_4
XU221 NR2 $PINS O=n290 I1=FE_OFN1391_n462 I2=FE_OFN1458_FE_DBTN120_IxIy_shift_3
XU222 NR2 $PINS O=n289 I1=FE_OFN1694_n1659 I2=FE_OFN275_FE_DBTN165_n1651
XU223 OAI22S $PINS O=n273 A1=n69 A2=intadd_118/B[0] B1=n68 B2=intadd_118/B[0]
XU224 NR2 $PINS O=n272 I1=n276 I2=n275
XU225 NR2 $PINS O=n271 I1=FE_OFN1391_n462 I2=FE_OFN1341_IxIy_shift_4
XU226 FA1S $PINS S=intadd_98/A[3] CO=intadd_98/B[4] A=n71 B=n70
+ CI=intadd_119/SUM[0]
XU228 MOAI1S $PINS O=intadd_99/A[0] A1=n73 A2=n72 B1=n73 B2=n72
XU230 NR2 $PINS O=n219 I1=FE_DBTN157_n2891 I2=n180
XU233 MOAI1S $PINS O=intadd_99/A[1] A1=n219 A2=n74 B1=n219 B2=n74
XU248 MOAI1S $PINS O=n75 A1=FE_OFN1693_n1659 A2=FE_OFN4332_FE_DBTN152_n3310
+ B1=FE_OFN1693_n1659 B2=FE_OFN4332_FE_DBTN152_n3310
XU249 NR2 $PINS O=n429 I1=FE_OFN4229_FE_OFN1118_IxIy_shift_8
+ I2=FE_OFN4332_FE_DBTN152_n3310
XU250 AOI22S $PINS O=n468 A1=FE_OFN4228_FE_OFN1118_IxIy_shift_8 A2=n75 B1=n429
+ B2=n462
XU253 MOAI1 $PINS O=n340 A1=FE_OFN1160_FE_DBTN152_n3310
+ A2=FE_OFN1325_IxIy_shift_10 B1=FE_OFN1160_FE_DBTN152_n3310
+ B2=FE_OFN1325_IxIy_shift_10
XU254 ND3 $PINS O=n464 I1=n76 I2=FE_OFN4339_n
+ I3=FE_OFN4219_FE_OFN1381_IyIt_shift_8
XU255 OA12 $PINS O=n469 A1=n464 B1=FE_OFN4219_FE_OFN1381_IyIt_shift_8 B2=n340
XU256 NR2 $PINS O=intadd_100/B[0] I1=n468 I2=n469
XU257 INV1S $PINS O=intadd_97/A[22] I=s1_P3[14]
XU258 MOAI1S $PINS O=intadd_97/B[16] A1=s1_P3[8] A2=n78 B1=s1_P3[8] B2=n78
XU259 ND2 $PINS O=n109 I1=A[0] I2=FE_OFN1498_FE_DBTN29_n4484
XU261 NR2 $PINS O=n160 I1=n109 I2=n108
XU263 MOAI1S $PINS O=n79 A1=n158 A2=n157 B1=n158 B2=n157
XU264 MOAI1S $PINS O=intadd_101/A[1] A1=n160 A2=n79 B1=n160 B2=n79
XU265 NR2 $PINS O=n156 I1=FE_OFN1702_IyIt_shift_1 I2=FE_DBTN165_n1651
XU267 MOAI1S $PINS O=intadd_101/B[1] A1=n156 A2=n80 B1=n156 B2=n80
XU268 NR2 $PINS O=intadd_98/B[0] I1=n93 I2=n92
XU271 NR2 $PINS O=intadd_99/B[0] I1=n99 I2=n98
XU272 AN2 $PINS O=intadd_97/A[2] I1=s1_P0[9] I2=s1_P2[1]
XU273 ND2S $PINS O=n84 I1=s1_P3[8] I2=n82
XU274 NR2 $PINS O=n122 I1=FE_OFN1645_n1653 I2=FE_OFN293_FE_DBTN96_IyIt_shift_6
XU275 NR2 $PINS O=n121 I1=FE_OFN1192_FE_DBTN14_IyIt_shift_7
+ I2=FE_OFN1334_IxIy_shift_5
XU276 NR2 $PINS O=n120 I1=FE_OFN1389_n252 I2=FE_OFN1174_FE_DBTN94_IyIt_shift_5
XU277 NR2 $PINS O=n118 I1=FE_OFN1192_FE_DBTN14_IyIt_shift_7 I2=FE_OFN1645_n1653
XU278 NR2 $PINS O=n117 I1=FE_OFN1389_n252 I2=FE_OFN293_FE_DBTN96_IyIt_shift_6
XU279 MAOI1 $PINS O=n85 A1=n453 A2=intadd_101/n1 B1=n453 B2=intadd_101/n1
XU280 MOAI1 $PINS O=n86 A1=n454 A2=n85 B1=n454 B2=n85
XU281 FA1 $PINS S=n481 CO=n482 A=N41 B=N24 CI=n86
XU283 MOAI1S $PINS O=n87 A1=FE_OFN1375_IyIt_shift_11
+ A2=FE_OFN4332_FE_DBTN152_n3310 B1=FE_OFN1375_IyIt_shift_11
+ B2=FE_OFN4332_FE_DBTN152_n3310
XU284 AOI22S $PINS O=n90 A1=FE_OFN4229_FE_OFN1118_IxIy_shift_8 A2=n87 B1=n429
+ B2=FE_OFN1694_n1659
XU286 MOAI1S $PINS O=n432 A1=FE_OFN2726_n2891 A2=n462 B1=FE_OFN2726_n2891
+ B2=n462
XU287 MOAI1S $PINS O=n89 A1=FE_OFN1223_n2891
+ A2=FE_OFN4219_FE_OFN1381_IyIt_shift_8 B1=FE_OFN1223_n2891
+ B2=FE_OFN4219_FE_OFN1381_IyIt_shift_8
XU288 AOI22S $PINS O=n91 A1=FE_OFN1484_FE_DBTN87_n340 A2=n432 B1=n437 B2=n89
XU289 NR2P $PINS O=intadd_100/A[1] I1=n90 I2=n91
XU290 OAI22S $PINS O=intadd_100/A[0] A1=n91 A2=intadd_100/A[1] B1=n90
+ B2=intadd_100/A[1]
XU291 OAI22S $PINS O=N36 A1=n93 A2=intadd_98/B[0] B1=n92 B2=intadd_98/B[0]
XU292 OAI22S $PINS O=intadd_119/A[1] A1=n95 A2=intadd_110/A[1] B1=n94
+ B2=intadd_110/A[1]
XU293 OAI22S $PINS O=intadd_109/A[1] A1=n97 A2=intadd_108/A[1] B1=n96
+ B2=intadd_108/A[1]
XU294 OAI22S $PINS O=N19 A1=n99 A2=intadd_99/B[0] B1=n98 B2=intadd_99/B[0]
XU298 NR2P $PINS O=intadd_115/B[0] I1=n201 I2=n200
XU299 NR2 $PINS O=intadd_107/A[1] I1=n101 I2=n100
XU300 OAI22S $PINS O=intadd_116/A[1] A1=n101 A2=intadd_107/A[1] B1=n100
+ B2=intadd_107/A[1]
XU302 NR2 $PINS O=intadd_105/A[1] I1=n103 I2=n102
XU303 OAI22S $PINS O=intadd_106/A[1] A1=n103 A2=intadd_105/A[1] B1=n102
+ B2=intadd_105/A[1]
XU304 NR2 $PINS O=intadd_101/CI I1=n107 I2=n106
XU305 OAI22S $PINS O=N2 A1=n107 A2=intadd_101/CI B1=n106 B2=intadd_101/CI
XU306 OAI22S $PINS O=intadd_101/A[0] A1=n109 A2=n160 B1=n108 B2=n160
XU307 NR2 $PINS O=intadd_112/A[0] I1=n144 I2=n143
XU308 NR2 $PINS O=intadd_104/B[1] I1=n111 I2=n110
XU309 OAI22S $PINS O=intadd_113/B[1] A1=n111 A2=intadd_104/B[1] B1=n110
+ B2=intadd_104/B[1]
XU310 OAI22S $PINS O=intadd_104/A[1] A1=n113 A2=n138 B1=n112 B2=n138
XU312 NR2 $PINS O=intadd_102/B[1] I1=n115 I2=n114
XU313 OAI22S $PINS O=intadd_103/A[1] A1=n115 A2=intadd_102/B[1] B1=n114
+ B2=intadd_102/B[1]
XU314 NR2 $PINS O=N1 I1=n180 I2=FE_OFN886_FE_DBTN117_IxIy_shift_0
XU315 FA1S $PINS S=intadd_101/A[11] CO=n453 A=n119 B=n118 CI=n117
XU316 FA1S $PINS S=intadd_111/A[2] CO=n119 A=n122 B=n121 CI=n120
XU317 NR2 $PINS O=n125 I1=FE_OFN1645_n1653 I2=FE_OFN1174_FE_DBTN94_IyIt_shift_5
XU318 NR2 $PINS O=n124 I1=FE_OFN1192_FE_DBTN14_IyIt_shift_7
+ I2=FE_OFN1341_IxIy_shift_4
XU319 NR2 $PINS O=n123 I1=FE_OFN1389_n252 I2=FE_OFN1257_n4488
XU320 FA1S $PINS S=intadd_111/A[1] CO=intadd_111/B[2] A=n125 B=n124 CI=n123
XU321 NR2 $PINS O=intadd_111/B[1] I1=FE_OFN1334_IxIy_shift_5
+ I2=FE_OFN293_FE_DBTN96_IyIt_shift_6
XU322 NR2 $PINS O=intadd_111/A[0] I1=FE_OFN1645_n1653 I2=FE_OFN1257_n4488
XU324 NR2 $PINS O=intadd_111/B[0] I1=FE_OFN1456_FE_DBTN120_IxIy_shift_3
+ I2=FE_OFN1192_FE_DBTN14_IyIt_shift_7
XU325 NR2 $PINS O=intadd_111/CI I1=FE_OFN1477_FE_DBTN92_IyIt_shift_3 I2=A[7]
XU326 NR2 $PINS O=intadd_102/A[0] I1=FE_OFN852_IxIy_shift_1
+ I2=FE_OFN1192_FE_DBTN14_IyIt_shift_7
XU327 NR2 $PINS O=intadd_102/B[0] I1=FE_OFN219_IxIy_shift_4 I2=FE_OFN1256_n4488
XU328 NR2 $PINS O=intadd_102/CI I1=FE_OFN1477_FE_DBTN92_IyIt_shift_3
+ I2=IxIy_shift_5
XU329 NR2 $PINS O=n129 I1=FE_OFN219_IxIy_shift_4
+ I2=FE_OFN1174_FE_DBTN94_IyIt_shift_5
XU330 NR2 $PINS O=n128 I1=FE_OFN1456_FE_DBTN120_IxIy_shift_3
+ I2=FE_OFN293_FE_DBTN96_IyIt_shift_6
XU331 NR2 $PINS O=n127 I1=FE_OFN1334_IxIy_shift_5 I2=FE_OFN1257_n4488
XU332 FA1S $PINS S=intadd_103/A[2] CO=intadd_102/B[2] A=n129 B=n128 CI=n127
XU333 NR2 $PINS O=intadd_103/A[0] I1=FE_OFN852_IxIy_shift_1
+ I2=FE_DBTN96_IyIt_shift_6
XU334 NR2 $PINS O=intadd_103/B[0] I1=FE_OFN886_FE_DBTN117_IxIy_shift_0
+ I2=FE_RN_3
XU335 NR2 $PINS O=intadd_103/CI I1=FE_RN_1 I2=IxIy_shift_5
XU336 NR2 $PINS O=n131 I1=FE_OFN275_FE_DBTN165_n1651
+ I2=FE_OFN1192_FE_DBTN14_IyIt_shift_7
XU337 NR2 $PINS O=n130 I1=FE_OFN1240_n4484 I2=A[7]
XU338 FA1S $PINS S=intadd_103/B[2] CO=n135 A=n132 B=n131 CI=n130
XU339 NR2 $PINS O=n134 I1=FE_OFN219_IxIy_shift_4
+ I2=FE_OFN293_FE_DBTN96_IyIt_shift_6
XU340 NR2 $PINS O=n133 I1=FE_OFN1334_IxIy_shift_5
+ I2=FE_OFN1174_FE_DBTN94_IyIt_shift_5
XU341 FA1S $PINS S=intadd_103/B[3] CO=intadd_102/B[3] A=n135 B=n134 CI=n133
XU342 NR2 $PINS O=n137 I1=FE_OFN275_FE_DBTN165_n1651
+ I2=FE_OFN293_FE_DBTN96_IyIt_shift_6
XU343 NR2 $PINS O=n136 I1=FE_OFN1456_FE_DBTN120_IxIy_shift_3
+ I2=FE_OFN1174_FE_DBTN94_IyIt_shift_5
XU344 FA1S $PINS S=intadd_104/A[2] CO=intadd_102/A[1] A=n138 B=n137 CI=n136
XU345 NR2 $PINS O=intadd_104/A[0] I1=FE_OFN852_IxIy_shift_1
+ I2=FE_DBTN94_IyIt_shift_5
XU346 NR2 $PINS O=intadd_104/B[0] I1=FE_OFN886_FE_DBTN117_IxIy_shift_0
+ I2=FE_DBTN96_IyIt_shift_6
XU347 NR2 $PINS O=intadd_104/CI I1=FE_RN_1 I2=IxIy_shift_4
XU348 NR2 $PINS O=n141 I1=FE_OFN275_FE_DBTN165_n1651
+ I2=FE_OFN1174_FE_DBTN94_IyIt_shift_5
XU349 NR2 $PINS O=n140 I1=FE_OFN1477_FE_DBTN92_IyIt_shift_3
+ I2=FE_OFN219_IxIy_shift_4
XU350 NR2 $PINS O=n139 I1=FE_OFN1456_FE_DBTN120_IxIy_shift_3
+ I2=FE_OFN1256_n4488
XU351 FA1S $PINS S=intadd_112/A[1] CO=intadd_103/B[1] A=n141 B=n140 CI=n139
XU352 NR2 $PINS O=intadd_112/B[0] I1=FE_OFN275_FE_DBTN165_n1651
+ I2=FE_OFN1256_n4488
XU353 NR2 $PINS O=intadd_112/CI I1=FE_OFN1477_FE_DBTN92_IyIt_shift_3 I2=FE_RN_2
XU354 NR2 $PINS O=intadd_113/A[0] I1=FE_OFN1477_FE_DBTN92_IyIt_shift_3
+ I2=FE_DBTN165_n1651
XU355 NR2 $PINS O=intadd_113/B[0] I1=FE_OFN886_FE_DBTN117_IxIy_shift_0
+ I2=FE_DBTN94_IyIt_shift_5
XU356 NR2 $PINS O=intadd_113/CI I1=FE_RN_1 I2=FE_RN_2
XU357 OAI22S $PINS O=n150 A1=n144 A2=intadd_112/A[0] B1=n143 B2=intadd_112/A[0]
XU358 NR2 $PINS O=n149 I1=FE_OFN852_IxIy_shift_1 I2=FE_OFN1256_n4488
XU359 NR2 $PINS O=n148 I1=n155 I2=n154
XU360 FA1S $PINS S=intadd_101/A[4] CO=intadd_101/B[5] A=intadd_113/SUM[1]
+ B=n147 CI=intadd_112/SUM[0]
XU361 FA1 $PINS S=n153 CO=n147 A=n150 B=n149 CI=n148
XU362 NR2 $PINS O=n168 I1=FE_OFN852_IxIy_shift_1
+ I2=FE_OFN1476_FE_DBTN92_IyIt_shift_3
XU363 NR2 $PINS O=n167 I1=FE_OFN886_FE_DBTN117_IxIy_shift_0 I2=FE_OFN1256_n4488
XU364 NR2 $PINS O=n166 I1=FE_RN_1 I2=FE_DBTN165_n1651
XU365 FA1S $PINS S=intadd_101/A[3] CO=intadd_101/B[4] A=n153 B=n152
+ CI=intadd_113/SUM[0]
XU366 MOAI1S $PINS O=n164 A1=n155 A2=n154 B1=n155 B2=n154
XU367 NR2 $PINS O=n159 I1=n158 I2=n157
XU368 NR2 $PINS O=n162 I1=n160 I2=n159
XU369 INV1S $PINS O=intadd_101/B[3] I=n161
XU370 FA1S $PINS S=n165 CO=n161 A=n164 B=n163 CI=n162
XU371 INV1S $PINS O=intadd_101/A[2] I=n165
XU372 NR2 $PINS O=intadd_101/B[0] I1=FE_DBTN165_n1651 I2=n180
XU373 FA1S $PINS S=intadd_101/B[2] CO=n152 A=n168 B=n167 CI=n166
XU375 NR2 $PINS O=n233 I1=FE_OFN1147_FE_DBTN160_n2620 I2=FE_DBTN94_IyIt_shift_5
XU376 INV1S $PINS O=intadd_114/A[2] I=n169
XU377 NR2 $PINS O=intadd_114/A[0] I1=FE_DBTN157_n2891 I2=FE_RN_3
XU378 NR2 $PINS O=intadd_114/B[0] I1=FE_OFN4287_n
+ I2=FE_OFN1173_FE_DBTN94_IyIt_shift_5
XU380 NR2 $PINS O=intadd_114/CI I1=FE_OFN1651_IxIy_shift_14 I2=n4488
XU381 NR2 $PINS O=n172 I1=FE_OFN1615_IxIy_shift_12 I2=FE_RN_3
XU382 NR2 $PINS O=n171 I1=FE_OFN4287_n I2=FE_OFN292_FE_DBTN96_IyIt_shift_6
XU383 NR2 $PINS O=n170 I1=FE_OFN1651_IxIy_shift_14
+ I2=FE_OFN1173_FE_DBTN94_IyIt_shift_5
XU384 FA1S $PINS S=intadd_114/B[1] CO=intadd_114/B[2] A=n172 B=n171 CI=n170
XU385 NR2 $PINS O=n175 I1=FE_OFN1147_FE_DBTN160_n2620 I2=FE_OFN1241_n4484
XU386 INV1S $PINS O=intadd_105/A[2] I=n173
XU387 NR2 $PINS O=intadd_105/A[0] I1=FE_OFN4287_n
+ I2=FE_OFN1476_FE_DBTN92_IyIt_shift_3
XU388 NR2 $PINS O=intadd_105/B[0] I1=FE_DBTN157_n2891
+ I2=FE_OFN1173_FE_DBTN94_IyIt_shift_5
XU389 NR2 $PINS O=intadd_105/CI I1=FE_OFN4323_n
+ I2=FE_OFN292_FE_DBTN96_IyIt_shift_6
XU390 FA1S $PINS S=n177 CO=n173 A=n176 B=n175 CI=n174
XU391 INV1S $PINS O=intadd_106/A[2] I=n177
XU392 NR2 $PINS O=n192 I1=FE_OFN1147_FE_DBTN160_n2620
+ I2=FE_OFN1702_IyIt_shift_1
XU393 AOI22S $PINS O=n191 A1=FE_OFN4228_FE_OFN1118_IxIy_shift_8
+ A2=FE_OFN1141_IyIt_shift_7 B1=FE_DBTN126_IxIy_shift_13
+ B2=FE_OFN1498_FE_DBTN29_n4484
XU394 INV1S $PINS O=intadd_106/B[2] I=n178
XU395 NR2 $PINS O=intadd_106/A[0] I1=FE_OFN4331_FE_DBTN152_n3310
+ I2=FE_OFN292_FE_DBTN96_IyIt_shift_6
XU396 NR2 $PINS O=intadd_106/B[0] I1=FE_OFN1454_FE_DBTN123_IxIy_shift_10
+ I2=FE_OFN1173_FE_DBTN94_IyIt_shift_5
XU397 NR2 $PINS O=intadd_106/CI I1=FE_OFN1651_IxIy_shift_14
+ I2=FE_OFN1702_IyIt_shift_1
XU398 NR2 $PINS O=n196 I1=FE_OFN1147_FE_DBTN160_n2620 I2=n180
XU399 INV1S $PINS O=intadd_106/B[1] I=n181
XU400 NR2 $PINS O=n185 I1=FE_OFN4323_n I2=FE_RN_3
XU401 NR2 $PINS O=n184 I1=FE_OFN4287_n I2=FE_OFN1256_n4488
XU402 NR2 $PINS O=n183 I1=FE_OFN1651_IxIy_shift_14
+ I2=FE_OFN1476_FE_DBTN92_IyIt_shift_3
XU403 NR2 $PINS O=n188 I1=FE_OFN1615_IxIy_shift_12
+ I2=FE_OFN292_FE_DBTN96_IyIt_shift_6
XU404 FA1S $PINS S=intadd_105/B[1] CO=n186 A=n185 B=n184 CI=n183
XU405 FA1S $PINS S=intadd_106/B[3] CO=intadd_105/B[3] A=n188 B=n187 CI=n186
XU406 NR2 $PINS O=n189 I1=FE_OFN4287_n I2=FE_OFN1241_n4484
XU407 AO13S $PINS O=intadd_107/B[1] A1=n191 B1=FE_OFN1141_IyIt_shift_7
+ B2=FE_OFN4228_FE_OFN1118_IxIy_shift_8 B3=n189
XU408 NR2 $PINS O=intadd_107/A[0] I1=n190 I2=FE_OFN292_FE_DBTN96_IyIt_shift_6
XU409 NR2 $PINS O=intadd_107/B[0] I1=FE_OFN4331_FE_DBTN152_n3310
+ I2=FE_OFN1173_FE_DBTN94_IyIt_shift_5
XU410 NR2 $PINS O=intadd_107/CI I1=FE_OFN1615_IxIy_shift_12 I2=FE_OFN1241_n4484
XU411 FA1S $PINS S=n194 CO=n178 A=n193 B=n192 CI=n191
XU412 INV1S $PINS O=intadd_107/A[2] I=n194
XU413 NR2 $PINS O=intadd_115/A[0] I1=FE_OFN1454_FE_DBTN123_IxIy_shift_10
+ I2=FE_OFN1257_n4488
XU414 NR2 $PINS O=intadd_115/CI I1=FE_DBTN157_n2891
+ I2=FE_OFN1476_FE_DBTN92_IyIt_shift_3
XU415 FA1S $PINS S=n198 CO=n181 A=n197 B=n196 CI=n195
XU416 INV1S $PINS O=intadd_115/A[1] I=n198
XU417 NR2 $PINS O=intadd_116/A[0] I1=n190 I2=FE_OFN1173_FE_DBTN94_IyIt_shift_5
XU418 NR2 $PINS O=intadd_116/B[0] I1=FE_OFN1454_FE_DBTN123_IxIy_shift_10
+ I2=FE_OFN1476_FE_DBTN92_IyIt_shift_3
XU419 NR2 $PINS O=intadd_116/CI I1=FE_DBTN157_n2891 I2=FE_OFN1240_n4484
XU420 OAI22S $PINS O=n211 A1=n201 A2=intadd_115/B[0] B1=n200 B2=intadd_115/B[0]
XU421 NR2 $PINS O=n210 I1=n215 I2=n214
XU422 NR2 $PINS O=n209 I1=FE_OFN4331_FE_DBTN152_n3310 I2=FE_OFN1257_n4488
XU423 FA1S $PINS S=intadd_99/A[4] CO=intadd_99/B[5] A=n203 B=intadd_116/SUM[1]
+ CI=intadd_115/SUM[0]
XU424 NR2 $PINS O=n230 I1=n190 I2=FE_OFN1257_n4488
XU425 NR2 $PINS O=n229 I1=FE_OFN4331_FE_DBTN152_n3310
+ I2=FE_OFN1476_FE_DBTN92_IyIt_shift_3
XU426 NR2 $PINS O=n228 I1=FE_OFN1454_FE_DBTN123_IxIy_shift_10
+ I2=FE_OFN1240_n4484
XU427 FA1S $PINS S=n212 CO=n203 A=n211 B=n210 CI=n209
XU428 FA1S $PINS S=intadd_99/A[3] CO=intadd_99/B[4] A=n213 B=n212
+ CI=intadd_116/SUM[0]
XU429 MOAI1S $PINS O=n226 A1=n215 A2=n214 B1=n215 B2=n214
XU430 INV1S $PINS O=n217 I=n216
XU431 AOI13HS $PINS O=n225 A1=n217 B1=FE_DBTN92_IyIt_shift_3 B2=A[8] B3=n218
XU432 INV1S $PINS O=intadd_99/B[3] I=n221
XU434 NR2 $PINS O=intadd_99/CI I1=FE_OFN1454_FE_DBTN123_IxIy_shift_10 I2=n180
XU435 FA1S $PINS S=n227 CO=n221 A=n226 B=n225 CI=n224
XU436 INV1S $PINS O=intadd_99/A[2] I=n227
XU437 FA1S $PINS S=intadd_99/B[2] CO=n213 A=n230 B=n229 CI=n228
XU438 FA1S $PINS S=n169 CO=n238 A=n233 B=n232 CI=n231
XU440 NR2 $PINS O=n236 I1=FE_OFN1147_FE_DBTN160_n2620
+ I2=FE_OFN292_FE_DBTN96_IyIt_shift_6
XU441 INV1S $PINS O=intadd_99/B[11] I=n235
XU442 FA1S $PINS S=n235 CO=n239 A=n238 B=n237 CI=n236
XU443 INV1S $PINS O=intadd_99/B[12] I=n239
XU444 NR2 $PINS O=N18 I1=FE_OFN4326_n190 I2=n180
XU445 INV1S $PINS O=N33 I=intadd_99/n1
XU447 NR2 $PINS O=n294 I1=FE_OFN1127_IyIt_shift_15 I2=FE_OFN1335_IxIy_shift_5
XU448 INV1S $PINS O=intadd_117/A[2] I=n241
XU449 NR2 $PINS O=intadd_117/A[0] I1=n428 I2=FE_OFN1389_n252
XU450 NR2 $PINS O=intadd_117/B[0] I1=n253 I2=FE_OFN1335_IxIy_shift_5
XU451 NR2 $PINS O=intadd_117/CI I1=FE_OFN1026_FE_DBTN101_IyIt_shift_14
+ I2=FE_OFN1341_IxIy_shift_4
XU453 NR2 $PINS O=n244 I1=n327 I2=FE_OFN1389_n252
XU454 NR2 $PINS O=n243 I1=n253 I2=FE_OFN1644_n1653
XU455 NR2 $PINS O=n242 I1=FE_OFN1026_FE_DBTN101_IyIt_shift_14
+ I2=FE_OFN1335_IxIy_shift_5
XU456 FA1S $PINS S=intadd_117/B[1] CO=intadd_117/B[2] A=n244 B=n243 CI=n242
XU457 NR2 $PINS O=n247 I1=FE_OFN1127_IyIt_shift_15 I2=FE_OFN1602_n1651
XU458 INV1S $PINS O=intadd_108/A[2] I=n245
XU459 NR2 $PINS O=intadd_108/A[0] I1=n253 I2=FE_OFN1458_FE_DBTN120_IxIy_shift_3
XU460 NR2 $PINS O=intadd_108/B[0] I1=n428 I2=FE_OFN1335_IxIy_shift_5
XU461 NR2 $PINS O=intadd_108/CI I1=FE_OFN1696_n1659 I2=FE_DBTN163_n1653
XU462 FA1S $PINS S=n249 CO=n245 A=n248 B=n247 CI=n246
XU463 INV1S $PINS O=intadd_109/A[2] I=n249
XU464 NR2 $PINS O=n262 I1=FE_OFN1127_IyIt_shift_15 I2=FE_OFN127_IxIy_shift_1
XU465 INV1S $PINS O=intadd_109/B[2] I=n250
XU466 NR2 $PINS O=intadd_109/B[0] I1=FE_OFN1696_n1659
+ I2=FE_OFN1335_IxIy_shift_5
XU467 NR2 $PINS O=intadd_109/CI I1=FE_OFN1026_FE_DBTN101_IyIt_shift_14
+ I2=FE_OFN127_IxIy_shift_1
XU468 NR2 $PINS O=n267 I1=FE_OFN1127_IyIt_shift_15 I2=FE_OFN1623_IxIy_shift_0
XU469 INV1S $PINS O=intadd_109/B[1] I=n251
XU470 NR2 $PINS O=n257 I1=FE_OFN1696_n1659 I2=FE_OFN1389_n252
XU471 NR2 $PINS O=n256 I1=n253 I2=FE_OFN1341_IxIy_shift_4
XU472 NR2 $PINS O=n255 I1=FE_OFN1026_FE_DBTN101_IyIt_shift_14
+ I2=FE_OFN1458_FE_DBTN120_IxIy_shift_3
XU473 NR2 $PINS O=n260 I1=n327 I2=FE_OFN1644_n1653
XU474 FA1S $PINS S=intadd_108/B[1] CO=n258 A=n257 B=n256 CI=n255
XU475 FA1S $PINS S=intadd_109/B[3] CO=intadd_108/B[3] A=n260 B=n259 CI=n258
XU476 NR2 $PINS O=intadd_110/A[0] I1=FE_OFN1381_IyIt_shift_8
+ I2=FE_DBTN163_n1653
XU477 NR2 $PINS O=intadd_110/B[0] I1=FE_OFN1391_n462 I2=FE_OFN1335_IxIy_shift_5
XU478 NR2 $PINS O=intadd_110/CI I1=n327 I2=FE_OFN1602_n1651
XU479 FA1S $PINS S=n264 CO=n250 A=n263 B=n262 CI=n261
XU480 INV1S $PINS O=intadd_110/A[2] I=n264
XU481 NR2 $PINS O=intadd_118/A[0] I1=FE_OFN1696_n1659
+ I2=FE_OFN1341_IxIy_shift_4
XU482 NR2 $PINS O=intadd_118/CI I1=n428 I2=FE_OFN1458_FE_DBTN120_IxIy_shift_3
XU483 FA1S $PINS S=n269 CO=n251 A=n268 B=n267 CI=n266
XU484 INV1S $PINS O=intadd_118/A[1] I=n269
XU485 NR2 $PINS O=intadd_119/A[0] I1=FE_OFN4220_FE_OFN1381_IyIt_shift_8
+ I2=FE_OFN1334_IxIy_shift_5
XU486 NR2 $PINS O=intadd_119/B[0] I1=FE_OFN1696_n1659
+ I2=FE_OFN1458_FE_DBTN120_IxIy_shift_3
XU487 NR2 $PINS O=intadd_119/CI I1=n428 I2=FE_OFN1602_n1651
XU488 FA1 $PINS S=n70 CO=n274 A=n273 B=n272 CI=n271
XU489 FA1 $PINS S=intadd_98/A[4] CO=intadd_98/B[5] A=n274 B=intadd_119/SUM[1]
+ CI=intadd_118/SUM[0]
XU490 MOAI1S $PINS O=n287 A1=n276 A2=n275 B1=n276 B2=n275
XU491 INV1S $PINS O=n278 I=n277
XU492 AOI13HS $PINS O=n286 A1=n278 B1=FE_OFN1472_FE_DBTN98_IyIt_shift_8 B2=n280
+ B3=FE_OFN1457_FE_DBTN120_IxIy_shift_3
XU493 INV1S $PINS O=intadd_98/B[3] I=n283
XU494 NR2 $PINS O=intadd_98/CI I1=FE_OFN1694_n1659 I2=FE_OFN1623_IxIy_shift_0
XU495 FA1S $PINS S=n288 CO=n283 A=n287 B=n286 CI=n285
XU496 INV1S $PINS O=intadd_98/A[2] I=n288
XU497 FA1S $PINS S=intadd_98/B[2] CO=n71 A=n291 B=n290 CI=n289
XU498 FA1S $PINS S=n241 CO=n300 A=n294 B=n293 CI=n292
XU499 NR2 $PINS O=n298 I1=FE_OFN1127_IyIt_shift_15 I2=FE_OFN1644_n1653
XU500 INV1S $PINS O=intadd_98/B[11] I=n297
XU501 FA1S $PINS S=n297 CO=n301 A=n300 B=n299 CI=n298
XU502 INV1S $PINS O=intadd_98/B[12] I=n301
XU503 NR2 $PINS O=N35 I1=FE_OFN1381_IyIt_shift_8 I2=FE_OFN1623_IxIy_shift_0
XU504 INV1S $PINS O=N50 I=intadd_98/n1
XU506 OA222 $PINS O=n450 A1=FE_OFN1171_FE_DBTN126_IxIy_shift_13
+ A2=FE_DBTN160_n2620 B1=FE_OFN4288_n B2=n346 C1=FE_OFN1148_FE_DBTN160_n2620
+ C2=FE_OFN1651_IxIy_shift_14
XU507 AOI22S $PINS O=n310 A1=FE_OFN1025_FE_DBTN101_IyIt_shift_14
+ A2=FE_OFN4289_n B1=FE_OFN994_IyIt_shift_14 B2=FE_DBTN160_n2620
XU511 MOAI1S $PINS O=n449 A1=FE_OFN1185_FE_DBTN22_IyIt_shift_15 A2=FE_OFN4290_n
+ B1=FE_OFN1185_FE_DBTN22_IyIt_shift_15 B2=FE_OFN4290_n
XU512 AOI22S $PINS O=intadd_100/A[10] A1=FE_OFN1527_n450 A2=n310
+ B1=FE_OFN1528_n451 B2=n449
XU513 INV1S $PINS O=intadd_100/A[11] I=intadd_100/A[10]
XU516 MOAI1S $PINS O=n311 A1=IyIt_shift_15
+ A2=FE_OFN1171_FE_DBTN126_IxIy_shift_13 B1=IyIt_shift_15
+ B2=FE_OFN1171_FE_DBTN126_IxIy_shift_13
XU517 OA222 $PINS O=n417 A1=FE_OFN1407_FE_DBTN157_n2891
+ A2=FE_OFN1171_FE_DBTN126_IxIy_shift_13 B1=FE_OFN4223_FE_OFN1221_n2891
+ B2=FE_OFN1616_IxIy_shift_12 C1=FE_OFN1169_FE_DBTN126_IxIy_shift_13
+ C2=FE_OFN1615_IxIy_shift_12
XU518 MOAI1S $PINS O=n319 A1=FE_OFN1171_FE_DBTN126_IxIy_shift_13
+ A2=FE_OFN1025_FE_DBTN101_IyIt_shift_14 B1=FE_OFN1171_FE_DBTN126_IxIy_shift_13
+ B2=FE_OFN1025_FE_DBTN101_IyIt_shift_14
XU519 AOI22S $PINS O=n316 A1=FE_OFN1682_n424 A2=n311 B1=FE_OFN1543_n417 B2=n319
XU521 MOAI1S $PINS O=n317 A1=FE_OFN1130_IyIt_shift_13 A2=FE_OFN4290_n B1=B[13]
+ B2=FE_OFN4290_n
XU522 AOI22S $PINS O=n314 A1=FE_OFN1528_n451 A2=n310 B1=FE_OFN1527_n450 B2=n317
XU523 OA12 $PINS O=n313 A1=n311 B1=FE_OFN1682_n424 B2=FE_OFN1543_n417
XU524 INV1S $PINS O=intadd_100/B[10] I=n312
XU525 FA1S $PINS S=n315 CO=n312 A=n316 B=n314 CI=n313
XU526 INV1S $PINS O=intadd_100/A[9] I=n315
XU527 INV1S $PINS O=n447 I=n316
XU528 MOAI1S $PINS O=n320 A1=B[12] A2=FE_OFN4290_n B1=B[12] B2=FE_OFN4290_n
XU529 AOI22S $PINS O=n446 A1=FE_OFN1528_n451 A2=n317 B1=FE_OFN1527_n450 B2=n320
XU530 MOAI1S $PINS O=n326 A1=FE_OFN4364_n A2=FE_OFN1185_FE_DBTN22_IyIt_shift_15
+ B1=FE_OFN4364_n B2=FE_OFN1185_FE_DBTN22_IyIt_shift_15
XU531 MOAI1S $PINS O=n339 A1=FE_OFN4224_FE_OFN1221_n2891
+ A2=FE_OFN1025_FE_DBTN101_IyIt_shift_14 B1=FE_OFN4224_FE_OFN1221_n2891
+ B2=FE_OFN1025_FE_DBTN101_IyIt_shift_14
XU532 INV1S $PINS O=n318 I=n339
XU533 INV1S $PINS O=n324 I=n352
XU534 MOAI1S $PINS O=n328 A1=FE_OFN1130_IyIt_shift_13 A2=FE_OFN4341_n
+ B1=FE_OFN1130_IyIt_shift_13 B2=FE_OFN4341_n
XU535 AOI22S $PINS O=n323 A1=FE_OFN1682_n424 A2=n319 B1=FE_OFN1543_n417 B2=n328
XU536 MOAI1S $PINS O=n332 A1=FE_OFN1374_IyIt_shift_11 A2=FE_OFN4289_n
+ B1=FE_OFN1374_IyIt_shift_11 B2=FE_OFN4289_n
XU537 AOI22S $PINS O=n322 A1=FE_OFN1528_n451 A2=n320 B1=FE_OFN1527_n450 B2=n332
XU538 INV1S $PINS O=intadd_100/B[9] I=n321
XU539 FA1S $PINS S=n336 CO=n445 A=n324 B=n323 CI=n322
XU540 OAI22S $PINS O=n335 A1=n340 A2=n326 B1=n325 B2=n326
XU541 MOAI1S $PINS O=n342 A1=B[12] A2=FE_OFN4341_n B1=B[12] B2=FE_OFN4341_n
XU542 AOI22S $PINS O=n351 A1=FE_OFN1682_n424 A2=n328 B1=FE_OFN1543_n417 B2=n342
XU543 AOI22S $PINS O=n341 A1=FE_OFN1694_n1659 A2=FE_OFN1148_FE_DBTN160_n2620
+ B1=FE_OFN1693_n1659 B2=FE_DBTN160_n2620
XU544 AOI22S $PINS O=n350 A1=n451 A2=n332 B1=n450 B2=n341
XU545 INV1S $PINS O=intadd_100/A[8] I=n333
XU546 FA1S $PINS S=n337 CO=n333 A=n336 B=n335 CI=n334
XU547 INV1S $PINS O=intadd_100/A[7] I=n337
XU548 MOAI1S $PINS O=n361 A1=FE_OFN1131_IyIt_shift_13
+ A2=FE_OFN4224_FE_OFN1221_n2891 B1=FE_OFN1131_IyIt_shift_13
+ B2=FE_OFN4224_FE_OFN1221_n2891
XU549 MOAI1S $PINS O=n359 A1=n340 A2=n339 B1=n437 B2=n361
XU550 MOAI1S $PINS O=n365 A1=FE_DBTN160_n2620 A2=n462 B1=FE_DBTN160_n2620
+ B2=n462
XU551 AO22 $PINS O=n357 A1=n451 A2=n341 B1=n450 B2=n365
XU552 NR2 $PINS O=n358 I1=n359 I2=n357
XU553 MOAI1S $PINS O=n367 A1=FE_OFN1373_IyIt_shift_11
+ A2=FE_OFN1167_FE_DBTN126_IxIy_shift_13 B1=FE_OFN1373_IyIt_shift_11
+ B2=FE_OFN1167_FE_DBTN126_IxIy_shift_13
XU554 AOI22S $PINS O=n370 A1=FE_OFN1544_n424 A2=n342 B1=FE_OFN1543_n417 B2=n367
XU555 MOAI1S $PINS O=n349 A1=FE_OFN4340_n A2=FE_OFN1187_FE_DBTN22_IyIt_shift_15
+ B1=FE_OFN4340_n B2=FE_OFN1187_FE_DBTN22_IyIt_shift_15
XU556 NR2 $PINS O=n344 I1=FE_OFN4228_FE_OFN1118_IxIy_shift_8 I2=FE_OFN4340_n
XU557 NR2 $PINS O=n369 I1=n349 I2=n344
XU559 MXL2HS $PINS OB=n347 S=n451 A=FE_OFN1651_IxIy_shift_14
+ B=FE_OFN4219_FE_OFN1381_IyIt_shift_8
XU560 NR2 $PINS O=n377 I1=FE_OFN1148_FE_DBTN160_n2620 I2=n347
XU561 MOAI1S $PINS O=n376 A1=FE_OFN4326_n190 A2=n349 B1=n429
+ B2=FE_DBTN101_IyIt_shift_14
XU562 FA1S $PINS S=n354 CO=n334 A=n352 B=n351 CI=n350
XU563 INV1S $PINS O=intadd_100/B[7] I=n353
XU564 FA1S $PINS S=n356 CO=n353 A=n358 B=n355 CI=n354
XU565 INV1S $PINS O=intadd_100/A[6] I=n356
XU566 OAI22S $PINS O=n374 A1=n359 A2=n358 B1=n357 B2=n358
XU567 MOAI1S $PINS O=n384 A1=FE_OFN2726_n2891 A2=FE_OFN1390_n327
+ B1=FE_OFN1223_n2891 B2=FE_OFN1390_n327
XU568 AOI22S $PINS O=n387 A1=FE_DBTN87_n340 A2=n361 B1=n437 B2=n384
XU569 MOAI1S $PINS O=n364 A1=FE_OFN1379_IyIt_shift_8 A2=FE_OFN4289_n
+ B1=FE_OFN1379_IyIt_shift_8 B2=FE_OFN1148_FE_DBTN160_n2620
XU570 AOI22S $PINS O=n386 A1=FE_OFN1528_n451 A2=n365 B1=n450 B2=n364
XU572 AOI22S $PINS O=n385 A1=FE_OFN1544_n424 A2=n367 B1=FE_OFN1543_n417 B2=n393
XU573 FA1S $PINS S=n372 CO=n355 A=n370 B=n369 CI=n368
XU574 INV1S $PINS O=intadd_100/B[6] I=n371
XU575 FA1S $PINS S=n375 CO=n371 A=n374 B=n373 CI=n372
XU576 INV1S $PINS O=intadd_100/A[5] I=n375
XU577 MOAI1S $PINS O=n391 A1=n377 A2=n376 B1=n377 B2=n376
XU578 MOAI1S $PINS O=n381 A1=FE_OFN4340_n A2=FE_DBTN101_IyIt_shift_14
+ B1=FE_OFN4340_n B2=FE_DBTN101_IyIt_shift_14
XU579 AOI22S $PINS O=n395 A1=FE_OFN4229_FE_OFN1118_IxIy_shift_8 A2=n381 B1=n429
+ B2=n253
XU580 MOAI1S $PINS O=n412 A1=FE_OFN1373_IyIt_shift_11
+ A2=FE_OFN4223_FE_OFN1221_n2891 B1=FE_OFN1373_IyIt_shift_11
+ B2=FE_OFN4223_FE_OFN1221_n2891
XU581 AOI22S $PINS O=n394 A1=FE_OFN1484_FE_DBTN87_n340 A2=n384 B1=n437 B2=n412
XU582 FA1S $PINS S=n389 CO=n373 A=n387 B=n386 CI=n385
XU583 INV1S $PINS O=intadd_100/B[5] I=n388
XU584 FA1S $PINS S=n392 CO=n388 A=n391 B=n390 CI=n389
XU585 INV1S $PINS O=intadd_100/A[4] I=n392
XU586 MOAI1S $PINS O=n418 A1=FE_OFN1137_IyIt_shift_9
+ A2=FE_OFN1167_FE_DBTN126_IxIy_shift_13 B1=FE_OFN1137_IyIt_shift_9
+ B2=FE_OFN4288_n
XU587 AOI22S $PINS O=n406 A1=FE_OFN1544_n424 A2=n393 B1=n417 B2=n418
XU588 FA1S $PINS S=n405 CO=n390 A=n396 B=n395 CI=n394
XU590 MXL2HS $PINS OB=n398 S=n424 A=FE_OFN1615_IxIy_shift_12
+ B=FE_OFN4219_FE_OFN1381_IyIt_shift_8
XU591 NR2 $PINS O=n409 I1=FE_OFN4288_n I2=n398
XU592 MOAI1S $PINS O=n402 A1=FE_OFN4339_n A2=FE_OFN1132_IyIt_shift_13
+ B1=FE_OFN4339_n B2=FE_OFN1132_IyIt_shift_13
XU593 MOAI1S $PINS O=n408 A1=FE_OFN4326_n190 A2=n402 B1=n429 B2=FE_OFN1390_n327
XU594 INV1S $PINS O=intadd_100/B[4] I=n403
XU595 FA1S $PINS S=n407 CO=n403 A=n406 B=n405 CI=n404
XU596 INV1S $PINS O=intadd_100/A[3] I=n407
XU597 MOAI1S $PINS O=n433 A1=FE_OFN1693_n1659 A2=FE_OFN4223_FE_OFN1221_n2891
+ B1=FE_OFN1693_n1659 B2=FE_OFN4223_FE_OFN1221_n2891
XU598 AOI22S $PINS O=n421 A1=FE_OFN1484_FE_DBTN87_n340 A2=n412
+ B1=FE_OFN2735_n437 B2=n433
XU599 MOAI1S $PINS O=n416 A1=FE_OFN1379_IyIt_shift_8
+ A2=FE_OFN1169_FE_DBTN126_IxIy_shift_13 B1=FE_OFN1379_IyIt_shift_8
+ B2=FE_OFN1169_FE_DBTN126_IxIy_shift_13
XU600 AOI22S $PINS O=n420 A1=FE_OFN1544_n424 A2=n418 B1=n417 B2=n416
XU601 INV1S $PINS O=intadd_100/B[3] I=n419
XU602 FA1S $PINS S=n423 CO=n419 A=n422 B=n421 CI=n420
XU603 INV1S $PINS O=intadd_100/A[2] I=n423
XU604 MOAI1S $PINS O=n430 A1=FE_OFN4339_n A2=FE_OFN1390_n327 B1=FE_OFN4339_n
+ B2=FE_OFN1390_n327
XU605 AOI22S $PINS O=n442 A1=FE_OFN4229_FE_OFN1118_IxIy_shift_8 A2=n430 B1=n429
+ B2=n428
XU606 AOI22S $PINS O=n441 A1=FE_OFN1484_FE_DBTN87_n340 A2=n433
+ B1=FE_OFN2735_n437 B2=n432
XU607 INV1S $PINS O=intadd_100/B[2] I=n434
XU608 MOAI1S $PINS O=intadd_100/CI A1=n440 A2=FE_OFN4122_IyIt_shift_8
+ B1=FE_OFN1223_n2891 B2=FE_OFN2735_n437
XU609 FA1S $PINS S=n444 CO=n434 A=n443 B=n442 CI=n441
XU610 INV1S $PINS O=intadd_100/B[1] I=n444
XU611 FA1S $PINS S=n448 CO=n321 A=n447 B=n446 CI=n445
XU612 INV1S $PINS O=intadd_100/B[8] I=n448
XU613 OAI12HS $PINS O=intadd_100/B[11] A1=n449 B1=FE_OFN1528_n451
+ B2=FE_OFN1527_n450
XU614 INV1S $PINS O=N67 I=intadd_100/n1
XU615 INV1S $PINS O=intadd_97/B[21] I=s1_P3[13]
XU616 INV1S $PINS O=intadd_97/B[20] I=s1_P3[12]
XU617 INV1S $PINS O=intadd_97/B[19] I=s1_P3[11]
XU618 INV1S $PINS O=intadd_97/B[18] I=s1_P3[10]
XU619 INV1S $PINS O=intadd_97/A[17] I=s1_P3[9]
XU620 NR2 $PINS O=n452 I1=s1_P0[9] I2=s1_P2[1]
XU621 NR2 $PINS O=intadd_97/B[1] I1=intadd_97/A[2] I2=n452
XU622 FA1S $PINS S=n473 CO=n474 A=N37 B=N20 CI=N11
XU623 FA1S $PINS S=n475 CO=n476 A=N38 B=N21 CI=N12
XU624 FA1S $PINS S=n477 CO=n478 A=N39 B=N22 CI=N13
XU625 FA1S $PINS S=n479 CO=n480 A=N40 B=N23 CI=N14
XU626 NR2 $PINS O=n455 I1=n453 I2=intadd_101/n1
XU627 NR2 $PINS O=n456 I1=n455 I2=n454
XU628 FA1 $PINS S=n483 CO=n484 A=N42 B=N25 CI=n456
XU629 NR2 $PINS O=n459 I1=n190 I2=FE_OFN1381_IyIt_shift_8
XU630 FA1S $PINS S=n485 CO=n486 A=n459 B=N26 CI=N43
XU631 NR2 $PINS O=n466 I1=n459 I2=FE_DBTN152_n3310
XU632 MOAI1S $PINS O=n463 A1=FE_OFN1137_IyIt_shift_9 A2=FE_DBTN152_n3310
+ B1=FE_OFN1137_IyIt_shift_9 B2=FE_DBTN152_n3310
XU633 AN2 $PINS O=n465 I1=n463 I2=FE_OFN4229_FE_OFN1118_IxIy_shift_8
XU634 OA12 $PINS O=n467 A1=n464 B1=n466 B2=n465
XU635 FA1S $PINS S=n487 CO=n488 A=n467 B=N27 CI=N44
XU636 OAI22S $PINS O=n470 A1=n469 A2=intadd_100/B[0] B1=n468 B2=intadd_100/B[0]
XU637 FA1S $PINS S=n489 CO=n490 A=n470 B=N28 CI=N45
XU638 FA1S $PINS S=n491 CO=n492 A=N55 B=N29 CI=N46
XU639 FA1S $PINS S=n493 CO=n494 A=N56 B=N30 CI=N47
XU640 FA1S $PINS S=n495 CO=n496 A=N57 B=N31 CI=N48
XU641 FA1 $PINS S=N90 CO=intadd_97/n9 A=intadd_97/B[14] B=intadd_97/A[14]
+ CI=intadd_97/n10
XU642 FA1 $PINS S=N89 CO=intadd_97/n10 A=intadd_97/B[13] B=intadd_97/A[13]
+ CI=intadd_97/n11
XU643 FA1 $PINS S=N91 CO=intadd_97/n8 A=intadd_97/B[15] B=intadd_97/A[15]
+ CI=intadd_97/n9
XU644 FA1 $PINS S=N66 CO=intadd_100/n1 A=intadd_100/B[11] B=intadd_100/A[11]
+ CI=intadd_100/n2
XU645 FA1 $PINS S=N65 CO=intadd_100/n2 A=intadd_100/B[10] B=intadd_100/A[10]
+ CI=intadd_100/n3
Xs1_P1_reg[15] QDFFRBS $PINS Q=s1_P1[15] D=N33 CK=clk_clone1
+ RB=FE_OFN98_i_reset_n_i
Xs2_result_reg[29] QDFFRBS $PINS Q=result[29] D=N97 CK=clk_clone1
+ RB=FE_OFN149_i_reset_n_i
Xs2_result_reg[14] QDFFRBS $PINS Q=result[14] D=N82 CK=clk
+ RB=FE_OFN145_i_reset_n_i
XR_57 QDFFRBS $PINS Q=intadd_97/A[15] D=n498 CK=clk_clone1
+ RB=FE_OFN59_i_reset_n_i
XR_72 QDFFRBS $PINS Q=intadd_97/B[7] D=n483 CK=clk RB=FE_OFN114_i_reset_n_i
XU646 FA1 $PINS S=N64 CO=intadd_100/n3 A=intadd_100/B[9] B=intadd_100/A[9]
+ CI=intadd_100/n4
XU5 ND2S $PINS O=n201 I1=FE_OFN980_IxIy_shift_12 I2=FE_OFN1705_IyIt_shift_1
XU10 ND2S $PINS O=n102 I1=FE_OFN973_IxIy_shift_14 I2=FE_OFN1498_FE_DBTN29_n4484
XU13 ND2S $PINS O=n115 I1=FE_OFN1498_FE_DBTN29_n4484 I2=A[6]
XU17 ND2S $PINS O=n72 I1=A[8] I2=FE_OFN1498_FE_DBTN29_n4484
XU19 ND2S $PINS O=n158 I1=n4484 I2=A[1]
XU29 ND2S $PINS O=n99 I1=A[9] I2=FE_OFN4309_n
.ENDS

.SUBCKT mult_pipe_1 rst_n A[15] A[14] A[13] A[12] A[11] A[10] A[9] A[8] A[7]
+ A[6] A[5] A[4] A[3] A[2] A[1] A[0] B[15] B[14] B[13] B[12] B[11] B[10] B[9]
+ B[8] B[7] B[6] B[5] B[4] B[3] B[2] B[1] B[0] result[31] result[30] result[29]
+ result[28] result[27] result[26] result[25] result[24] result[23] result[22]
+ result[21] result[20] result[19] result[18] result[17] result[16] result[15]
+ result[14] result[13] result[12] result[11] result[10] result[9] result[8]
+ result[7] result[6] result[5] result[4] result[3] result[2] result[1]
+ result[0] IxIy_shift_4 IxIt_shift_7 IxIy_shift_5 n1437 n4487
+ FE_OFN115_i_reset_n_i FE_OFN105_i_reset_n_i FE_OFN104_i_reset_n_i
+ FE_OFN102_i_reset_n_i FE_OFN100_i_reset_n_i FE_OFN89_i_reset_n_i
+ FE_OFN88_i_reset_n_i FE_OFN86_i_reset_n_i FE_OFN69_i_reset_n_i
+ FE_OFN68_i_reset_n_i FE_OFN67_i_reset_n_i FE_OFN45_i_reset_n_i
+ FE_OFN44_i_reset_n_i FE_OFN24_i_reset_n_i FE_OFN136_IxIt_shift_1
+ FE_OFN178_n1437 FE_OFN233_IxIt_shift_7 FE_OFN251_n2620 clk_clone1 clk_clone3
+ clk_clone2 clk
XFE_PHC3216_N99 BUF1CK $PINS O=N99 I=FE_PHN3216_N99
XFE_PHC3128_N70 DELB $PINS O=FE_PHN3128_N70 I=N70
XFE_PHC3125_N71 DELB $PINS O=FE_PHN3125_N71 I=N71
XFE_PHC3123_N74 DELB $PINS O=FE_PHN3123_N74 I=N74
XFE_PHC3122_N72 DELB $PINS O=FE_PHN3122_N72 I=N72
XFE_PHC3121_N68 DELB $PINS O=N68 I=FE_PHN3121_N68
XFE_PHC3119_N75 DELB $PINS O=N75 I=FE_PHN3119_N75
XFE_PHC3111_N73 DELB $PINS O=FE_PHN3111_N73 I=N73
XFE_PHC3083_N69 DELB $PINS O=FE_PHN3083_N69 I=N69
XFE_PHC3054_N76 DELB $PINS O=FE_PHN3054_N76 I=N76
XFE_RC_42_0 XOR2HS $PINS O=n414 I1=FE_OFN1354_IxIt_shift_11
+ I2=FE_OFN4314_FE_DBTN156_n2891
XFE_RC_37_0 MAO222 $PINS O=n499 A1=N58 B1=N32 C1=N49
XFE_RC_36_0 XOR3 $PINS O=n498 I1=N58 I2=N32 I3=N49
XFE_OFC2886_IxIy_shift_8 BUF1 $PINS O=FE_OFN4321_n I=FE_OFN1569_IxIy_shift_8
XFE_OFC2880_FE_DBTN127_IxIy_shift_13 BUF1 $PINS O=FE_OFN4315_n
+ I=FE_OFN1163_FE_DBTN127_IxIy_shift_13
XFE_OFC2879_FE_DBTN156_n2891 BUF1 $PINS O=FE_OFN4314_FE_DBTN156_n2891
+ I=FE_DBTN156_n2891
XFE_OFC2869_FE_DBTN110_IxIt_shift_8 BUF1 $PINS O=FE_OFN4304_n
+ I=FE_OFN1462_FE_DBTN110_IxIt_shift_8
XFE_OFC2868_FE_DBTN110_IxIt_shift_8 BUF1 $PINS O=FE_OFN4303_n
+ I=FE_OFN1462_FE_DBTN110_IxIt_shift_8
XFE_OFC2867_FE_DBTN110_IxIt_shift_8 INV1S $PINS O=FE_OFN4302_n I=FE_OFN4300_n
XFE_OFC2866_FE_DBTN110_IxIt_shift_8 INV1S $PINS O=FE_OFN4301_n I=FE_OFN4300_n
XFE_OFC2865_FE_DBTN110_IxIt_shift_8 INV1S $PINS O=FE_OFN4300_n
+ I=FE_OFN1463_FE_DBTN110_IxIt_shift_8
XFE_OFC2837_FE_OFN1224_n2891 BUF1 $PINS O=FE_OFN4272_FE_OFN1224_n2891
+ I=FE_OFN1224_n2891
XFE_OFC2836_n427 BUF1CK $PINS O=FE_OFN4271_n427 I=n427
XFE_OFC2832_FE_OFN1000_n143 BUF1 $PINS O=FE_OFN4267_FE_OFN1000_n143
+ I=FE_OFN1000_n143
XFE_OFC2825_FE_OFN1392_n187 BUF1 $PINS O=FE_OFN4260_FE_OFN1392_n187
+ I=FE_OFN1392_n187
XFE_OFC2824_FE_OFN1611_IxIy_shift_12 BUF1 $PINS
+ O=FE_OFN4259_FE_OFN1611_IxIy_shift_12 I=FE_OFN1611_IxIy_shift_12
XFE_OFC2820_FE_OFN1161_FE_DBTN151_n3310 BUF1 $PINS
+ O=FE_OFN4255_FE_OFN1161_FE_DBTN151_n3310 I=FE_OFN1161_FE_DBTN151_n3310
XFE_OFC2792_FE_OFN1218_n2891 BUF1 $PINS O=FE_OFN4227_FE_OFN1218_n2891
+ I=FE_OFN1218_n2891
XFE_OFC2790_FE_OFN1218_n2891 BUF1 $PINS O=FE_OFN4225_FE_OFN1218_n2891
+ I=FE_OFN1218_n2891
XFE_OFC2768_FE_OFN1164_FE_DBTN127_IxIy_shift_13 BUF1 $PINS
+ O=FE_OFN4203_FE_OFN1164_FE_DBTN127_IxIy_shift_13
+ I=FE_OFN4201_FE_OFN1164_FE_DBTN127_IxIy_shift_13
XFE_OFC2767_FE_OFN1164_FE_DBTN127_IxIy_shift_13 BUF1 $PINS
+ O=FE_OFN4202_FE_OFN1164_FE_DBTN127_IxIy_shift_13
+ I=FE_OFN1164_FE_DBTN127_IxIy_shift_13
XFE_OFC2766_FE_OFN1164_FE_DBTN127_IxIy_shift_13 BUF1 $PINS
+ O=FE_OFN4201_FE_OFN1164_FE_DBTN127_IxIy_shift_13
+ I=FE_OFN1164_FE_DBTN127_IxIy_shift_13
XFE_OFC2758_FE_OFN1067_n3310 BUF1 $PINS O=FE_OFN4193_FE_OFN1067_n3310
+ I=FE_OFN1067_n3310
XFE_OFC2757_FE_OFN1067_n3310 BUF1 $PINS O=FE_OFN4192_FE_OFN1067_n3310
+ I=FE_OFN1067_n3310
XFE_OFC2745_FE_OFN1570_n2620 BUF1 $PINS O=FE_OFN4180_FE_OFN1570_n2620
+ I=FE_OFN4179_FE_OFN1570_n2620
XFE_OFC2744_FE_OFN1570_n2620 BUF1 $PINS O=FE_OFN4179_FE_OFN1570_n2620
+ I=FE_OFN251_n2620
XFE_RC_3_0 XOR2HS $PINS O=n319 I1=FE_OFN989_IxIt_shift_13
+ I2=FE_OFN1156_FE_DBTN159_n2620
XFE_RC_2_0 XOR2HS $PINS O=n419 I1=FE_OFN1213_n1658
+ I2=FE_OFN4201_FE_OFN1164_FE_DBTN127_IxIy_shift_13
XFE_OFC2617_IxIt_shift_1 BUF1 $PINS O=FE_OFN863_IxIt_shift_1
+ I=FE_OFN136_IxIt_shift_1
XFE_OFC2498_n341 BUF1 $PINS O=FE_OFN1761_n341 I=FE_OFN1485_FE_DBTN86_n341
XFE_OFC2496_n341 INV1S $PINS O=FE_OFN1485_FE_DBTN86_n341 I=n341
XFE_OFC2495_IxIt_shift_5 BUF1 $PINS O=FE_OFN288_FE_DBTN106_IxIt_shift_5
+ I=FE_OFN289_FE_DBTN106_IxIt_shift_5
XFE_OFC2493_IxIt_shift_5 BUF1 $PINS O=FE_OFN289_FE_DBTN106_IxIt_shift_5
+ I=FE_DBTN106_IxIt_shift_5
XFE_OFC2491_IxIt_shift_5 INV1S $PINS O=FE_DBTN106_IxIt_shift_5 I=B[5]
XFE_OFC2450_IxIt_shift_15 BUF1 $PINS O=FE_OFN1743_IxIt_shift_15
+ I=FE_OFN1741_IxIt_shift_15
XFE_OFC2449_IxIt_shift_15 INV1S $PINS O=FE_OFN1742_IxIt_shift_15
+ I=FE_OFN1741_IxIt_shift_15
XFE_OFC2448_IxIt_shift_15 BUF1 $PINS O=FE_OFN1741_IxIt_shift_15
+ I=FE_OFN983_IxIt_shift_15
XFE_OFC2447_IxIt_shift_15 INV1S $PINS O=FE_OFN1740_IxIt_shift_15
+ I=FE_OFN983_IxIt_shift_15
XFE_OFC2443_IxIt_shift_15 INV1S $PINS O=FE_OFN983_IxIt_shift_15 I=B[15]
XFE_OFC2436_IxIt_shift_6 BUF1 $PINS O=FE_OFN284_FE_DBTN108_IxIt_shift_6
+ I=FE_DBTN108_IxIt_shift_6
XFE_OFC2434_IxIt_shift_6 INV1S $PINS O=FE_DBTN108_IxIt_shift_6 I=B[6]
XFE_OFC2433_IxIt_shift_6 INV1S $PINS O=FE_OFN285_FE_DBTN108_IxIt_shift_6 I=B[6]
XFE_OFC2424_IxIt_shift_11 INV1S $PINS O=FE_OFN1731_IxIt_shift_11
+ I=FE_OFN1730_IxIt_shift_11
XFE_OFC2423_IxIt_shift_11 INV1S $PINS O=FE_OFN1730_IxIt_shift_11
+ I=FE_OFN1354_IxIt_shift_11
XFE_OFC2420_IxIt_shift_11 INV1S $PINS O=FE_OFN1353_IxIt_shift_11
+ I=FE_OFN1354_IxIt_shift_11
XFE_OFC2419_IxIt_shift_11 INV1S $PINS O=n429 I=FE_OFN1354_IxIt_shift_11
XFE_OFC2418_IxIt_shift_11 INV1S $PINS O=FE_OFN1354_IxIt_shift_11 I=B[11]
XFE_OFC2407_IxIt_shift_12 INV1S $PINS O=n427 I=FE_OFN1350_IxIt_shift_12
XFE_OFC2405_IxIt_shift_12 INV1S $PINS O=FE_OFN1350_IxIt_shift_12 I=B[12]
XFE_OFC2404_IxIt_shift_12 INV1S $PINS O=FE_OFN1529_n427 I=B[12]
XFE_OFC2367_IxIt_shift_13 INV1S $PINS O=FE_OFN1711_IxIt_shift_13
+ I=FE_OFN1710_IxIt_shift_13
XFE_OFC2366_IxIt_shift_13 INV1S $PINS O=FE_OFN1710_IxIt_shift_13
+ I=FE_OFN989_IxIt_shift_13
XFE_OFC2365_IxIt_shift_13 INV1S $PINS O=FE_OFN1709_IxIt_shift_13
+ I=FE_OFN989_IxIt_shift_13
XFE_OFC2364_IxIt_shift_13 INV1S $PINS O=FE_OFN992_IxIt_shift_13
+ I=FE_OFN989_IxIt_shift_13
XFE_OFC2363_IxIt_shift_13 INV1S $PINS O=FE_OFN991_IxIt_shift_13
+ I=FE_OFN989_IxIt_shift_13
XFE_OFC2359_IxIt_shift_13 INV1S $PINS O=FE_OFN989_IxIt_shift_13 I=B[13]
XFE_OFC2224_n1658 INV1S $PINS O=FE_OFN1674_n1658 I=FE_OFN1672_n1658
XFE_OFC2223_n1658 INV1S $PINS O=FE_OFN1673_n1658 I=FE_OFN1672_n1658
XFE_OFC2222_n1658 INV2 $PINS O=FE_OFN1672_n1658 I=FE_OFN1213_n1658
XFE_OFC2221_n1658 INV1S $PINS O=FE_OFN1671_n1658 I=FE_OFN1213_n1658
XFE_OFC2220_n1658 INV1S $PINS O=FE_OFN1670_n1658 I=FE_OFN1213_n1658
XFE_OFC2217_n1658 INV1S $PINS O=FE_OFN1213_n1658 I=B[9]
XFE_OFC2142_IxIy_shift_14 INV1S $PINS O=FE_OFN1650_IxIy_shift_14 I=n348
XFE_OFC2140_IxIy_shift_14 BUF1 $PINS O=n348 I=A[14]
XFE_OFC2124_IxIy_shift_6 BUF1 $PINS O=FE_OFN1647_IxIy_shift_6
+ I=FE_OFN281_FE_DBTN122_IxIy_shift_6
XFE_OFC2123_IxIy_shift_6 INV1S $PINS O=FE_OFN281_FE_DBTN122_IxIy_shift_6 I=A[6]
XFE_OFC2114_IxIy_shift_3 BUF1 $PINS O=FE_DBTN121_IxIy_shift_3
+ I=FE_OFN1455_FE_DBTN121_IxIy_shift_3
XFE_OFC2112_IxIy_shift_3 BUF1 $PINS O=FE_OFN1342_IxIy_shift_3
+ I=FE_OFN1344_IxIy_shift_3
XFE_OFC2111_IxIy_shift_3 INV1S $PINS O=FE_OFN1455_FE_DBTN121_IxIy_shift_3
+ I=FE_OFN1344_IxIy_shift_3
XFE_OFC2109_IxIy_shift_3 BUF1 $PINS O=FE_OFN1344_IxIy_shift_3 I=A[3]
XFE_OFC2066_IxIy_shift_2 BUF1 $PINS O=FE_OFN1638_IxIy_shift_2
+ I=FE_OFN283_FE_DBTN119_IxIy_shift_2
XFE_OFC2065_IxIy_shift_2 BUF1 $PINS O=FE_OFN1637_IxIy_shift_2
+ I=FE_OFN283_FE_DBTN119_IxIy_shift_2
XFE_OFC2064_IxIy_shift_2 BUF1 $PINS O=FE_OFN283_FE_DBTN119_IxIy_shift_2
+ I=FE_DBTN119_IxIy_shift_2
XFE_OFC2063_IxIy_shift_2 INV1S $PINS O=FE_OFN282_FE_DBTN119_IxIy_shift_2
+ I=FE_DBTN119_IxIy_shift_2
XFE_OFC2062_IxIy_shift_2 INV1S $PINS O=FE_DBTN119_IxIy_shift_2 I=A[2]
XFE_OFC1988_IxIy_shift_0 INV1S $PINS O=FE_DBTN118_IxIy_shift_0
+ I=FE_OFN855_IxIy_shift_0
XFE_OFC1987_IxIy_shift_0 INV1S $PINS O=FE_OFN853_IxIy_shift_0
+ I=FE_OFN855_IxIy_shift_0
XFE_OFC1986_IxIy_shift_0 BUF1 $PINS O=FE_OFN885_FE_DBTN118_IxIy_shift_0
+ I=FE_OFN855_IxIy_shift_0
XFE_OFC1984_IxIy_shift_0 BUF1 $PINS O=FE_OFN855_IxIy_shift_0 I=A[0]
XFE_OFC1976_IxIy_shift_12 INV1S $PINS O=FE_OFN1613_IxIy_shift_12
+ I=FE_OFN1611_IxIy_shift_12
XFE_OFC1969_IxIy_shift_12 INV1S $PINS O=FE_OFN1611_IxIy_shift_12
+ I=FE_OFN975_IxIy_shift_12
XFE_OFC1966_IxIy_shift_12 INV1S $PINS O=FE_OFN975_IxIy_shift_12 I=A[12]
XFE_OFC1906_n1437 BUF1 $PINS O=FE_OFN1599_n1437 I=n1437
XFE_OFC1903_n1437 INV1S $PINS O=FE_OFN1200_n1437 I=n1437
XFE_OFC1902_n1437 INV1S $PINS O=FE_RN_1 I=n1437
XFE_OFC1854_IxIy_shift_13 BUF1 $PINS O=FE_OFN1163_FE_DBTN127_IxIy_shift_13
+ I=FE_OFN4202_FE_OFN1164_FE_DBTN127_IxIy_shift_13
XFE_OFC1851_IxIy_shift_13 INV1S $PINS O=FE_DBTN127_IxIy_shift_13
+ I=FE_OFN1100_IxIy_shift_13
XFE_OFC1850_IxIy_shift_13 BUF1 $PINS O=FE_OFN1164_FE_DBTN127_IxIy_shift_13
+ I=FE_OFN1100_IxIy_shift_13
XFE_OFC1848_IxIy_shift_13 INV1S $PINS O=FE_OFN1098_IxIy_shift_13
+ I=FE_OFN1100_IxIy_shift_13
XFE_OFC1847_IxIy_shift_13 INV1S $PINS O=FE_OFN1166_FE_DBTN127_IxIy_shift_13
+ I=FE_OFN1100_IxIy_shift_13
XFE_OFC1845_IxIy_shift_13 INV1S $PINS O=FE_OFN1100_IxIy_shift_13 I=A[13]
XFE_OFC1825_IxIy_shift_7 BUF1 $PINS O=n250 I=FE_OFN1120_IxIy_shift_7
XFE_OFC1822_IxIy_shift_7 BUF1 $PINS O=FE_OFN1122_IxIy_shift_7 I=A[7]
XFE_OFC1821_IxIy_shift_7 INV1S $PINS O=FE_OFN1120_IxIy_shift_7 I=A[7]
XFE_OFC1811_IxIy_shift_1 BUF1 $PINS O=FE_OFN1576_IxIy_shift_1 I=n143
XFE_OFC1810_IxIy_shift_1 INV2 $PINS O=FE_OFN1000_n143 I=n143
XFE_OFC1804_IxIy_shift_1 INV1S $PINS O=n143 I=FE_OFN845_IxIy_shift_1
XFE_OFC1802_IxIy_shift_1 BUF1 $PINS O=FE_OFN845_IxIy_shift_1 I=A[1]
XFE_OFC1743_n2620 INV1S $PINS O=FE_OFN1571_n2620 I=FE_OFN4179_FE_OFN1570_n2620
XFE_OFC1742_n2620 INV1S $PINS O=FE_OFN1154_FE_DBTN159_n2620
+ I=FE_OFN4179_FE_OFN1570_n2620
XFE_OFC1732_IxIy_shift_8 INV1S $PINS O=FE_OFN1569_IxIy_shift_8
+ I=FE_OFN1392_n187
XFE_OFC1727_IxIy_shift_8 INV1S $PINS O=FE_OFN1392_n187
+ I=FE_OFN1107_IxIy_shift_8
XFE_OFC1725_IxIy_shift_8 INV1S $PINS O=FE_OFN1114_IxIy_shift_8
+ I=FE_OFN1107_IxIy_shift_8
XFE_OFC1724_IxIy_shift_8 INV1S $PINS O=FE_OFN1111_IxIy_shift_8
+ I=FE_OFN1107_IxIy_shift_8
XFE_OFC1723_IxIy_shift_8 INV1S $PINS O=FE_OFN1110_IxIy_shift_8
+ I=FE_OFN1107_IxIy_shift_8
XFE_OFC1720_IxIy_shift_8 INV1S $PINS O=FE_OFN1107_IxIy_shift_8 I=A[8]
XFE_OFC1658_IxIy_shift_10 BUF1 $PINS O=FE_OFN1561_IxIy_shift_10
+ I=FE_OFN1322_IxIy_shift_10
XFE_OFC1657_IxIy_shift_10 INV1S $PINS O=FE_OFN1453_FE_DBTN124_IxIy_shift_10
+ I=FE_OFN1322_IxIy_shift_10
XFE_OFC1651_IxIy_shift_10 INV2CK $PINS O=FE_OFN1322_IxIy_shift_10 I=A[10]
XFE_OFC1648_IxIt_shift_8 INV1S $PINS O=FE_OFN1463_FE_DBTN110_IxIt_shift_8
+ I=FE_OFN1365_IxIt_shift_8
XFE_OFC1647_IxIt_shift_8 BUF1 $PINS O=FE_OFN1462_FE_DBTN110_IxIt_shift_8
+ I=FE_OFN1365_IxIt_shift_8
XFE_OFC1642_IxIt_shift_8 INV1S $PINS O=FE_OFN1365_IxIt_shift_8 I=B[8]
XFE_OFC1635_n3310 BUF1 $PINS O=FE_OFN1161_FE_DBTN151_n3310 I=FE_DBTN151_n3310
XFE_OFC1634_n3310 INV1S $PINS O=FE_OFN1067_n3310 I=FE_DBTN151_n3310
XFE_OFC1628_n3310 INV2 $PINS O=FE_DBTN151_n3310 I=FE_OFN1070_n3310
XFE_OFC1623_n3310 INV1S $PINS O=FE_OFN1070_n3310 I=A[9]
XFE_OFC1586_n2891 BUF1 $PINS O=FE_DBTN156_n2891 I=FE_OFN1224_n2891
XFE_OFC1581_n2891 BUF1 $PINS O=FE_OFN1218_n2891 I=FE_OFN1222_n2891
XFE_OFC1580_n2891 INV1S $PINS O=FE_OFN1224_n2891 I=FE_OFN1222_n2891
XFE_OFC1574_n2891 BUF1 $PINS O=FE_OFN1222_n2891 I=A[11]
XFE_OFC1546_n438 BUF1 $PINS O=FE_OFN1548_n438 I=n438
XFE_OFC1545_n425 BUF1 $PINS O=FE_OFN1547_n425 I=n425
XFE_OFC1544_n418 BUF1 $PINS O=FE_OFN1546_n418 I=n418
XFE_OFC1529_n452 BUF1 $PINS O=FE_OFN1531_n452 I=n452
XFE_OFC1528_n451 BUF1 $PINS O=FE_OFN1530_n451 I=n451
XFE_OFC1497_FE_DBTN28_IxIt_shift_7 BUF1 $PINS
+ O=FE_OFN1499_FE_DBTN28_IxIt_shift_7 I=B[7]
XFE_OFC1466_FE_DBTN104_IxIt_shift_3 BUF1 $PINS
+ O=FE_OFN1468_FE_DBTN104_IxIt_shift_3 I=FE_DBTN104_IxIt_shift_3
XFE_OFC1465_FE_DBTN104_IxIt_shift_3 BUF1 $PINS
+ O=FE_OFN1467_FE_DBTN104_IxIt_shift_3 I=FE_DBTN104_IxIt_shift_3
XFE_OFC1457_FE_DBTN113_IxIt_shift_10 BUF1 $PINS
+ O=FE_OFN1459_FE_DBTN113_IxIt_shift_10 I=FE_DBTN113_IxIt_shift_10
XFE_OFC1368_IxIt_shift_3 BUF1 $PINS O=FE_OFN1370_IxIt_shift_3 I=B[3]
XFE_OFC1366_IxIt_shift_7 BUF1 $PINS O=FE_OFN1368_IxIt_shift_7
+ I=FE_OFN233_IxIt_shift_7
XFE_OFC1356_IxIt_shift_10 BUF1 $PINS O=FE_OFN1358_IxIt_shift_10
+ I=FE_OFN1357_IxIt_shift_10
XFE_OFC1355_IxIt_shift_10 BUF1 $PINS O=FE_OFN1357_IxIt_shift_10 I=B[10]
XFE_OFC1338_IxIy_shift_4 BUF1 $PINS O=FE_OFN1340_IxIy_shift_4
+ I=FE_OFN1338_IxIy_shift_4
XFE_OFC1336_IxIy_shift_4 BUF1 $PINS O=FE_OFN1338_IxIy_shift_4 I=IxIy_shift_4
XFE_OFC1331_IxIy_shift_5 BUF1 $PINS O=FE_OFN1333_IxIy_shift_5
+ I=FE_OFN1329_IxIy_shift_5
XFE_OFC1327_IxIy_shift_5 BUF1 $PINS O=FE_OFN1329_IxIy_shift_5 I=IxIy_shift_5
XFE_OFC1250_n4487 BUF1 $PINS O=FE_OFN1252_n4487 I=FE_OFN1250_n4487
XFE_OFC1248_n4487 BUF1 $PINS O=FE_OFN1250_n4487 I=n4487
XFE_OFC1154_FE_DBTN159_n2620 BUF1 $PINS O=FE_OFN1156_FE_DBTN159_n2620
+ I=FE_OFN1155_FE_DBTN159_n2620
XFE_OFC1153_FE_DBTN159_n2620 BUF1 $PINS O=FE_OFN1155_FE_DBTN159_n2620
+ I=FE_OFN1154_FE_DBTN159_n2620
XFE_OFC1019_FE_DBTN114_IxIt_shift_14 BUF1 $PINS
+ O=FE_OFN1021_FE_DBTN114_IxIt_shift_14 I=FE_DBTN114_IxIt_shift_14
XFE_OFC1018_FE_DBTN114_IxIt_shift_14 BUF1 $PINS
+ O=FE_OFN1020_FE_DBTN114_IxIt_shift_14 I=FE_DBTN114_IxIt_shift_14
XFE_OFC983_IxIt_shift_14 BUF1 $PINS O=FE_OFN985_IxIt_shift_14 I=B[14]
XFE_OFC868_IxIt_shift_0 INV1S $PINS O=FE_OFN870_IxIt_shift_0
+ I=FE_OFN868_IxIt_shift_0
XFE_OFC867_IxIt_shift_0 INV1S $PINS O=FE_OFN869_IxIt_shift_0
+ I=FE_OFN868_IxIt_shift_0
XFE_OFC866_IxIt_shift_0 INV2 $PINS O=FE_OFN868_IxIt_shift_0
+ I=FE_OFN867_IxIt_shift_0
XFE_OFC865_IxIt_shift_0 BUF2 $PINS O=FE_OFN867_IxIt_shift_0 I=B[0]
XFE_OFC862_IxIt_shift_1 BUF2 $PINS O=FE_OFN864_IxIt_shift_1
+ I=FE_OFN863_IxIt_shift_1
XFE_OFC268_i_reset_n_i BUF1 $PINS O=FE_OFN270_i_reset_n_i
+ I=FE_OFN269_i_reset_n_i
XFE_OFC267_i_reset_n_i BUF1 $PINS O=FE_OFN269_i_reset_n_i
+ I=FE_OFN266_i_reset_n_i
XFE_OFC264_i_reset_n_i BUF1 $PINS O=FE_OFN266_i_reset_n_i
+ I=FE_OFN260_i_reset_n_i
XFE_OFC260_i_reset_n_i BUF1 $PINS O=FE_OFN262_i_reset_n_i
+ I=FE_OFN229_i_reset_n_i
XFE_OFC258_i_reset_n_i BUF1 $PINS O=FE_OFN260_i_reset_n_i
+ I=FE_OFN104_i_reset_n_i
XFE_OFC227_i_reset_n_i INV1S $PINS O=FE_OFN229_i_reset_n_i
+ I=FE_OFN88_i_reset_n_i
XFE_OFC187_i_reset_n_i BUF1 $PINS O=FE_OFN189_i_reset_n_i
+ I=FE_OFN69_i_reset_n_i
XFE_OFC186_i_reset_n_i BUF1 $PINS O=FE_OFN188_i_reset_n_i
+ I=FE_OFN69_i_reset_n_i
XFE_OFC54_i_reset_n_i BUF1 $PINS O=FE_OFN55_i_reset_n_i I=rst_n
XFE_DBTC114_IxIt_shift_14 INV1S $PINS O=FE_DBTN114_IxIt_shift_14
+ I=FE_OFN985_IxIt_shift_14
XFE_DBTC113_IxIt_shift_10 INV1S $PINS O=FE_DBTN113_IxIt_shift_10
+ I=FE_OFN1358_IxIt_shift_10
XFE_DBTC104_IxIt_shift_3 INV1S $PINS O=FE_DBTN104_IxIt_shift_3
+ I=FE_OFN1370_IxIt_shift_3
Xs1_P0_reg[9] QDFFRBN $PINS Q=s1_P0[9] D=N10 CK=clk RB=FE_OFN266_i_reset_n_i
Xs1_P0_reg[7] QDFFRBN $PINS Q=FE_PHN3119_N75 D=N8 CK=clk_clone2
+ RB=FE_OFN68_i_reset_n_i
Xs1_P0_reg[5] QDFFRBN $PINS Q=N73 D=N6 CK=clk_clone2 RB=FE_OFN102_i_reset_n_i
Xs1_P0_reg[4] QDFFRBN $PINS Q=N72 D=N5 CK=clk_clone2 RB=FE_OFN68_i_reset_n_i
Xs1_P0_reg[3] QDFFRBN $PINS Q=N71 D=N4 CK=clk_clone2 RB=FE_OFN68_i_reset_n_i
Xs1_P0_reg[2] QDFFRBN $PINS Q=N70 D=N3 CK=clk_clone2 RB=FE_OFN68_i_reset_n_i
Xs1_P0_reg[1] QDFFRBN $PINS Q=N69 D=N2 CK=clk_clone2 RB=FE_OFN24_i_reset_n_i
Xs1_P0_reg[0] QDFFRBN $PINS Q=FE_PHN3121_N68 D=N1 CK=clk_clone2
+ RB=FE_OFN68_i_reset_n_i
Xs1_P1_reg[15] QDFFRBN $PINS Q=s1_P1[15] D=N33 CK=clk_clone3
+ RB=FE_OFN229_i_reset_n_i
Xs1_P1_reg[1] QDFFRBN $PINS Q=s1_P1[1] D=N19 CK=clk RB=FE_OFN260_i_reset_n_i
Xs1_P2_reg[15] QDFFRBN $PINS Q=s1_P2[15] D=N50 CK=clk_clone3
+ RB=FE_OFN229_i_reset_n_i
Xs1_P2_reg[1] QDFFRBN $PINS Q=s1_P2[1] D=N36 CK=clk RB=FE_OFN269_i_reset_n_i
Xs1_P3_reg[15] QDFFRBN $PINS Q=s1_P3[15] D=N67 CK=clk_clone3
+ RB=FE_OFN262_i_reset_n_i
Xs1_P3_reg[14] QDFFRBN $PINS Q=s1_P3[14] D=N66 CK=clk_clone3
+ RB=FE_OFN262_i_reset_n_i
Xs1_P3_reg[13] QDFFRBN $PINS Q=s1_P3[13] D=N65 CK=clk_clone3
+ RB=FE_OFN229_i_reset_n_i
Xs1_P3_reg[12] QDFFRBN $PINS Q=s1_P3[12] D=N64 CK=clk_clone3
+ RB=FE_OFN262_i_reset_n_i
Xs1_P3_reg[10] QDFFRBN $PINS Q=s1_P3[10] D=N62 CK=clk_clone3
+ RB=FE_OFN262_i_reset_n_i
Xs1_P3_reg[9] QDFFRBN $PINS Q=s1_P3[9] D=N61 CK=clk_clone3
+ RB=FE_OFN262_i_reset_n_i
Xs1_P3_reg[8] QDFFRBN $PINS Q=s1_P3[8] D=N60 CK=clk_clone3
+ RB=FE_OFN229_i_reset_n_i
Xs1_P3_reg[7] QDFFRBN $PINS Q=s1_P3[7] D=N59 CK=clk_clone3
+ RB=FE_OFN229_i_reset_n_i
Xs2_result_reg[31] QDFFRBN $PINS Q=result[31] D=N99 CK=clk_clone3
+ RB=FE_OFN89_i_reset_n_i
Xs2_result_reg[30] QDFFRBN $PINS Q=result[30] D=N98 CK=clk_clone3
+ RB=FE_OFN89_i_reset_n_i
Xs2_result_reg[29] QDFFRBN $PINS Q=result[29] D=N97 CK=clk_clone3
+ RB=FE_OFN89_i_reset_n_i
Xs2_result_reg[28] QDFFRBN $PINS Q=result[28] D=N96 CK=clk_clone3
+ RB=FE_OFN115_i_reset_n_i
Xs2_result_reg[27] QDFFRBN $PINS Q=result[27] D=N95 CK=clk_clone3
+ RB=FE_OFN115_i_reset_n_i
Xs2_result_reg[26] QDFFRBN $PINS Q=result[26] D=N94 CK=clk_clone3
+ RB=FE_OFN115_i_reset_n_i
Xs2_result_reg[25] QDFFRBN $PINS Q=result[25] D=N93 CK=clk_clone3
+ RB=FE_OFN115_i_reset_n_i
Xs2_result_reg[24] QDFFRBN $PINS Q=result[24] D=N92 CK=clk_clone3
+ RB=FE_OFN115_i_reset_n_i
Xs2_result_reg[23] QDFFRBN $PINS Q=result[23] D=N91 CK=clk_clone3
+ RB=FE_OFN105_i_reset_n_i
Xs2_result_reg[22] QDFFRBN $PINS Q=result[22] D=N90 CK=clk_clone3
+ RB=FE_OFN45_i_reset_n_i
Xs2_result_reg[20] QDFFRBN $PINS Q=result[20] D=N88 CK=clk_clone3
+ RB=FE_OFN45_i_reset_n_i
Xs2_result_reg[19] QDFFRBN $PINS Q=result[19] D=N87 CK=clk_clone3
+ RB=FE_OFN188_i_reset_n_i
Xs2_result_reg[18] QDFFRBN $PINS Q=result[18] D=N86 CK=clk_clone3
+ RB=FE_OFN100_i_reset_n_i
Xs2_result_reg[17] QDFFRBN $PINS Q=result[17] D=N85 CK=clk_clone3
+ RB=FE_OFN188_i_reset_n_i
Xs2_result_reg[16] QDFFRBN $PINS Q=result[16] D=N84 CK=clk_clone2
+ RB=FE_OFN188_i_reset_n_i
Xs2_result_reg[15] QDFFRBN $PINS Q=result[15] D=N83 CK=clk_clone2
+ RB=FE_OFN188_i_reset_n_i
Xs2_result_reg[14] QDFFRBN $PINS Q=result[14] D=N82 CK=clk_clone2
+ RB=FE_OFN100_i_reset_n_i
Xs2_result_reg[13] QDFFRBN $PINS Q=result[13] D=N81 CK=clk_clone2
+ RB=FE_OFN100_i_reset_n_i
Xs2_result_reg[12] QDFFRBN $PINS Q=result[12] D=N80 CK=clk_clone2
+ RB=FE_OFN100_i_reset_n_i
Xs2_result_reg[11] QDFFRBN $PINS Q=result[11] D=N79 CK=clk_clone2
+ RB=FE_OFN44_i_reset_n_i
Xs2_result_reg[10] QDFFRBN $PINS Q=result[10] D=N78 CK=clk_clone2
+ RB=FE_OFN44_i_reset_n_i
Xs2_result_reg[9] QDFFRBN $PINS Q=result[9] D=N77 CK=clk_clone2
+ RB=FE_OFN67_i_reset_n_i
Xs2_result_reg[8] QDFFRBN $PINS Q=result[8] D=FE_PHN3054_N76 CK=clk_clone2
+ RB=FE_OFN86_i_reset_n_i
Xs2_result_reg[7] QDFFRBN $PINS Q=result[7] D=N75 CK=clk_clone2
+ RB=FE_OFN24_i_reset_n_i
Xs2_result_reg[5] QDFFRBN $PINS Q=result[5] D=FE_PHN3111_N73 CK=clk_clone2
+ RB=FE_OFN24_i_reset_n_i
Xs2_result_reg[4] QDFFRBN $PINS Q=result[4] D=FE_PHN3122_N72 CK=clk_clone2
+ RB=FE_OFN24_i_reset_n_i
Xs2_result_reg[3] QDFFRBN $PINS Q=result[3] D=FE_PHN3125_N71 CK=clk_clone2
+ RB=FE_OFN55_i_reset_n_i
Xs2_result_reg[2] QDFFRBN $PINS Q=result[2] D=FE_PHN3128_N70 CK=clk_clone1
+ RB=FE_OFN55_i_reset_n_i
Xs2_result_reg[1] QDFFRBN $PINS Q=result[1] D=FE_PHN3083_N69 CK=clk_clone2
+ RB=FE_OFN55_i_reset_n_i
Xs2_result_reg[0] QDFFRBN $PINS Q=result[0] D=N68 CK=clk_clone2
+ RB=FE_OFN67_i_reset_n_i
Xintadd_76/U14 FA1 $PINS S=N20 CO=intadd_76/n13 A=intadd_76/B[0]
+ B=intadd_76/A[0] CI=intadd_76/CI
Xintadd_76/U13 FA1S $PINS S=N21 CO=intadd_76/n12 A=intadd_76/B[1]
+ B=intadd_76/A[1] CI=intadd_76/n13
Xintadd_76/U12 FA1 $PINS S=N22 CO=intadd_76/n11 A=intadd_76/B[2]
+ B=intadd_76/A[2] CI=intadd_76/n12
Xintadd_76/U11 FA1 $PINS S=N23 CO=intadd_76/n10 A=intadd_76/B[3]
+ B=intadd_76/A[3] CI=intadd_76/n11
Xintadd_76/U10 FA1 $PINS S=N24 CO=intadd_76/n9 A=intadd_76/B[4]
+ B=intadd_76/A[4] CI=intadd_76/n10
Xintadd_76/U9 FA1 $PINS S=N25 CO=intadd_76/n8 A=intadd_76/B[5] B=intadd_76/A[5]
+ CI=intadd_76/n9
Xintadd_76/U8 FA1 $PINS S=N26 CO=intadd_76/n7 A=intadd_93/n1 B=intadd_76/A[6]
+ CI=intadd_76/n8
Xintadd_76/U7 FA1 $PINS S=N27 CO=intadd_76/n6 A=intadd_92/n1 B=intadd_76/A[7]
+ CI=intadd_76/n7
Xintadd_76/U6 FA1 $PINS S=N28 CO=intadd_76/n5 A=intadd_84/n1 B=intadd_76/A[8]
+ CI=intadd_76/n6
Xintadd_76/U5 FA1 $PINS S=N29 CO=intadd_76/n4 A=intadd_83/n1 B=intadd_76/A[9]
+ CI=intadd_76/n5
Xintadd_76/U4 FA1 $PINS S=N30 CO=intadd_76/n3 A=intadd_82/n1 B=intadd_76/A[10]
+ CI=intadd_76/n4
Xintadd_76/U3 FA1 $PINS S=N31 CO=intadd_76/n2 A=intadd_76/B[11] B=intadd_91/n1
+ CI=intadd_76/n3
Xintadd_76/U2 FA1 $PINS S=N32 CO=intadd_76/n1 A=intadd_76/B[12]
+ B=intadd_76/A[12] CI=intadd_76/n2
Xintadd_79/U5 FA1S $PINS S=intadd_79/SUM[0] CO=intadd_79/n4 A=intadd_79/B[0]
+ B=intadd_79/A[0] CI=intadd_79/CI
Xintadd_79/U4 FA1S $PINS S=intadd_79/SUM[1] CO=intadd_79/n3 A=intadd_79/B[1]
+ B=intadd_79/A[1] CI=intadd_79/n4
Xintadd_79/U3 FA1S $PINS S=intadd_79/SUM[2] CO=intadd_79/n2 A=intadd_79/B[2]
+ B=intadd_79/A[2] CI=intadd_79/n3
Xintadd_79/U2 FA1S $PINS S=intadd_79/SUM[3] CO=intadd_79/n1 A=intadd_79/B[3]
+ B=intadd_79/A[3] CI=intadd_79/n2
Xintadd_80/U5 FA1S $PINS S=intadd_80/SUM[0] CO=intadd_80/n4 A=intadd_80/B[0]
+ B=intadd_80/A[0] CI=intadd_80/CI
Xintadd_80/U4 FA1S $PINS S=intadd_80/SUM[1] CO=intadd_80/n3 A=intadd_80/B[1]
+ B=intadd_80/A[1] CI=intadd_80/n4
Xintadd_80/U3 FA1S $PINS S=intadd_80/SUM[2] CO=intadd_80/n2 A=intadd_80/B[2]
+ B=intadd_80/A[2] CI=intadd_80/n3
Xintadd_80/U2 FA1S $PINS S=intadd_80/SUM[3] CO=intadd_80/n1 A=intadd_80/B[3]
+ B=intadd_79/SUM[2] CI=intadd_80/n2
Xintadd_81/U5 FA1S $PINS S=intadd_81/SUM[0] CO=intadd_81/n4 A=intadd_81/B[0]
+ B=intadd_81/A[0] CI=intadd_81/CI
Xintadd_81/U4 FA1S $PINS S=intadd_81/SUM[1] CO=intadd_81/n3 A=intadd_81/B[1]
+ B=intadd_81/A[1] CI=intadd_81/n4
Xintadd_81/U3 FA1S $PINS S=intadd_81/SUM[2] CO=intadd_81/n2 A=intadd_79/SUM[0]
+ B=intadd_81/A[2] CI=intadd_81/n3
Xintadd_81/U2 FA1S $PINS S=intadd_81/SUM[3] CO=intadd_81/n1 A=intadd_79/SUM[1]
+ B=intadd_80/SUM[2] CI=intadd_81/n2
Xintadd_82/U5 FA1S $PINS S=intadd_82/SUM[0] CO=intadd_82/n4 A=intadd_82/B[0]
+ B=intadd_82/A[0] CI=intadd_82/CI
Xintadd_82/U4 FA1S $PINS S=intadd_82/SUM[1] CO=intadd_82/n3 A=intadd_82/B[1]
+ B=intadd_82/A[1] CI=intadd_82/n4
Xintadd_82/U3 FA1S $PINS S=intadd_82/SUM[2] CO=intadd_82/n2 A=intadd_82/B[2]
+ B=intadd_82/A[2] CI=intadd_82/n3
Xintadd_82/U2 FA1S $PINS S=intadd_76/A[9] CO=intadd_82/n1 A=intadd_82/B[3]
+ B=intadd_82/A[3] CI=intadd_82/n2
Xintadd_83/U5 FA1S $PINS S=intadd_83/SUM[0] CO=intadd_83/n4 A=intadd_83/B[0]
+ B=intadd_83/A[0] CI=intadd_83/CI
Xintadd_83/U4 FA1S $PINS S=intadd_83/SUM[1] CO=intadd_83/n3 A=intadd_83/B[1]
+ B=intadd_83/A[1] CI=intadd_83/n4
Xintadd_83/U3 FA1S $PINS S=intadd_83/SUM[2] CO=intadd_83/n2 A=intadd_83/B[2]
+ B=intadd_83/A[2] CI=intadd_83/n3
Xintadd_83/U2 FA1S $PINS S=intadd_76/A[8] CO=intadd_83/n1 A=intadd_83/B[3]
+ B=intadd_82/SUM[2] CI=intadd_83/n2
Xintadd_84/U5 FA1S $PINS S=intadd_84/SUM[0] CO=intadd_84/n4 A=intadd_84/B[0]
+ B=intadd_84/A[0] CI=intadd_84/CI
Xintadd_84/U4 FA1S $PINS S=intadd_84/SUM[1] CO=intadd_84/n3 A=intadd_84/B[1]
+ B=intadd_84/A[1] CI=intadd_84/n4
Xintadd_84/U3 FA1S $PINS S=intadd_84/SUM[2] CO=intadd_84/n2 A=intadd_82/SUM[0]
+ B=intadd_84/A[2] CI=intadd_84/n3
Xintadd_84/U2 FA1S $PINS S=intadd_76/A[7] CO=intadd_84/n1 A=intadd_83/SUM[2]
+ B=intadd_82/SUM[1] CI=intadd_84/n2
Xintadd_85/U5 FA1S $PINS S=intadd_85/SUM[0] CO=intadd_85/n4 A=intadd_85/B[0]
+ B=intadd_85/A[0] CI=intadd_85/CI
Xintadd_85/U4 FA1S $PINS S=intadd_85/SUM[1] CO=intadd_85/n3 A=intadd_85/B[1]
+ B=intadd_85/A[1] CI=intadd_85/n4
Xintadd_85/U3 FA1S $PINS S=intadd_85/SUM[2] CO=intadd_85/n2 A=intadd_85/B[2]
+ B=intadd_85/A[2] CI=intadd_85/n3
Xintadd_86/U5 FA1S $PINS S=intadd_86/SUM[0] CO=intadd_86/n4 A=intadd_86/B[0]
+ B=intadd_86/A[0] CI=intadd_86/CI
Xintadd_86/U4 FA1S $PINS S=intadd_86/SUM[1] CO=intadd_86/n3 A=intadd_86/B[1]
+ B=intadd_86/A[1] CI=intadd_86/n4
Xintadd_86/U3 FA1S $PINS S=intadd_86/SUM[2] CO=intadd_86/n2 A=intadd_86/B[2]
+ B=intadd_86/A[2] CI=intadd_86/n3
Xintadd_87/U5 FA1S $PINS S=intadd_87/SUM[0] CO=intadd_87/n4 A=intadd_87/B[0]
+ B=intadd_87/A[0] CI=intadd_87/CI
Xintadd_87/U4 FA1S $PINS S=intadd_87/SUM[1] CO=intadd_87/n3 A=intadd_87/B[1]
+ B=intadd_87/A[1] CI=intadd_87/n4
Xintadd_87/U3 FA1S $PINS S=intadd_87/SUM[2] CO=intadd_87/n2 A=intadd_85/SUM[0]
+ B=intadd_87/A[2] CI=intadd_87/n3
Xintadd_88/U4 FA1S $PINS S=intadd_79/A[2] CO=intadd_88/n3 A=intadd_88/B[0]
+ B=intadd_88/A[0] CI=intadd_88/CI
Xintadd_88/U3 FA1S $PINS S=intadd_79/A[3] CO=intadd_88/n2 A=intadd_88/B[1]
+ B=intadd_88/A[1] CI=intadd_88/n3
Xintadd_88/U2 FA1S $PINS S=intadd_88/SUM[2] CO=intadd_88/n1 A=intadd_88/B[2]
+ B=intadd_88/A[2] CI=intadd_88/n2
Xintadd_89/U4 FA1S $PINS S=intadd_89/SUM[0] CO=intadd_89/n3 A=intadd_89/B[0]
+ B=intadd_89/A[0] CI=intadd_89/CI
Xintadd_89/U3 FA1S $PINS S=intadd_89/SUM[1] CO=intadd_89/n2 A=intadd_80/SUM[0]
+ B=intadd_89/A[1] CI=intadd_89/n3
Xintadd_89/U2 FA1S $PINS S=intadd_89/SUM[2] CO=intadd_89/n1 A=intadd_80/SUM[1]
+ B=intadd_81/SUM[2] CI=intadd_89/n2
Xintadd_90/U4 FA1S $PINS S=intadd_90/SUM[0] CO=intadd_90/n3 A=intadd_90/B[0]
+ B=intadd_90/A[0] CI=intadd_90/CI
Xintadd_90/U3 FA1S $PINS S=intadd_90/SUM[1] CO=intadd_90/n2 A=intadd_90/B[1]
+ B=intadd_81/SUM[0] CI=intadd_90/n3
Xintadd_90/U2 FA1S $PINS S=intadd_90/SUM[2] CO=intadd_90/n1 A=intadd_81/SUM[1]
+ B=intadd_89/SUM[1] CI=intadd_90/n2
Xintadd_91/U4 FA1S $PINS S=intadd_82/B[2] CO=intadd_91/n3 A=intadd_91/B[0]
+ B=intadd_91/A[0] CI=intadd_91/CI
Xintadd_91/U3 FA1S $PINS S=intadd_82/A[3] CO=intadd_91/n2 A=intadd_91/B[1]
+ B=intadd_91/A[1] CI=intadd_91/n3
Xintadd_91/U2 FA1S $PINS S=intadd_76/A[10] CO=intadd_91/n1 A=intadd_91/B[2]
+ B=intadd_91/A[2] CI=intadd_91/n2
Xintadd_92/U4 FA1S $PINS S=intadd_92/SUM[0] CO=intadd_92/n3 A=intadd_92/B[0]
+ B=intadd_92/A[0] CI=intadd_92/CI
Xintadd_92/U3 FA1S $PINS S=intadd_92/SUM[1] CO=intadd_92/n2 A=intadd_83/SUM[0]
+ B=intadd_92/A[1] CI=intadd_92/n3
Xintadd_92/U2 FA1S $PINS S=intadd_76/A[6] CO=intadd_92/n1 A=intadd_84/SUM[2]
+ B=intadd_83/SUM[1] CI=intadd_92/n2
Xintadd_93/U4 FA1S $PINS S=intadd_93/SUM[0] CO=intadd_93/n3 A=intadd_93/B[0]
+ B=intadd_93/A[0] CI=intadd_93/CI
Xintadd_93/U3 FA1S $PINS S=intadd_93/SUM[1] CO=intadd_93/n2 A=intadd_84/SUM[0]
+ B=intadd_93/A[1] CI=intadd_93/n3
Xintadd_93/U2 FA1S $PINS S=intadd_76/A[5] CO=intadd_93/n1 A=intadd_84/SUM[1]
+ B=intadd_92/SUM[1] CI=intadd_93/n2
Xintadd_94/U4 FA1S $PINS S=intadd_85/B[2] CO=intadd_94/n3 A=intadd_94/B[0]
+ B=intadd_94/A[0] CI=intadd_94/CI
Xintadd_94/U3 FA1S $PINS S=intadd_85/A[3] CO=intadd_94/n2 A=intadd_94/B[1]
+ B=intadd_94/A[1] CI=intadd_94/n3
Xintadd_94/U2 FA1S $PINS S=intadd_94/SUM[2] CO=intadd_94/n1 A=intadd_94/B[2]
+ B=intadd_94/A[2] CI=intadd_94/n2
Xintadd_95/U4 FA1S $PINS S=intadd_95/SUM[0] CO=intadd_95/n3 A=intadd_95/B[0]
+ B=intadd_95/A[0] CI=intadd_95/CI
Xintadd_95/U3 FA1S $PINS S=intadd_95/SUM[1] CO=intadd_95/n2 A=intadd_86/SUM[0]
+ B=intadd_95/A[1] CI=intadd_95/n3
Xintadd_96/U4 FA1S $PINS S=intadd_96/SUM[0] CO=intadd_96/n3 A=intadd_96/B[0]
+ B=intadd_96/A[0] CI=intadd_96/CI
Xintadd_74/U4 FA1 $PINS S=N96 CO=intadd_74/n3 A=intadd_74/B[20] B=s1_P3[11]
+ CI=intadd_74/n4
Xintadd_74/U3 FA1 $PINS S=N97 CO=intadd_74/n2 A=intadd_74/B[21] B=s1_P3[12]
+ CI=intadd_74/n3
Xintadd_75/U14 FA1S $PINS S=N37 CO=intadd_75/n13 A=intadd_75/B[0]
+ B=intadd_75/A[0] CI=intadd_75/CI
Xintadd_75/U13 FA1S $PINS S=N38 CO=intadd_75/n12 A=intadd_75/B[1]
+ B=intadd_75/A[1] CI=intadd_75/n13
Xintadd_75/U12 FA1 $PINS S=N39 CO=intadd_75/n11 A=intadd_75/B[2]
+ B=intadd_75/A[2] CI=intadd_75/n12
Xintadd_75/U9 FA1 $PINS S=N42 CO=intadd_75/n8 A=intadd_75/B[5]
+ B=intadd_96/SUM[2] CI=intadd_75/n9
Xintadd_75/U8 FA1 $PINS S=N43 CO=intadd_75/n7 A=intadd_96/n1 B=intadd_95/SUM[2]
+ CI=intadd_75/n8
Xintadd_75/U7 FA1 $PINS S=N44 CO=intadd_75/n6 A=intadd_95/n1 B=intadd_87/SUM[3]
+ CI=intadd_75/n7
Xintadd_75/U6 FA1 $PINS S=N45 CO=intadd_75/n5 A=intadd_87/n1 B=intadd_86/SUM[3]
+ CI=intadd_75/n6
Xintadd_75/U5 FA1 $PINS S=N46 CO=intadd_75/n4 A=intadd_86/n1 B=intadd_85/SUM[3]
+ CI=intadd_75/n5
Xintadd_75/U4 FA1 $PINS S=N47 CO=intadd_75/n3 A=intadd_85/n1 B=intadd_94/SUM[2]
+ CI=intadd_75/n4
Xintadd_75/U3 FA1 $PINS S=N48 CO=intadd_75/n2 A=intadd_75/B[11] B=intadd_94/n1
+ CI=intadd_75/n3
Xintadd_75/U2 FA1 $PINS S=N49 CO=intadd_75/n1 A=intadd_75/B[12]
+ B=intadd_75/A[12] CI=intadd_75/n2
Xintadd_77/U11 FA1 $PINS S=N57 CO=intadd_77/n10 A=intadd_77/B[2]
+ B=intadd_77/A[2] CI=intadd_77/n11
Xintadd_77/U9 FA1 $PINS S=N59 CO=intadd_77/n8 A=intadd_77/B[4] B=intadd_77/A[4]
+ CI=intadd_77/n9
Xintadd_77/U7 FA1 $PINS S=N61 CO=intadd_77/n6 A=intadd_77/B[6] B=intadd_77/A[6]
+ CI=intadd_77/n7
Xintadd_77/U6 FA1 $PINS S=N62 CO=intadd_77/n5 A=intadd_77/B[7] B=intadd_77/A[7]
+ CI=intadd_77/n6
Xintadd_78/U13 FA1S $PINS S=N3 CO=intadd_78/n12 A=intadd_78/B[0]
+ B=intadd_78/A[0] CI=intadd_78/CI
Xintadd_78/U12 FA1 $PINS S=N4 CO=intadd_78/n11 A=intadd_78/B[1]
+ B=intadd_78/A[1] CI=intadd_78/n12
Xintadd_78/U11 FA1 $PINS S=N5 CO=intadd_78/n10 A=intadd_78/B[2]
+ B=intadd_78/A[2] CI=intadd_78/n11
Xintadd_78/U10 FA1 $PINS S=N6 CO=intadd_78/n9 A=intadd_78/B[3] B=intadd_78/A[3]
+ CI=intadd_78/n10
Xintadd_78/U9 FA1 $PINS S=N7 CO=intadd_78/n8 A=intadd_78/B[4] B=intadd_78/A[4]
+ CI=intadd_78/n9
XR_29 QDFFRBN $PINS Q=intadd_74/A[15] D=n499 CK=clk_clone3
+ RB=FE_OFN105_i_reset_n_i
XR_30 QDFFRBN $PINS Q=intadd_74/B[14] D=n498 CK=clk_clone3
+ RB=FE_OFN69_i_reset_n_i
XR_31 QDFFRBN $PINS Q=intadd_74/A[14] D=n497 CK=clk_clone3
+ RB=FE_OFN69_i_reset_n_i
XR_32 QDFFRBN $PINS Q=intadd_74/B[13] D=n496 CK=clk_clone3
+ RB=FE_OFN189_i_reset_n_i
XR_33 QDFFRBN $PINS Q=intadd_74/A[13] D=n495 CK=clk_clone3
+ RB=FE_OFN69_i_reset_n_i
XR_34 QDFFRBN $PINS Q=intadd_74/B[12] D=n494 CK=clk_clone3
+ RB=FE_OFN189_i_reset_n_i
XR_35 QDFFRBN $PINS Q=intadd_74/A[12] D=n493 CK=clk_clone3
+ RB=FE_OFN189_i_reset_n_i
XR_36 QDFFRBN $PINS Q=intadd_74/B[11] D=n492 CK=clk_clone3
+ RB=FE_OFN189_i_reset_n_i
XR_38 QDFFRBN $PINS Q=intadd_74/B[10] D=n490 CK=clk RB=FE_OFN270_i_reset_n_i
XR_39 QDFFRBN $PINS Q=intadd_74/A[10] D=n489 CK=clk RB=FE_OFN270_i_reset_n_i
XR_40 QDFFRBN $PINS Q=intadd_74/B[9] D=n488 CK=clk RB=FE_OFN270_i_reset_n_i
XR_41 QDFFRBN $PINS Q=intadd_74/A[9] D=n487 CK=clk RB=FE_OFN270_i_reset_n_i
XR_42 QDFFRBN $PINS Q=intadd_74/B[8] D=n486 CK=clk RB=FE_OFN270_i_reset_n_i
XR_43 QDFFRBN $PINS Q=intadd_74/A[8] D=n485 CK=clk RB=FE_OFN270_i_reset_n_i
XR_44 QDFFRBN $PINS Q=intadd_74/B[7] D=n484 CK=clk RB=FE_OFN269_i_reset_n_i
XR_45 QDFFRBN $PINS Q=intadd_74/A[7] D=n483 CK=clk RB=FE_OFN269_i_reset_n_i
XR_46 QDFFRBN $PINS Q=intadd_74/B[6] D=n482 CK=clk RB=FE_OFN269_i_reset_n_i
XR_47 QDFFRBN $PINS Q=intadd_74/A[6] D=n481 CK=clk RB=FE_OFN269_i_reset_n_i
XR_48 QDFFRBN $PINS Q=intadd_74/B[5] D=n480 CK=clk RB=FE_OFN266_i_reset_n_i
XR_49 QDFFRBN $PINS Q=intadd_74/A[5] D=n479 CK=clk RB=FE_OFN266_i_reset_n_i
XR_50 QDFFRBN $PINS Q=intadd_74/B[4] D=n478 CK=clk RB=FE_OFN266_i_reset_n_i
XR_51 QDFFRBN $PINS Q=intadd_74/A[4] D=n477 CK=clk RB=FE_OFN260_i_reset_n_i
XR_53 QDFFRBN $PINS Q=intadd_74/A[3] D=n475 CK=clk RB=FE_OFN260_i_reset_n_i
XR_54 QDFFRBN $PINS Q=intadd_74/B[2] D=n474 CK=clk RB=FE_OFN260_i_reset_n_i
XR_55 QDFFRBN $PINS Q=intadd_74/n23 D=n473 CK=clk RB=FE_OFN260_i_reset_n_i
XR_56 QDFFRBN $PINS Q=N76 D=n472 CK=clk_clone2 RB=FE_OFN86_i_reset_n_i
Xintadd_75/U11 FA1 $PINS S=N40 CO=intadd_75/n10 A=intadd_75/B[3]
+ B=intadd_75/A[3] CI=intadd_75/n11
Xintadd_86/U2 FA1S $PINS S=intadd_86/SUM[3] CO=intadd_86/n1 A=intadd_86/B[3]
+ B=intadd_85/SUM[2] CI=intadd_86/n2
Xintadd_85/U2 FA1S $PINS S=intadd_85/SUM[3] CO=intadd_85/n1 A=intadd_85/B[3]
+ B=intadd_85/A[3] CI=intadd_85/n2
Xintadd_96/U2 FA1S $PINS S=intadd_96/SUM[2] CO=intadd_96/n1 A=intadd_87/SUM[1]
+ B=intadd_95/SUM[1] CI=intadd_96/n2
Xintadd_95/U2 FA1S $PINS S=intadd_95/SUM[2] CO=intadd_95/n1 A=intadd_87/SUM[2]
+ B=intadd_86/SUM[1] CI=intadd_95/n2
Xintadd_87/U2 FA1S $PINS S=intadd_87/SUM[3] CO=intadd_87/n1 A=intadd_86/SUM[2]
+ B=intadd_85/SUM[1] CI=intadd_87/n2
Xintadd_74/U6 FA1 $PINS S=N94 CO=intadd_74/n5 A=intadd_74/B[18] B=s1_P3[9]
+ CI=intadd_74/n6
Xintadd_74/U8 FA1 $PINS S=N92 CO=intadd_74/n7 A=intadd_74/B[16]
+ B=intadd_74/A[16] CI=intadd_74/n8
Xintadd_74/U11 FA1 $PINS S=N89 CO=intadd_74/n10 A=intadd_74/B[13]
+ B=intadd_74/A[13] CI=intadd_74/n11
Xintadd_74/U12 FA1 $PINS S=N88 CO=intadd_74/n11 A=intadd_74/B[12]
+ B=intadd_74/A[12] CI=intadd_74/n12
Xintadd_74/U13 FA1 $PINS S=N87 CO=intadd_74/n12 A=intadd_74/B[11]
+ B=intadd_74/A[11] CI=intadd_74/n13
Xintadd_74/U14 FA1 $PINS S=N86 CO=intadd_74/n13 A=intadd_74/B[10]
+ B=intadd_74/A[10] CI=intadd_74/n14
Xintadd_74/U15 FA1 $PINS S=N85 CO=intadd_74/n14 A=intadd_74/B[9]
+ B=intadd_74/A[9] CI=intadd_74/n15
Xintadd_74/U16 FA1 $PINS S=N84 CO=intadd_74/n15 A=intadd_74/B[8]
+ B=intadd_74/A[8] CI=intadd_74/n16
Xintadd_74/U17 FA1 $PINS S=N83 CO=intadd_74/n16 A=intadd_74/B[7]
+ B=intadd_74/A[7] CI=intadd_74/n17
Xintadd_74/U18 FA1 $PINS S=N82 CO=intadd_74/n17 A=intadd_74/B[6]
+ B=intadd_74/A[6] CI=intadd_74/n18
Xintadd_74/U19 FA1 $PINS S=N81 CO=intadd_74/n18 A=intadd_74/B[5]
+ B=intadd_74/A[5] CI=intadd_74/n19
Xintadd_74/U20 FA1S $PINS S=N80 CO=intadd_74/n19 A=intadd_74/B[4]
+ B=intadd_74/A[4] CI=intadd_74/n20
Xintadd_74/U21 FA1S $PINS S=N79 CO=intadd_74/n20 A=intadd_74/B[3]
+ B=intadd_74/A[3] CI=intadd_74/n21
Xintadd_74/U22 FA1S $PINS S=N78 CO=intadd_74/n21 A=intadd_74/B[2]
+ B=intadd_74/A[2] CI=intadd_74/n22
Xintadd_78/U2 FA1 $PINS S=N14 CO=intadd_78/n1 A=intadd_88/n1 B=intadd_78/A[11]
+ CI=intadd_78/n2
Xintadd_78/U3 FA1 $PINS S=N13 CO=intadd_78/n2 A=intadd_79/n1 B=intadd_88/SUM[2]
+ CI=intadd_78/n3
Xintadd_78/U4 FA1 $PINS S=N12 CO=intadd_78/n3 A=intadd_80/n1 B=intadd_79/SUM[3]
+ CI=intadd_78/n4
Xintadd_78/U5 FA1 $PINS S=N11 CO=intadd_78/n4 A=intadd_81/n1 B=intadd_80/SUM[3]
+ CI=intadd_78/n5
Xintadd_78/U7 FA1 $PINS S=N9 CO=intadd_78/n6 A=intadd_90/n1 B=intadd_89/SUM[2]
+ CI=intadd_78/n7
Xintadd_78/U6 FA1 $PINS S=N10 CO=intadd_78/n5 A=intadd_89/n1 B=intadd_81/SUM[3]
+ CI=intadd_78/n6
Xintadd_78/U8 FA1 $PINS S=N8 CO=intadd_78/n7 A=intadd_78/B[5]
+ B=intadd_90/SUM[2] CI=intadd_78/n8
Xintadd_74/U5 FA1 $PINS S=N95 CO=intadd_74/n4 A=intadd_74/B[19] B=s1_P3[10]
+ CI=intadd_74/n5
Xintadd_74/U2 FA1 $PINS S=N98 CO=intadd_74/n1 A=s1_P3[13] B=intadd_74/A[22]
+ CI=intadd_74/n2
Xintadd_77/U5 FA1 $PINS S=N63 CO=intadd_77/n4 A=intadd_77/B[8] B=intadd_77/A[8]
+ CI=intadd_77/n5
Xintadd_74/U7 FA1 $PINS S=N93 CO=intadd_74/n6 A=intadd_74/B[17]
+ B=intadd_74/A[17] CI=intadd_74/n7
Xintadd_77/U13 FA1 $PINS S=N55 CO=intadd_77/n12 A=intadd_77/B[0]
+ B=intadd_77/A[0] CI=intadd_77/CI
Xintadd_96/U3 FA1S $PINS S=intadd_96/SUM[1] CO=intadd_96/n2 A=intadd_87/SUM[0]
+ B=intadd_96/A[1] CI=intadd_96/n3
Xintadd_77/U12 FA1 $PINS S=N56 CO=intadd_77/n11 A=intadd_77/B[1]
+ B=intadd_77/A[1] CI=intadd_77/n12
Xintadd_77/U10 FA1 $PINS S=N58 CO=intadd_77/n9 A=intadd_77/B[3]
+ B=intadd_77/A[3] CI=intadd_77/n10
Xintadd_75/U10 FA1 $PINS S=N41 CO=intadd_75/n9 A=intadd_75/B[4]
+ B=intadd_75/A[4] CI=intadd_75/n10
Xintadd_77/U8 FA1 $PINS S=N60 CO=intadd_77/n7 A=intadd_77/B[5] B=intadd_77/A[5]
+ CI=intadd_77/n8
XU3 FA1S $PINS S=N65 CO=intadd_77/n2 A=intadd_77/B[10] B=intadd_77/A[10]
+ CI=intadd_77/n3
XU4 FA1S $PINS S=N64 CO=intadd_77/n3 A=intadd_77/B[9] B=intadd_77/A[9]
+ CI=intadd_77/n4
XU24 MOAI1S $PINS O=n60 A1=n215 A2=n59 B1=n215 B2=n59
XU29 MOAI1S $PINS O=n423 A1=n411 A2=n410 B1=n411 B2=n410
XU30 ND2S $PINS O=n95 I1=FE_OFN1111_IxIy_shift_8 I2=FE_OFN863_IxIt_shift_1
XU31 ND2S $PINS O=n142 I1=FE_OFN863_IxIt_shift_1 I2=A[4]
XU33 ND3 $PINS O=n213 I1=FE_OFN1111_IxIy_shift_8 I2=FE_OFN1599_n1437 I3=n69
XU34 ND2S $PINS O=n113 I1=n1437 I2=A[6]
XU35 ND2S $PINS O=n99 I1=A[14] I2=FE_OFN1599_n1437
XU36 ND2S $PINS O=n68 I1=FE_OFN1111_IxIy_shift_8 I2=FE_OFN1599_n1437
XU38 ND2S $PINS O=n152 I1=FE_OFN867_IxIt_shift_0 I2=A[4]
XU39 ND2S $PINS O=n212 I1=FE_OFN1222_n2891 I2=FE_OFN864_IxIt_shift_1
XU41 MOAI1 $PINS O=FE_PHN3216_N99 A1=intadd_74/A[22] A2=n74 B1=intadd_74/A[22]
+ B2=n74
XU42 ND2S $PINS O=n370 I1=n379 I2=n378
XU43 ND2S $PINS O=n406 I1=n411 I2=n410
XU44 MOAI1S $PINS O=n354 A1=n341 A2=n328 B1=n438 B2=n320
XU47 ND2S $PINS O=n398 I1=FE_OFN4302_n I2=n452
XU48 ND3 $PINS O=n161 I1=FE_OFN1344_IxIy_shift_3 I2=FE_OFN870_IxIt_shift_0
+ I3=n154
XU49 ND2S $PINS O=n64 I1=FE_OFN1710_IxIt_shift_13
+ I2=FE_OFN885_FE_DBTN118_IxIy_shift_0
XU50 NR2 $PINS O=n136 I1=n111 I2=n110
XU52 ND2S $PINS O=n444 I1=FE_OFN4302_n I2=n425
XU53 ND2S $PINS O=n441 I1=FE_OFN4225_FE_OFN1218_n2891 I2=FE_OFN1761_n341
XU54 ND2S $PINS O=n291 I1=FE_OFN1710_IxIt_shift_13 I2=FE_OFN1122_IxIy_shift_7
XU55 ND2S $PINS O=n141 I1=FE_OFN867_IxIt_shift_0 I2=A[5]
XU56 ND2S $PINS O=intadd_75/A[12] I1=FE_OFN1740_IxIt_shift_15
+ I2=FE_OFN1122_IxIy_shift_7
XU57 ND2S $PINS O=n297 I1=FE_OFN985_IxIt_shift_14 I2=FE_OFN1122_IxIy_shift_7
XU58 ND2S $PINS O=n96 I1=FE_DBTN151_n3310 I2=FE_OFN867_IxIt_shift_0
XU59 ND3 $PINS O=n221 I1=FE_OFN1453_FE_DBTN124_IxIy_shift_10
+ I2=FE_OFN864_IxIt_shift_1 I3=n216
XU60 ND3 $PINS O=n465 I1=n83 I2=FE_OFN1161_FE_DBTN151_n3310
+ I3=FE_OFN1462_FE_DBTN110_IxIt_shift_8
XU61 ND2S $PINS O=n197 I1=FE_OFN1098_IxIy_shift_13 I2=FE_OFN869_IxIt_shift_0
XU62 ND2S $PINS O=n61 I1=FE_OFN1672_n1658 I2=FE_OFN1000_n143
XU63 ND2S $PINS O=n89 I1=FE_OFN4301_n I2=FE_OFN1000_n143
XU64 ND2S $PINS O=n110 I1=A[7] I2=FE_OFN867_IxIt_shift_0
XU65 ND2S $PINS O=n455 I1=A[7] I2=FE_OFN1499_FE_DBTN28_IxIt_shift_7
XU66 ND2S $PINS O=n63 I1=FE_OFN1358_IxIt_shift_10 I2=FE_OFN4267_FE_OFN1000_n143
XU67 ND2S $PINS O=n274 I1=FE_OFN1730_IxIt_shift_11 I2=FE_OFN1000_n143
XU68 ND2S $PINS O=n107 I1=A[6] I2=FE_OFN867_IxIt_shift_0
XU69 ND2S $PINS O=n194 I1=FE_OFN4259_FE_OFN1611_IxIy_shift_12
+ I2=FE_OFN1370_IxIt_shift_3
XU70 ND2S $PINS O=n190 I1=FE_OFN4259_FE_OFN1611_IxIy_shift_12 I2=B[4]
XU71 ND2S $PINS O=n174 I1=FE_OFN4259_FE_OFN1611_IxIy_shift_12 I2=B[5]
XU73 ND2S $PINS O=n98 I1=FE_OFN1098_IxIy_shift_13 I2=FE_OFN864_IxIt_shift_1
XU74 ND2S $PINS O=n97 I1=A[14] I2=FE_OFN869_IxIt_shift_0
XU75 ND2S $PINS O=n229 I1=FE_OFN1166_FE_DBTN127_IxIy_shift_13
+ I2=FE_OFN1499_FE_DBTN28_IxIt_shift_7
XU76 ND2S $PINS O=n112 I1=FE_OFN136_IxIt_shift_1 I2=A[7]
XU77 ND2S $PINS O=n94 I1=FE_OFN1672_n1658 I2=FE_OFN1122_IxIy_shift_7
XU78 ND2S $PINS O=n106 I1=FE_OFN855_IxIy_shift_0 I2=FE_OFN1599_n1437
XU79 ND2S $PINS O=n73 I1=FE_OFN1344_IxIy_shift_3 I2=FE_OFN870_IxIt_shift_0
XU80 ND2S $PINS O=n153 I1=FE_OFN863_IxIt_shift_1 I2=FE_OFN1344_IxIy_shift_3
XU82 ND2S $PINS O=n83 I1=FE_OFN1670_n1658 I2=FE_OFN1392_n187
XU83 ND2S $PINS O=n59 I1=FE_OFN1111_IxIy_shift_8 I2=FE_OFN1370_IxIt_shift_3
XU84 ND2S $PINS O=n245 I1=FE_OFN1350_IxIt_shift_12 I2=A[5]
XU85 ND2S $PINS O=n70 I1=FE_OFN1453_FE_DBTN124_IxIy_shift_10
+ I2=FE_OFN864_IxIt_shift_1
XU86 ND2S $PINS O=n103 I1=FE_OFN855_IxIy_shift_0 I2=B[1]
XU88 ND2S $PINS O=n108 I1=FE_OFN863_IxIt_shift_1 I2=A[5]
XU89 ND2S $PINS O=n57 I1=FE_OFN4301_n I2=FE_OFN1342_IxIy_shift_3
XU90 ND2S $PINS O=n100 I1=FE_DBTN151_n3310 I2=FE_OFN1499_FE_DBTN28_IxIt_shift_7
XU91 ND2S $PINS O=n234 I1=n348 I2=FE_OFN1499_FE_DBTN28_IxIt_shift_7
XU92 ND2S $PINS O=intadd_76/A[12] I1=FE_OFN4179_FE_OFN1570_n2620
+ I2=FE_OFN1499_FE_DBTN28_IxIt_shift_7
XU93 ND2S $PINS O=n184 I1=FE_OFN4179_FE_OFN1570_n2620
+ I2=FE_OFN1370_IxIt_shift_3
XU100 ND2S $PINS O=n90 I1=FE_OFN1672_n1658 I2=FE_OFN885_FE_DBTN118_IxIy_shift_0
XU101 ND2S $PINS O=n228 I1=A[14] I2=B[6]
XU103 ND2S $PINS O=n172 I1=FE_OFN1222_n2891 I2=B[6]
XU105 ND2S $PINS O=n192 I1=FE_OFN1222_n2891 I2=B[4]
XU109 ND2S $PINS O=n261 I1=FE_OFN1350_IxIt_shift_12 I2=A[4]
XU110 ND2S $PINS O=n93 I1=FE_OFN985_IxIt_shift_14
+ I2=FE_OFN282_FE_DBTN119_IxIy_shift_2
XU113 ND2S $PINS O=n266 I1=FE_OFN1350_IxIt_shift_12 I2=FE_OFN1342_IxIy_shift_3
XU114 MOAI1S $PINS O=n327 A1=FE_OFN1453_FE_DBTN124_IxIy_shift_10
+ A2=FE_OFN1218_n2891 B1=FE_OFN1453_FE_DBTN124_IxIy_shift_10 B2=FE_OFN1218_n2891
XU115 ND2S $PINS O=n290 I1=FE_OFN985_IxIt_shift_14 I2=A[6]
XU116 ND2S $PINS O=intadd_94/A[1] I1=FE_OFN1742_IxIt_shift_15 I2=A[4]
XU117 ND2S $PINS O=n257 I1=FE_OFN1740_IxIt_shift_15 I2=FE_OFN1342_IxIy_shift_3
XU118 ND2S $PINS O=n273 I1=FE_OFN1350_IxIt_shift_12
+ I2=FE_OFN885_FE_DBTN118_IxIy_shift_0
XU119 ND2S $PINS O=n91 I1=FE_OFN985_IxIt_shift_14
+ I2=FE_OFN885_FE_DBTN118_IxIy_shift_0
XU122 ND2S $PINS O=n264 I1=FE_OFN1730_IxIt_shift_11 I2=A[4]
XU124 INV1S $PINS O=n71 I=FE_OFN864_IxIt_shift_1
XU125 ND2S $PINS O=n243 I1=FE_OFN1730_IxIt_shift_11 I2=A[6]
XU133 ND2S $PINS O=intadd_91/A[1] I1=FE_OFN4179_FE_OFN1570_n2620 I2=B[4]
XU136 ND2S $PINS O=n111 I1=FE_OFN136_IxIt_shift_1 I2=A[6]
XU143 ND2S $PINS O=intadd_74/B[17] I1=n81 I2=n80
XU144 ND2S $PINS O=intadd_74/A[16] I1=n78 I2=n79
XU145 ND2S $PINS O=n75 I1=n80 I2=n79
XU146 ND2S $PINS O=n78 I1=s1_P3[7] I2=n80
XU147 ND2S $PINS O=n81 I1=s1_P3[8] I2=n79
XU148 ND2S $PINS O=n79 I1=s1_P1[15] I2=s1_P2[15]
XU173 NR2 $PINS O=n438 I1=FE_OFN1485_FE_DBTN86_n341 I2=n327
XU174 MOAI1S $PINS O=n452 A1=n348 A2=FE_OFN1164_FE_DBTN127_IxIy_shift_13
+ B1=n348 B2=FE_OFN1164_FE_DBTN127_IxIy_shift_13
XU175 MOAI1 $PINS O=n425 A1=FE_OFN4259_FE_OFN1611_IxIy_shift_12
+ A2=FE_DBTN156_n2891 B1=FE_OFN4259_FE_OFN1611_IxIy_shift_12 B2=FE_DBTN156_n2891
XU182 NR2 $PINS O=intadd_86/A[0] I1=FE_OFN1674_n1658
+ I2=FE_OFN281_FE_DBTN122_IxIy_shift_6
XU184 NR2 $PINS O=n130 I1=FE_OFN1468_FE_DBTN104_IxIt_shift_3
+ I2=FE_OFN1647_IxIy_shift_6
XU187 INV1S $PINS O=n177 I=FE_OFN870_IxIt_shift_0
XU188 MOAI1 $PINS O=n77 A1=n455 A2=n76 B1=n455 B2=n76
XU189 MOAI1 $PINS O=n74 A1=s1_P3[15] A2=intadd_74/n1 B1=s1_P3[15]
+ B2=intadd_74/n1
XU195 NR2 $PINS O=n56 I1=FE_OFN1711_IxIt_shift_13 I2=FE_OFN1638_IxIy_shift_2
XU198 AOI22S $PINS O=n259 A1=FE_OFN4301_n A2=FE_OFN1122_IxIy_shift_7
+ B1=FE_OFN1710_IxIt_shift_13 B2=FE_OFN282_FE_DBTN119_IxIy_shift_2
XU199 AO13S $PINS O=intadd_87/B[1] A1=n259 B1=FE_OFN1122_IxIy_shift_7
+ B2=FE_OFN4301_n B3=n56
XU200 NR2 $PINS O=n278 I1=FE_OFN1674_n1658 I2=FE_OFN283_FE_DBTN119_IxIy_shift_2
XU201 MOAI1S $PINS O=n58 A1=n278 A2=n57 B1=n278 B2=n57
XU204 NR2 $PINS O=n62 I1=FE_OFN4304_n I2=FE_OFN283_FE_DBTN119_IxIy_shift_2
XU205 ND3 $PINS O=n275 I1=FE_OFN1672_n1658 I2=FE_OFN4267_FE_OFN1000_n143 I3=n62
XU206 MOAI1S $PINS O=intadd_75/B[1] A1=n58 A2=n275 B1=n58 B2=n275
XU207 NR2 $PINS O=n215 I1=FE_OFN4192_FE_OFN1067_n3310 I2=FE_OFN1200_n1437
XU210 NR2 $PINS O=n69 I1=FE_OFN4192_FE_OFN1067_n3310 I2=n71
XU211 MOAI1S $PINS O=intadd_76/B[1] A1=n60 A2=n213 B1=n60 B2=n213
XU213 ND2 $PINS O=n92 I1=FE_OFN1710_IxIt_shift_13 I2=FE_OFN1000_n143
XU214 NR2 $PINS O=intadd_87/A[1] I1=n92 I2=n91
XU215 OR2 $PINS O=n80 I1=s1_P1[15] I2=s1_P2[15]
XU216 MOAI1S $PINS O=intadd_74/B[15] A1=s1_P3[7] A2=n75 B1=s1_P3[7] B2=n75
XU217 MOAI1S $PINS O=intadd_75/A[0] A1=n62 A2=n61 B1=n62 B2=n61
XU220 NR2 $PINS O=n279 I1=FE_OFN1731_IxIt_shift_11 I2=FE_DBTN118_IxIy_shift_0
XU221 MOAI1S $PINS O=intadd_75/A[1] A1=n279 A2=n63 B1=n279 B2=n63
XU223 NR2 $PINS O=intadd_95/B[0] I1=n65 I2=n64
XU224 NR2 $PINS O=n289 I1=FE_OFN4304_n I2=FE_OFN1340_IxIy_shift_4
XU226 NR2 $PINS O=n288 I1=FE_OFN1674_n1658 I2=FE_DBTN121_IxIy_shift_3
XU227 NR2 $PINS O=n287 I1=FE_OFN1459_FE_DBTN113_IxIt_shift_10
+ I2=FE_OFN1638_IxIy_shift_2
XU228 OAI22S $PINS O=n271 A1=n65 A2=intadd_95/B[0] B1=n64 B2=intadd_95/B[0]
XU229 NR2 $PINS O=n270 I1=n274 I2=n273
XU230 NR2 $PINS O=n269 I1=FE_OFN1674_n1658 I2=FE_OFN1340_IxIy_shift_4
XU231 FA1S $PINS S=intadd_75/A[3] CO=intadd_75/B[4] A=n67 B=n66
+ CI=intadd_96/SUM[0]
XU232 MOAI1S $PINS O=intadd_76/A[0] A1=n69 A2=n68 B1=n69 B2=n68
XU234 NR2 $PINS O=n216 I1=FE_OFN4272_FE_OFN1224_n2891 I2=n177
XU236 MOAI1S $PINS O=intadd_76/A[1] A1=n216 A2=n70 B1=n216 B2=n70
XU249 NR2 $PINS O=intadd_85/A[1] I1=n94 I2=n93
XU250 ND2 $PINS O=n105 I1=FE_OFN845_IxIy_shift_1 I2=B[1]
XU251 NR2 $PINS O=n158 I1=n106 I2=n105
XU252 ND2 $PINS O=n156 I1=FE_OFN1599_n1437 I2=FE_OFN845_IxIy_shift_1
XU254 MOAI1S $PINS O=n72 A1=n156 A2=n155 B1=n156 B2=n155
XU255 MOAI1S $PINS O=intadd_78/A[1] A1=n158 A2=n72 B1=n158 B2=n72
XU256 NR2 $PINS O=n154 I1=n71 I2=FE_DBTN119_IxIy_shift_2
XU257 MOAI1S $PINS O=intadd_78/B[1] A1=n154 A2=n73 B1=n154 B2=n73
XU258 INV1S $PINS O=intadd_74/A[22] I=s1_P3[14]
XU259 MOAI1S $PINS O=intadd_74/B[16] A1=s1_P3[8] A2=n75 B1=s1_P3[8] B2=n75
XU260 NR2 $PINS O=intadd_75/B[0] I1=n90 I2=n89
XU263 NR2 $PINS O=intadd_76/B[0] I1=n96 I2=n95
XU264 NR2 $PINS O=n120 I1=FE_OFN1647_IxIy_shift_6
+ I2=FE_OFN284_FE_DBTN108_IxIt_shift_6
XU265 NR2 $PINS O=n119 I1=FE_OFN1368_IxIt_shift_7 I2=FE_OFN1329_IxIy_shift_5
XU266 NR2 $PINS O=n118 I1=FE_OFN1120_IxIy_shift_7
+ I2=FE_OFN288_FE_DBTN106_IxIt_shift_5
XU267 NR2 $PINS O=n116 I1=FE_OFN1368_IxIt_shift_7 I2=FE_OFN1647_IxIy_shift_6
XU268 NR2 $PINS O=n115 I1=FE_OFN1120_IxIy_shift_7
+ I2=FE_OFN284_FE_DBTN108_IxIt_shift_6
XU269 MAOI1 $PINS O=n76 A1=n454 A2=intadd_78/n1 B1=n454 B2=intadd_78/n1
XU270 FA1 $PINS S=n482 CO=n483 A=N41 B=N24 CI=n77
XU271 AN2 $PINS O=intadd_74/A[2] I1=s1_P0[9] I2=s1_P2[1]
XU274 MOAI1S $PINS O=n82 A1=FE_OFN1358_IxIt_shift_10
+ A2=FE_OFN4193_FE_OFN1067_n3310 B1=FE_OFN1358_IxIt_shift_10
+ B2=FE_OFN4193_FE_OFN1067_n3310
XU275 NR2 $PINS O=n430 I1=FE_OFN4260_FE_OFN1392_n187
+ I2=FE_OFN4193_FE_OFN1067_n3310
XU276 AOI22S $PINS O=n469 A1=FE_OFN1392_n187 A2=n82 B1=n430 B2=FE_OFN1673_n1658
XU279 MOAI1 $PINS O=n341 A1=FE_DBTN151_n3310
+ A2=FE_OFN1453_FE_DBTN124_IxIy_shift_10 B1=FE_DBTN151_n3310
+ B2=FE_OFN1453_FE_DBTN124_IxIy_shift_10
XU280 OA12 $PINS O=n470 A1=n465 B1=FE_OFN1462_FE_DBTN110_IxIt_shift_8 B2=n341
XU281 NR2 $PINS O=intadd_77/B[0] I1=n469 I2=n470
XU284 MOAI1S $PINS O=n84 A1=FE_OFN1730_IxIt_shift_11
+ A2=FE_OFN4193_FE_OFN1067_n3310 B1=FE_OFN1730_IxIt_shift_11
+ B2=FE_OFN4193_FE_OFN1067_n3310
XU285 AOI22S $PINS O=n87 A1=FE_OFN1392_n187 A2=n84 B1=n430
+ B2=FE_DBTN113_IxIt_shift_10
XU287 MOAI1S $PINS O=n433 A1=FE_OFN4225_FE_OFN1218_n2891 A2=FE_OFN1673_n1658
+ B1=FE_OFN4225_FE_OFN1218_n2891 B2=FE_OFN1673_n1658
XU288 MOAI1S $PINS O=n86 A1=FE_OFN4225_FE_OFN1218_n2891
+ A2=FE_OFN1462_FE_DBTN110_IxIt_shift_8 B1=FE_OFN4225_FE_OFN1218_n2891
+ B2=FE_OFN1462_FE_DBTN110_IxIt_shift_8
XU289 AOI22S $PINS O=n88 A1=FE_OFN1761_n341 A2=n433 B1=FE_OFN1548_n438 B2=n86
XU290 NR2P $PINS O=intadd_77/A[1] I1=n87 I2=n88
XU291 OAI22S $PINS O=intadd_77/A[0] A1=n88 A2=intadd_77/A[1] B1=n87
+ B2=intadd_77/A[1]
XU292 OAI22S $PINS O=N36 A1=n90 A2=intadd_75/B[0] B1=n89 B2=intadd_75/B[0]
XU293 OAI22S $PINS O=intadd_96/A[1] A1=n92 A2=intadd_87/A[1] B1=n91
+ B2=intadd_87/A[1]
XU294 OAI22S $PINS O=intadd_86/A[1] A1=n94 A2=intadd_85/A[1] B1=n93
+ B2=intadd_85/A[1]
XU295 OAI22S $PINS O=N19 A1=n96 A2=intadd_76/B[0] B1=n95 B2=intadd_76/B[0]
XU298 ND2 $PINS O=n198 I1=FE_OFN1611_IxIy_shift_12 I2=FE_OFN864_IxIt_shift_1
XU299 NR2 $PINS O=intadd_92/B[0] I1=n198 I2=n197
XU300 NR2 $PINS O=intadd_84/A[1] I1=n98 I2=n97
XU301 OAI22S $PINS O=intadd_93/A[1] A1=n98 A2=intadd_84/A[1] B1=n97
+ B2=intadd_84/A[1]
XU302 NR2 $PINS O=intadd_82/A[1] I1=n100 I2=n99
XU303 OAI22S $PINS O=intadd_83/A[1] A1=n100 A2=intadd_82/A[1] B1=n99
+ B2=intadd_82/A[1]
XU304 ND2 $PINS O=n104 I1=FE_OFN845_IxIy_shift_1 I2=FE_OFN870_IxIt_shift_0
XU305 NR2 $PINS O=intadd_78/CI I1=n104 I2=n103
XU306 OAI22S $PINS O=N2 A1=n104 A2=intadd_78/CI B1=n103 B2=intadd_78/CI
XU307 OAI22S $PINS O=intadd_78/A[0] A1=n106 A2=n158 B1=n105 B2=n158
XU308 NR2 $PINS O=intadd_89/A[0] I1=n142 I2=n141
XU309 NR2 $PINS O=intadd_81/B[1] I1=n108 I2=n107
XU310 OAI22S $PINS O=intadd_90/B[1] A1=n108 A2=intadd_81/B[1] B1=n107
+ B2=intadd_81/B[1]
XU311 OAI22S $PINS O=intadd_81/A[1] A1=n111 A2=n136 B1=n110 B2=n136
XU312 NR2 $PINS O=intadd_79/B[1] I1=n113 I2=n112
XU313 OAI22S $PINS O=intadd_80/A[1] A1=n113 A2=intadd_79/B[1] B1=n112
+ B2=intadd_79/B[1]
XU314 NR2 $PINS O=N1 I1=n177 I2=FE_OFN853_IxIy_shift_0
XU315 FA1S $PINS S=intadd_78/A[11] CO=n454 A=n117 B=n116 CI=n115
XU316 FA1S $PINS S=intadd_88/A[2] CO=n117 A=n120 B=n119 CI=n118
XU317 NR2 $PINS O=n123 I1=FE_OFN1647_IxIy_shift_6
+ I2=FE_OFN288_FE_DBTN106_IxIt_shift_5
XU318 NR2 $PINS O=n122 I1=FE_OFN1368_IxIt_shift_7 I2=FE_OFN1340_IxIy_shift_4
XU319 NR2 $PINS O=n121 I1=FE_OFN1120_IxIy_shift_7 I2=FE_OFN1252_n4487
XU320 FA1S $PINS S=intadd_88/A[1] CO=intadd_88/B[2] A=n123 B=n122 CI=n121
XU321 NR2 $PINS O=intadd_88/B[1] I1=FE_OFN1329_IxIy_shift_5
+ I2=FE_OFN284_FE_DBTN108_IxIt_shift_6
XU322 NR2 $PINS O=intadd_88/A[0] I1=FE_OFN1647_IxIy_shift_6 I2=FE_OFN1252_n4487
XU323 NR2 $PINS O=intadd_88/B[0] I1=FE_DBTN121_IxIy_shift_3
+ I2=FE_OFN1368_IxIt_shift_7
XU324 NR2 $PINS O=intadd_88/CI I1=FE_OFN1468_FE_DBTN104_IxIt_shift_3
+ I2=FE_OFN1120_IxIy_shift_7
XU325 NR2 $PINS O=intadd_79/A[0] I1=FE_OFN1576_IxIy_shift_1
+ I2=FE_OFN233_IxIt_shift_7
XU326 NR2 $PINS O=intadd_79/B[0] I1=FE_OFN1338_IxIy_shift_4 I2=FE_OFN1252_n4487
XU327 NR2 $PINS O=intadd_79/CI I1=FE_OFN1468_FE_DBTN104_IxIt_shift_3
+ I2=IxIy_shift_5
XU328 NR2 $PINS O=n127 I1=FE_OFN1338_IxIy_shift_4
+ I2=FE_OFN288_FE_DBTN106_IxIt_shift_5
XU329 NR2 $PINS O=n126 I1=FE_OFN1455_FE_DBTN121_IxIy_shift_3
+ I2=FE_DBTN108_IxIt_shift_6
XU330 NR2 $PINS O=n125 I1=FE_OFN1329_IxIy_shift_5 I2=FE_OFN1252_n4487
XU331 FA1S $PINS S=intadd_80/A[2] CO=intadd_79/B[2] A=n127 B=n126 CI=n125
XU332 NR2 $PINS O=intadd_80/A[0] I1=FE_OFN1576_IxIy_shift_1
+ I2=FE_DBTN108_IxIt_shift_6
XU333 NR2 $PINS O=intadd_80/B[0] I1=FE_OFN853_IxIy_shift_0
+ I2=FE_OFN1368_IxIt_shift_7
XU334 NR2 $PINS O=intadd_80/CI I1=FE_RN_1 I2=IxIy_shift_5
XU335 NR2 $PINS O=n129 I1=FE_OFN1637_IxIy_shift_2 I2=FE_OFN1368_IxIt_shift_7
XU336 NR2 $PINS O=n128 I1=FE_RN_1 I2=FE_OFN1120_IxIy_shift_7
XU337 FA1S $PINS S=intadd_80/B[2] CO=n133 A=n130 B=n129 CI=n128
XU338 NR2 $PINS O=n132 I1=FE_OFN1338_IxIy_shift_4
+ I2=FE_OFN284_FE_DBTN108_IxIt_shift_6
XU339 NR2 $PINS O=n131 I1=FE_OFN1329_IxIy_shift_5
+ I2=FE_OFN288_FE_DBTN106_IxIt_shift_5
XU340 FA1S $PINS S=intadd_80/B[3] CO=intadd_79/B[3] A=n133 B=n132 CI=n131
XU341 NR2 $PINS O=n135 I1=FE_OFN1637_IxIy_shift_2 I2=FE_DBTN108_IxIt_shift_6
XU342 NR2 $PINS O=n134 I1=FE_OFN1455_FE_DBTN121_IxIy_shift_3
+ I2=FE_OFN288_FE_DBTN106_IxIt_shift_5
XU343 FA1S $PINS S=intadd_81/A[2] CO=intadd_79/A[1] A=n136 B=n135 CI=n134
XU344 NR2 $PINS O=intadd_81/A[0] I1=n143 I2=FE_OFN289_FE_DBTN106_IxIt_shift_5
XU345 NR2 $PINS O=intadd_81/B[0] I1=FE_OFN853_IxIy_shift_0
+ I2=FE_DBTN108_IxIt_shift_6
XU346 NR2 $PINS O=intadd_81/CI I1=FE_RN_1 I2=FE_OFN1338_IxIy_shift_4
XU347 NR2 $PINS O=n139 I1=FE_OFN1637_IxIy_shift_2
+ I2=FE_OFN288_FE_DBTN106_IxIt_shift_5
XU348 NR2 $PINS O=n138 I1=FE_OFN1468_FE_DBTN104_IxIt_shift_3
+ I2=FE_OFN1338_IxIy_shift_4
XU349 NR2 $PINS O=n137 I1=FE_OFN1455_FE_DBTN121_IxIy_shift_3
+ I2=FE_OFN1252_n4487
XU350 FA1S $PINS S=intadd_89/A[1] CO=intadd_80/B[1] A=n139 B=n138 CI=n137
XU351 NR2 $PINS O=intadd_89/B[0] I1=FE_OFN283_FE_DBTN119_IxIy_shift_2
+ I2=FE_OFN1252_n4487
XU352 NR2 $PINS O=intadd_89/CI I1=FE_OFN1468_FE_DBTN104_IxIt_shift_3
+ I2=FE_OFN1455_FE_DBTN121_IxIy_shift_3
XU353 NR2 $PINS O=intadd_90/A[0] I1=FE_OFN1468_FE_DBTN104_IxIt_shift_3
+ I2=FE_OFN283_FE_DBTN119_IxIy_shift_2
XU354 NR2 $PINS O=intadd_90/B[0] I1=FE_OFN853_IxIy_shift_0
+ I2=FE_OFN289_FE_DBTN106_IxIt_shift_5
XU355 NR2 $PINS O=intadd_90/CI I1=FE_RN_1 I2=FE_OFN1455_FE_DBTN121_IxIy_shift_3
XU356 OAI22S $PINS O=n149 A1=n142 A2=intadd_89/A[0] B1=n141 B2=intadd_89/A[0]
XU357 NR2 $PINS O=n148 I1=FE_OFN1576_IxIy_shift_1 I2=FE_OFN1250_n4487
XU358 NR2 $PINS O=n147 I1=n153 I2=n152
XU359 FA1S $PINS S=intadd_78/A[4] CO=intadd_78/B[5] A=intadd_90/SUM[1] B=n146
+ CI=intadd_89/SUM[0]
XU360 FA1S $PINS S=n151 CO=n146 A=n149 B=n148 CI=n147
XU361 NR2 $PINS O=n166 I1=FE_OFN1576_IxIy_shift_1 I2=FE_DBTN104_IxIt_shift_3
XU362 NR2 $PINS O=n165 I1=FE_OFN853_IxIy_shift_0 I2=FE_OFN1250_n4487
XU363 NR2 $PINS O=n164 I1=FE_OFN1200_n1437 I2=FE_DBTN119_IxIy_shift_2
XU364 FA1S $PINS S=intadd_78/A[3] CO=intadd_78/B[4] A=n151 B=n150
+ CI=intadd_90/SUM[0]
XU365 MOAI1S $PINS O=n162 A1=n153 A2=n152 B1=n153 B2=n152
XU366 NR2 $PINS O=n157 I1=n156 I2=n155
XU367 NR2 $PINS O=n160 I1=n158 I2=n157
XU368 INV1S $PINS O=intadd_78/B[3] I=n159
XU369 FA1S $PINS S=n163 CO=n159 A=n162 B=n161 CI=n160
XU370 INV1S $PINS O=intadd_78/A[2] I=n163
XU371 NR2 $PINS O=intadd_78/B[0] I1=FE_DBTN119_IxIy_shift_2 I2=n177
XU372 FA1S $PINS S=intadd_78/B[2] CO=n150 A=n166 B=n165 CI=n164
XU374 NR2 $PINS O=n230 I1=FE_OFN1571_n2620 I2=FE_DBTN106_IxIt_shift_5
XU375 INV1S $PINS O=intadd_91/A[2] I=n167
XU376 NR2 $PINS O=intadd_91/A[0] I1=FE_OFN4272_FE_OFN1224_n2891 I2=IxIt_shift_7
XU378 NR2 $PINS O=intadd_91/B[0]
+ I1=FE_OFN4203_FE_OFN1164_FE_DBTN127_IxIy_shift_13 I2=FE_DBTN106_IxIt_shift_5
XU380 NR2 $PINS O=intadd_91/CI I1=FE_OFN1650_IxIy_shift_14 I2=n4487
XU381 NR2 $PINS O=n170 I1=FE_OFN1613_IxIy_shift_12 I2=IxIt_shift_7
XU382 NR2 $PINS O=n169 I1=FE_OFN4203_FE_OFN1164_FE_DBTN127_IxIy_shift_13
+ I2=FE_OFN285_FE_DBTN108_IxIt_shift_6
XU383 NR2 $PINS O=n168 I1=FE_OFN1650_IxIy_shift_14 I2=FE_DBTN106_IxIt_shift_5
XU384 FA1S $PINS S=intadd_91/B[1] CO=intadd_91/B[2] A=n170 B=n169 CI=n168
XU385 NR2 $PINS O=n173 I1=FE_OFN1571_n2620 I2=B[2]
XU386 INV1S $PINS O=intadd_82/A[2] I=n171
XU387 NR2 $PINS O=intadd_82/A[0]
+ I1=FE_OFN4201_FE_OFN1164_FE_DBTN127_IxIy_shift_13
+ I2=FE_OFN1467_FE_DBTN104_IxIt_shift_3
XU388 NR2 $PINS O=intadd_82/B[0] I1=FE_OFN1224_n2891
+ I2=FE_OFN289_FE_DBTN106_IxIt_shift_5
XU389 NR2 $PINS O=intadd_82/CI I1=FE_OFN1561_IxIy_shift_10
+ I2=FE_OFN285_FE_DBTN108_IxIt_shift_6
XU390 FA1S $PINS S=n175 CO=n171 A=n174 B=n173 CI=n172
XU391 INV1S $PINS O=intadd_83/A[2] I=n175
XU392 NR2 $PINS O=n189 I1=FE_OFN1571_n2620 I2=n71
XU393 AOI22S $PINS O=n188 A1=FE_OFN1110_IxIy_shift_8 A2=B[7]
+ B1=FE_OFN1098_IxIy_shift_13 B2=FE_OFN1599_n1437
XU394 INV1S $PINS O=intadd_83/B[2] I=n176
XU395 NR2 $PINS O=intadd_83/A[0] I1=FE_OFN4192_FE_OFN1067_n3310
+ I2=FE_OFN285_FE_DBTN108_IxIt_shift_6
XU396 NR2 $PINS O=intadd_83/B[0] I1=FE_OFN1561_IxIy_shift_10
+ I2=FE_DBTN106_IxIt_shift_5
XU397 NR2 $PINS O=intadd_83/CI I1=FE_OFN1650_IxIy_shift_14 I2=n71
XU398 NR2 $PINS O=n193 I1=FE_OFN1571_n2620 I2=n177
XU399 INV1S $PINS O=intadd_83/B[1] I=n178
XU400 NR2 $PINS O=n182 I1=FE_OFN1561_IxIy_shift_10 I2=IxIt_shift_7
XU401 NR2 $PINS O=n181 I1=FE_OFN4201_FE_OFN1164_FE_DBTN127_IxIy_shift_13
+ I2=n4487
XU402 NR2 $PINS O=n180 I1=FE_OFN1650_IxIy_shift_14
+ I2=FE_OFN1467_FE_DBTN104_IxIt_shift_3
XU403 NR2 $PINS O=n185 I1=FE_OFN1613_IxIy_shift_12
+ I2=FE_OFN285_FE_DBTN108_IxIt_shift_6
XU404 FA1S $PINS S=intadd_82/B[1] CO=n183 A=n182 B=n181 CI=n180
XU405 FA1S $PINS S=intadd_83/B[3] CO=intadd_82/B[3] A=n185 B=n184 CI=n183
XU406 NR2 $PINS O=n186 I1=FE_OFN4201_FE_OFN1164_FE_DBTN127_IxIy_shift_13
+ I2=B[2]
XU407 AO13S $PINS O=intadd_84/B[1] A1=n188 B1=FE_OFN1499_FE_DBTN28_IxIt_shift_7
+ B2=FE_OFN1114_IxIy_shift_8 B3=n186
XU408 NR2 $PINS O=intadd_84/A[0] I1=FE_OFN1569_IxIy_shift_8
+ I2=FE_OFN285_FE_DBTN108_IxIt_shift_6
XU409 NR2 $PINS O=intadd_84/B[0] I1=FE_OFN4192_FE_OFN1067_n3310
+ I2=FE_OFN289_FE_DBTN106_IxIt_shift_5
XU410 NR2 $PINS O=intadd_84/CI I1=FE_OFN1613_IxIy_shift_12 I2=B[2]
XU411 FA1S $PINS S=n191 CO=n176 A=n190 B=n189 CI=n188
XU412 INV1S $PINS O=intadd_84/A[2] I=n191
XU413 NR2 $PINS O=intadd_92/A[0] I1=FE_OFN1561_IxIy_shift_10
+ I2=FE_OFN1250_n4487
XU414 NR2 $PINS O=intadd_92/CI I1=FE_OFN4272_FE_OFN1224_n2891
+ I2=FE_OFN1467_FE_DBTN104_IxIt_shift_3
XU415 FA1S $PINS S=n195 CO=n178 A=n194 B=n193 CI=n192
XU416 INV1S $PINS O=intadd_92/A[1] I=n195
XU417 NR2 $PINS O=intadd_93/A[0] I1=FE_OFN1569_IxIy_shift_8
+ I2=FE_OFN289_FE_DBTN106_IxIt_shift_5
XU418 NR2 $PINS O=intadd_93/B[0] I1=FE_OFN1322_IxIy_shift_10
+ I2=FE_OFN1467_FE_DBTN104_IxIt_shift_3
XU419 NR2 $PINS O=intadd_93/CI I1=FE_OFN4272_FE_OFN1224_n2891
+ I2=FE_OFN1200_n1437
XU420 OAI22S $PINS O=n208 A1=n198 A2=intadd_92/B[0] B1=n197 B2=intadd_92/B[0]
XU422 NR2 $PINS O=n207 I1=n212 I2=n211
XU423 NR2 $PINS O=n206 I1=FE_OFN4192_FE_OFN1067_n3310 I2=FE_OFN1250_n4487
XU424 FA1S $PINS S=intadd_76/A[4] CO=intadd_76/B[5] A=n200 B=intadd_93/SUM[1]
+ CI=intadd_92/SUM[0]
XU425 NR2 $PINS O=n227 I1=FE_OFN4321_n I2=FE_OFN1250_n4487
XU426 NR2 $PINS O=n226 I1=FE_OFN4192_FE_OFN1067_n3310
+ I2=FE_OFN1467_FE_DBTN104_IxIt_shift_3
XU427 NR2 $PINS O=n225 I1=FE_OFN1322_IxIy_shift_10 I2=FE_OFN1200_n1437
XU428 FA1S $PINS S=n209 CO=n200 A=n208 B=n207 CI=n206
XU429 FA1S $PINS S=intadd_76/A[3] CO=intadd_76/B[4] A=n210 B=n209
+ CI=intadd_93/SUM[0]
XU430 MOAI1S $PINS O=n223 A1=n212 A2=n211 B1=n212 B2=n211
XU431 INV1S $PINS O=n214 I=n213
XU432 AOI13HS $PINS O=n222 A1=n214 B1=FE_OFN1370_IxIt_shift_3
+ B2=FE_OFN1111_IxIy_shift_8 B3=n215
XU433 INV1S $PINS O=intadd_76/B[3] I=n218
XU435 NR2 $PINS O=intadd_76/CI I1=FE_OFN1561_IxIy_shift_10 I2=n177
XU436 FA1S $PINS S=n224 CO=n218 A=n223 B=n222 CI=n221
XU437 INV1S $PINS O=intadd_76/A[2] I=n224
XU438 FA1S $PINS S=intadd_76/B[2] CO=n210 A=n227 B=n226 CI=n225
XU439 FA1S $PINS S=n167 CO=n235 A=n230 B=n229 CI=n228
XU441 NR2 $PINS O=n233 I1=FE_OFN1571_n2620 I2=FE_OFN285_FE_DBTN108_IxIt_shift_6
XU442 INV1S $PINS O=intadd_76/B[11] I=n232
XU443 FA1S $PINS S=n232 CO=n236 A=n235 B=n234 CI=n233
XU444 INV1S $PINS O=intadd_76/B[12] I=n236
XU445 NR2 $PINS O=N18 I1=FE_OFN4321_n I2=n177
XU446 INV1S $PINS O=N33 I=intadd_76/n1
XU448 NR2 $PINS O=n292 I1=FE_OFN1741_IxIt_shift_15 I2=FE_OFN1333_IxIy_shift_5
XU449 INV1S $PINS O=intadd_94/A[2] I=n238
XU450 NR2 $PINS O=intadd_94/A[0] I1=FE_OFN1731_IxIt_shift_11 I2=n250
XU451 NR2 $PINS O=intadd_94/B[0] I1=FE_OFN1711_IxIt_shift_13
+ I2=FE_OFN1333_IxIy_shift_5
XU452 NR2 $PINS O=intadd_94/CI I1=FE_OFN1020_FE_DBTN114_IxIt_shift_14
+ I2=FE_OFN1340_IxIy_shift_4
XU454 NR2 $PINS O=n241 I1=n427 I2=n250
XU455 NR2 $PINS O=n240 I1=FE_OFN1711_IxIt_shift_13
+ I2=FE_OFN281_FE_DBTN122_IxIy_shift_6
XU456 NR2 $PINS O=n239 I1=FE_OFN1020_FE_DBTN114_IxIt_shift_14
+ I2=FE_OFN1333_IxIy_shift_5
XU457 FA1S $PINS S=intadd_94/B[1] CO=intadd_94/B[2] A=n241 B=n240 CI=n239
XU458 NR2 $PINS O=n244 I1=FE_OFN1741_IxIt_shift_15 I2=FE_OFN1638_IxIy_shift_2
XU459 INV1S $PINS O=intadd_85/A[2] I=n242
XU460 NR2 $PINS O=intadd_85/A[0] I1=FE_OFN1711_IxIt_shift_13
+ I2=FE_DBTN121_IxIy_shift_3
XU461 NR2 $PINS O=intadd_85/B[0] I1=FE_OFN1731_IxIt_shift_11
+ I2=FE_OFN1333_IxIy_shift_5
XU462 NR2 $PINS O=intadd_85/CI I1=FE_OFN1459_FE_DBTN113_IxIt_shift_10
+ I2=FE_OFN281_FE_DBTN122_IxIy_shift_6
XU463 FA1S $PINS S=n246 CO=n242 A=n245 B=n244 CI=n243
XU464 INV1S $PINS O=intadd_86/A[2] I=n246
XU465 NR2 $PINS O=n260 I1=FE_OFN1741_IxIt_shift_15 I2=n143
XU466 INV1S $PINS O=intadd_86/B[2] I=n247
XU467 NR2 $PINS O=intadd_86/B[0] I1=FE_OFN1459_FE_DBTN113_IxIt_shift_10
+ I2=FE_OFN1333_IxIy_shift_5
XU468 NR2 $PINS O=intadd_86/CI I1=FE_OFN1020_FE_DBTN114_IxIt_shift_14 I2=n143
XU469 NR2 $PINS O=n265 I1=FE_OFN1741_IxIt_shift_15 I2=FE_DBTN118_IxIy_shift_0
XU470 INV1S $PINS O=intadd_86/B[1] I=n249
XU471 NR2 $PINS O=n255 I1=FE_OFN1459_FE_DBTN113_IxIt_shift_10 I2=n250
XU472 NR2 $PINS O=n254 I1=FE_OFN1711_IxIt_shift_13 I2=FE_OFN1340_IxIy_shift_4
XU473 NR2 $PINS O=n253 I1=FE_OFN1020_FE_DBTN114_IxIt_shift_14
+ I2=FE_DBTN121_IxIy_shift_3
XU474 NR2 $PINS O=n258 I1=n427 I2=FE_OFN281_FE_DBTN122_IxIy_shift_6
XU475 FA1S $PINS S=intadd_85/B[1] CO=n256 A=n255 B=n254 CI=n253
XU476 FA1S $PINS S=intadd_86/B[3] CO=intadd_85/B[3] A=n258 B=n257 CI=n256
XU477 NR2 $PINS O=intadd_87/A[0] I1=FE_OFN4304_n I2=FE_OFN1647_IxIy_shift_6
XU478 NR2 $PINS O=intadd_87/B[0] I1=FE_OFN1674_n1658 I2=FE_OFN1333_IxIy_shift_5
XU479 NR2 $PINS O=intadd_87/CI I1=n427 I2=FE_OFN1638_IxIy_shift_2
XU480 FA1S $PINS S=n262 CO=n247 A=n261 B=n260 CI=n259
XU481 INV1S $PINS O=intadd_87/A[2] I=n262
XU482 NR2 $PINS O=intadd_95/A[0] I1=FE_OFN1459_FE_DBTN113_IxIt_shift_10
+ I2=FE_OFN1340_IxIy_shift_4
XU483 NR2 $PINS O=intadd_95/CI I1=FE_OFN1731_IxIt_shift_11
+ I2=FE_DBTN121_IxIy_shift_3
XU484 FA1S $PINS S=n267 CO=n249 A=n266 B=n265 CI=n264
XU485 INV1S $PINS O=intadd_95/A[1] I=n267
XU486 NR2 $PINS O=intadd_96/A[0] I1=FE_OFN4304_n I2=FE_OFN1329_IxIy_shift_5
XU487 NR2 $PINS O=intadd_96/B[0] I1=FE_OFN1459_FE_DBTN113_IxIt_shift_10
+ I2=FE_DBTN121_IxIy_shift_3
XU488 NR2 $PINS O=intadd_96/CI I1=FE_OFN1731_IxIt_shift_11
+ I2=FE_OFN1638_IxIy_shift_2
XU489 FA1S $PINS S=n66 CO=n272 A=n271 B=n270 CI=n269
XU490 FA1S $PINS S=intadd_75/A[4] CO=intadd_75/B[5] A=n272 B=intadd_96/SUM[1]
+ CI=intadd_95/SUM[0]
XU491 MOAI1S $PINS O=n285 A1=n274 A2=n273 B1=n274 B2=n273
XU492 INV1S $PINS O=n276 I=n275
XU493 AOI13HS $PINS O=n284 A1=n276 B1=FE_OFN4301_n B2=n278
+ B3=FE_OFN1342_IxIy_shift_3
XU494 ND3 $PINS O=n283 I1=FE_OFN1358_IxIt_shift_10
+ I2=FE_OFN4267_FE_OFN1000_n143 I3=n279
XU495 INV1S $PINS O=intadd_75/B[3] I=n281
XU496 NR2 $PINS O=intadd_75/CI I1=FE_DBTN113_IxIt_shift_10
+ I2=FE_DBTN118_IxIy_shift_0
XU497 FA1S $PINS S=n286 CO=n281 A=n285 B=n284 CI=n283
XU498 INV1S $PINS O=intadd_75/A[2] I=n286
XU499 FA1S $PINS S=intadd_75/B[2] CO=n67 A=n289 B=n288 CI=n287
XU500 FA1S $PINS S=n238 CO=n298 A=n292 B=n291 CI=n290
XU501 NR2 $PINS O=n296 I1=FE_OFN1743_IxIt_shift_15
+ I2=FE_OFN281_FE_DBTN122_IxIy_shift_6
XU502 INV1S $PINS O=intadd_75/B[11] I=n295
XU503 FA1S $PINS S=n295 CO=n299 A=n298 B=n297 CI=n296
XU504 INV1S $PINS O=intadd_75/B[12] I=n299
XU505 NR2 $PINS O=N35 I1=FE_OFN4304_n I2=FE_DBTN118_IxIy_shift_0
XU506 INV1S $PINS O=N50 I=intadd_75/n1
XU508 OA222 $PINS O=n451 A1=FE_DBTN127_IxIy_shift_13
+ A2=FE_OFN4180_FE_OFN1570_n2620
+ B1=FE_OFN4202_FE_OFN1164_FE_DBTN127_IxIy_shift_13 B2=n348
+ C1=FE_OFN1154_FE_DBTN159_n2620 C2=FE_OFN1650_IxIy_shift_14
XU509 AOI22S $PINS O=n312 A1=FE_OFN1021_FE_DBTN114_IxIt_shift_14
+ A2=FE_OFN1155_FE_DBTN159_n2620 B1=FE_OFN985_IxIt_shift_14
+ B2=FE_OFN4180_FE_OFN1570_n2620
XU512 MOAI1S $PINS O=n450 A1=B[15] A2=FE_OFN1156_FE_DBTN159_n2620 B1=B[15]
+ B2=FE_OFN1156_FE_DBTN159_n2620
XU513 AOI22S $PINS O=intadd_77/A[10] A1=FE_OFN1530_n451 A2=n312
+ B1=FE_OFN1531_n452 B2=n450
XU514 INV1S $PINS O=intadd_77/A[11] I=intadd_77/A[10]
XU518 MOAI1S $PINS O=n313 A1=FE_OFN1743_IxIt_shift_15
+ A2=FE_DBTN127_IxIy_shift_13 B1=FE_OFN1743_IxIt_shift_15
+ B2=FE_DBTN127_IxIy_shift_13
XU519 OA222 $PINS O=n418 A1=FE_OFN1222_n2891 A2=FE_DBTN127_IxIy_shift_13
+ B1=FE_OFN1224_n2891 B2=FE_OFN1611_IxIy_shift_12
+ C1=FE_OFN4201_FE_OFN1164_FE_DBTN127_IxIy_shift_13 C2=FE_OFN1613_IxIy_shift_12
XU520 MOAI1S $PINS O=n321 A1=FE_DBTN127_IxIy_shift_13
+ A2=FE_OFN1021_FE_DBTN114_IxIt_shift_14 B1=FE_DBTN127_IxIy_shift_13
+ B2=FE_OFN1021_FE_DBTN114_IxIt_shift_14
XU521 AOI22S $PINS O=n318 A1=FE_OFN1547_n425 A2=n313 B1=FE_OFN1546_n418 B2=n321
XU524 AOI22S $PINS O=n316 A1=FE_OFN1531_n452 A2=n312 B1=FE_OFN1530_n451 B2=n319
XU525 OA12 $PINS O=n315 A1=n313 B1=FE_OFN1547_n425 B2=FE_OFN1546_n418
XU526 INV1S $PINS O=intadd_77/B[10] I=n314
XU527 FA1S $PINS S=n317 CO=n314 A=n318 B=n316 CI=n315
XU528 INV1S $PINS O=intadd_77/A[9] I=n317
XU529 INV1S $PINS O=n448 I=n318
XU530 MOAI1S $PINS O=n322 A1=FE_OFN1529_n427 A2=FE_OFN1156_FE_DBTN159_n2620
+ B1=FE_OFN1529_n427 B2=FE_OFN1155_FE_DBTN159_n2620
XU531 AOI22S $PINS O=n447 A1=FE_OFN1531_n452 A2=n319 B1=FE_OFN1530_n451 B2=n322
XU532 MOAI1S $PINS O=n328 A1=FE_OFN4227_FE_OFN1218_n2891
+ A2=FE_OFN1740_IxIt_shift_15 B1=FE_OFN4227_FE_OFN1218_n2891
+ B2=FE_OFN1740_IxIt_shift_15
XU533 MOAI1S $PINS O=n340 A1=FE_OFN4314_FE_DBTN156_n2891
+ A2=FE_OFN1021_FE_DBTN114_IxIt_shift_14 B1=FE_OFN4314_FE_DBTN156_n2891
+ B2=FE_OFN1021_FE_DBTN114_IxIt_shift_14
XU534 INV1S $PINS O=n320 I=n340
XU535 INV1S $PINS O=n326 I=n354
XU536 MOAI1S $PINS O=n329 A1=FE_OFN991_IxIt_shift_13 A2=FE_OFN4315_n
+ B1=FE_OFN991_IxIt_shift_13 B2=FE_OFN4315_n
XU537 AOI22S $PINS O=n325 A1=FE_OFN1547_n425 A2=n321 B1=FE_OFN1546_n418 B2=n329
XU538 MOAI1S $PINS O=n333 A1=n429 A2=FE_OFN1155_FE_DBTN159_n2620 B1=n429
+ B2=FE_OFN1155_FE_DBTN159_n2620
XU539 AOI22S $PINS O=n324 A1=FE_OFN1531_n452 A2=n322 B1=n451 B2=n333
XU540 INV1S $PINS O=intadd_77/B[9] I=n323
XU541 FA1S $PINS S=n337 CO=n446 A=n326 B=n325 CI=n324
XU542 OAI22S $PINS O=n336 A1=n341 A2=n328 B1=n327 B2=n328
XU543 MOAI1S $PINS O=n344 A1=FE_OFN1529_n427 A2=FE_OFN4315_n B1=FE_OFN1529_n427
+ B2=FE_OFN4315_n
XU544 AOI22S $PINS O=n353 A1=FE_OFN1547_n425 A2=n329 B1=FE_OFN1546_n418 B2=n344
XU545 AOI22S $PINS O=n343 A1=FE_DBTN113_IxIt_shift_10
+ A2=FE_OFN1154_FE_DBTN159_n2620 B1=FE_OFN1357_IxIt_shift_10
+ B2=FE_OFN4180_FE_OFN1570_n2620
XU546 AOI22S $PINS O=n352 A1=FE_OFN1531_n452 A2=n333 B1=n451 B2=n343
XU547 INV1S $PINS O=intadd_77/A[8] I=n334
XU548 FA1S $PINS S=n338 CO=n334 A=n337 B=n336 CI=n335
XU549 INV1S $PINS O=intadd_77/A[7] I=n338
XU550 MOAI1S $PINS O=n363 A1=FE_OFN992_IxIt_shift_13
+ A2=FE_OFN4314_FE_DBTN156_n2891 B1=FE_OFN992_IxIt_shift_13
+ B2=FE_OFN4314_FE_DBTN156_n2891
XU551 MOAI1S $PINS O=n361 A1=n341 A2=n340 B1=n438 B2=n363
XU552 MOAI1S $PINS O=n367 A1=FE_OFN4180_FE_OFN1570_n2620 A2=FE_OFN1673_n1658
+ B1=FE_OFN4180_FE_OFN1570_n2620 B2=FE_OFN1673_n1658
XU553 AO22 $PINS O=n359 A1=n452 A2=n343 B1=n451 B2=n367
XU554 NR2 $PINS O=n360 I1=n361 I2=n359
XU555 MOAI1S $PINS O=n369 A1=n429 A2=FE_OFN1163_FE_DBTN127_IxIy_shift_13
+ B1=FE_OFN1353_IxIt_shift_11 B2=FE_OFN1163_FE_DBTN127_IxIy_shift_13
XU556 AOI22S $PINS O=n372 A1=FE_OFN1547_n425 A2=n344 B1=FE_OFN1546_n418 B2=n369
XU557 MOAI1S $PINS O=n351 A1=FE_OFN4255_FE_OFN1161_FE_DBTN151_n3310
+ A2=FE_OFN1740_IxIt_shift_15 B1=FE_OFN4255_FE_OFN1161_FE_DBTN151_n3310
+ B2=FE_OFN1740_IxIt_shift_15
XU558 NR2 $PINS O=n346 I1=FE_OFN4260_FE_OFN1392_n187
+ I2=FE_OFN4255_FE_OFN1161_FE_DBTN151_n3310
XU559 NR2 $PINS O=n371 I1=n351 I2=n346
XU561 MXL2HS $PINS OB=n349 S=n452 A=FE_OFN1650_IxIy_shift_14 B=FE_OFN4303_n
XU562 NR2 $PINS O=n379 I1=FE_OFN1154_FE_DBTN159_n2620 I2=n349
XU563 MOAI1S $PINS O=n378 A1=FE_OFN1569_IxIy_shift_8 A2=n351 B1=n430
+ B2=FE_OFN1021_FE_DBTN114_IxIt_shift_14
XU564 FA1S $PINS S=n356 CO=n335 A=n354 B=n353 CI=n352
XU565 INV1S $PINS O=intadd_77/B[7] I=n355
XU566 FA1S $PINS S=n358 CO=n355 A=n360 B=n357 CI=n356
XU567 INV1S $PINS O=intadd_77/A[6] I=n358
XU568 OAI22S $PINS O=n376 A1=n361 A2=n360 B1=n359 B2=n360
XU569 MOAI1S $PINS O=n386 A1=FE_OFN4227_FE_OFN1218_n2891 A2=FE_OFN4271_n427
+ B1=FE_OFN4227_FE_OFN1218_n2891 B2=FE_OFN4271_n427
XU570 AOI22S $PINS O=n389 A1=FE_OFN1761_n341 A2=n363 B1=FE_OFN1548_n438 B2=n386
XU571 MOAI1S $PINS O=n366 A1=FE_OFN4302_n A2=FE_OFN1154_FE_DBTN159_n2620
+ B1=FE_OFN4302_n B2=FE_OFN1154_FE_DBTN159_n2620
XU572 AOI22S $PINS O=n388 A1=n452 A2=n367 B1=n451 B2=n366
XU573 MOAI1S $PINS O=n395 A1=FE_OFN1357_IxIt_shift_10
+ A2=FE_OFN1163_FE_DBTN127_IxIy_shift_13 B1=FE_OFN1357_IxIt_shift_10
+ B2=FE_OFN1163_FE_DBTN127_IxIy_shift_13
XU574 AOI22S $PINS O=n387 A1=FE_OFN1547_n425 A2=n369 B1=FE_OFN1546_n418 B2=n395
XU575 FA1S $PINS S=n374 CO=n357 A=n372 B=n371 CI=n370
XU576 INV1S $PINS O=intadd_77/B[6] I=n373
XU577 FA1S $PINS S=n377 CO=n373 A=n376 B=n375 CI=n374
XU578 INV1S $PINS O=intadd_77/A[5] I=n377
XU579 MOAI1S $PINS O=n393 A1=n379 A2=n378 B1=n379 B2=n378
XU580 MOAI1S $PINS O=n383 A1=FE_OFN4255_FE_OFN1161_FE_DBTN151_n3310
+ A2=FE_DBTN114_IxIt_shift_14 B1=FE_OFN4255_FE_OFN1161_FE_DBTN151_n3310
+ B2=FE_DBTN114_IxIt_shift_14
XU581 AOI22S $PINS O=n397 A1=FE_OFN4260_FE_OFN1392_n187 A2=n383 B1=n430
+ B2=FE_OFN1711_IxIt_shift_13
XU583 AOI22S $PINS O=n396 A1=FE_OFN1761_n341 A2=n386 B1=FE_OFN1548_n438 B2=n414
XU584 FA1S $PINS S=n391 CO=n375 A=n389 B=n388 CI=n387
XU585 INV1S $PINS O=intadd_77/B[5] I=n390
XU586 FA1S $PINS S=n394 CO=n390 A=n393 B=n392 CI=n391
XU587 INV1S $PINS O=intadd_77/A[4] I=n394
XU589 AOI22S $PINS O=n408 A1=n425 A2=n395 B1=n418 B2=n419
XU590 FA1S $PINS S=n407 CO=n392 A=n398 B=n397 CI=n396
XU592 MXL2HS $PINS OB=n400 S=n425 A=FE_OFN1613_IxIy_shift_12 B=FE_OFN4303_n
XU593 NR2 $PINS O=n411 I1=FE_OFN1164_FE_DBTN127_IxIy_shift_13 I2=n400
XU594 MOAI1S $PINS O=n404 A1=FE_OFN4255_FE_OFN1161_FE_DBTN151_n3310
+ A2=FE_OFN1709_IxIt_shift_13 B1=FE_OFN1161_FE_DBTN151_n3310
+ B2=FE_OFN1709_IxIt_shift_13
XU595 MOAI1S $PINS O=n410 A1=FE_OFN1569_IxIy_shift_8 A2=n404 B1=n430
+ B2=FE_OFN4271_n427
XU596 INV1S $PINS O=intadd_77/B[4] I=n405
XU597 FA1S $PINS S=n409 CO=n405 A=n408 B=n407 CI=n406
XU598 INV1S $PINS O=intadd_77/A[3] I=n409
XU599 MOAI1S $PINS O=n434 A1=FE_OFN1357_IxIt_shift_10 A2=FE_DBTN156_n2891
+ B1=FE_OFN1357_IxIt_shift_10 B2=FE_DBTN156_n2891
XU600 AOI22S $PINS O=n422 A1=FE_OFN1761_n341 A2=n414 B1=FE_OFN1548_n438 B2=n434
XU601 MOAI1S $PINS O=n417 A1=FE_OFN4302_n
+ A2=FE_OFN1163_FE_DBTN127_IxIy_shift_13 B1=FE_OFN4302_n
+ B2=FE_OFN4202_FE_OFN1164_FE_DBTN127_IxIy_shift_13
XU602 AOI22S $PINS O=n421 A1=n425 A2=n419 B1=n418 B2=n417
XU603 INV1S $PINS O=intadd_77/B[3] I=n420
XU604 FA1S $PINS S=n424 CO=n420 A=n423 B=n422 CI=n421
XU605 INV1S $PINS O=intadd_77/A[2] I=n424
XU606 MOAI1S $PINS O=n431 A1=FE_OFN1161_FE_DBTN151_n3310 A2=FE_OFN4271_n427
+ B1=FE_OFN1161_FE_DBTN151_n3310 B2=FE_OFN4271_n427
XU607 AOI22S $PINS O=n443 A1=FE_OFN4260_FE_OFN1392_n187 A2=n431 B1=n430
+ B2=FE_OFN1731_IxIt_shift_11
XU608 AOI22S $PINS O=n442 A1=FE_OFN1761_n341 A2=n434 B1=FE_OFN1548_n438 B2=n433
XU609 INV1S $PINS O=intadd_77/B[2] I=n435
XU610 MOAI1S $PINS O=intadd_77/CI A1=n441 A2=FE_OFN4301_n B1=FE_OFN1218_n2891
+ B2=FE_OFN1548_n438
XU611 FA1S $PINS S=n445 CO=n435 A=n444 B=n443 CI=n442
XU612 INV1S $PINS O=intadd_77/B[1] I=n445
XU613 FA1S $PINS S=n449 CO=n323 A=n448 B=n447 CI=n446
XU614 INV1S $PINS O=intadd_77/B[8] I=n449
XU615 OAI12HS $PINS O=intadd_77/B[11] A1=n450 B1=FE_OFN1531_n452
+ B2=FE_OFN1530_n451
XU616 INV1S $PINS O=N67 I=intadd_77/n1
XU617 INV1S $PINS O=intadd_74/B[21] I=s1_P3[13]
XU618 INV1S $PINS O=intadd_74/B[20] I=s1_P3[12]
XU619 INV1S $PINS O=intadd_74/B[19] I=s1_P3[11]
XU620 INV1S $PINS O=intadd_74/B[18] I=s1_P3[10]
XU621 INV1S $PINS O=intadd_74/A[17] I=s1_P3[9]
XU622 NR2 $PINS O=n453 I1=s1_P0[9] I2=s1_P2[1]
XU623 NR2 $PINS O=intadd_74/B[1] I1=intadd_74/A[2] I2=n453
XU624 FA1S $PINS S=n474 CO=n475 A=N37 B=N20 CI=N11
XU625 FA1S $PINS S=n476 CO=n477 A=N38 B=N21 CI=N12
XU626 FA1S $PINS S=n478 CO=n479 A=N39 B=N22 CI=N13
XU627 FA1S $PINS S=n480 CO=n481 A=N40 B=N23 CI=N14
XU628 NR2 $PINS O=n456 I1=n454 I2=intadd_78/n1
XU629 NR2 $PINS O=n457 I1=n456 I2=n455
XU630 FA1 $PINS S=n484 CO=n485 A=N42 B=N25 CI=n457
XU631 NR2 $PINS O=n460 I1=FE_OFN1569_IxIy_shift_8 I2=FE_OFN4304_n
XU632 FA1S $PINS S=n486 CO=n487 A=n460 B=N26 CI=N43
XU633 NR2 $PINS O=n467 I1=n460 I2=FE_OFN4193_FE_OFN1067_n3310
XU634 MOAI1S $PINS O=n464 A1=FE_OFN1671_n1658 A2=FE_OFN1067_n3310
+ B1=FE_OFN1671_n1658 B2=FE_OFN1067_n3310
XU635 AN2 $PINS O=n466 I1=n464 I2=FE_OFN1392_n187
XU636 OA12 $PINS O=n468 A1=n465 B1=n467 B2=n466
XU637 FA1S $PINS S=n488 CO=n489 A=n468 B=N27 CI=N44
XU638 OAI22S $PINS O=n471 A1=n470 A2=intadd_77/B[0] B1=n469 B2=intadd_77/B[0]
XU639 FA1S $PINS S=n490 CO=n491 A=n471 B=N28 CI=N45
XU640 FA1S $PINS S=n492 CO=n493 A=N55 B=N29 CI=N46
XU641 FA1S $PINS S=n494 CO=n495 A=N56 B=N30 CI=N47
XU642 FA1S $PINS S=n496 CO=n497 A=N57 B=N31 CI=N48
XU643 FA1S $PINS S=N77 CO=intadd_74/n22 A=intadd_74/B[1] B=s1_P1[1]
+ CI=intadd_74/n23
XU644 FA1 $PINS S=N90 CO=intadd_74/n9 A=intadd_74/B[14] B=intadd_74/A[14]
+ CI=intadd_74/n10
XU645 FA1 $PINS S=N91 CO=intadd_74/n8 A=intadd_74/B[15] B=intadd_74/A[15]
+ CI=intadd_74/n9
XU646 FA1S $PINS S=n472 CO=n473 A=N9 B=N18 CI=N35
XU647 FA1 $PINS S=N66 CO=intadd_77/n1 A=intadd_77/B[11] B=intadd_77/A[11]
+ CI=intadd_77/n2
Xs1_P0_reg[6] QDFFRBS $PINS Q=N74 D=N7 CK=clk_clone2 RB=FE_OFN102_i_reset_n_i
Xs1_P3_reg[11] QDFFRBS $PINS Q=s1_P3[11] D=N63 CK=clk_clone3
+ RB=FE_OFN262_i_reset_n_i
Xs2_result_reg[21] QDFFRBS $PINS Q=result[21] D=N89 CK=clk_clone3
+ RB=FE_OFN45_i_reset_n_i
Xs2_result_reg[6] QDFFRBS $PINS Q=result[6] D=FE_PHN3123_N74 CK=clk_clone2
+ RB=FE_OFN24_i_reset_n_i
XR_37 QDFFRBS $PINS Q=intadd_74/A[11] D=n491 CK=clk_clone3
+ RB=FE_OFN189_i_reset_n_i
XR_52 QDFFRBS $PINS Q=intadd_74/B[3] D=n476 CK=clk RB=FE_OFN266_i_reset_n_i
XU8 ND2S $PINS O=n211 I1=FE_OFN1611_IxIy_shift_12 I2=FE_OFN869_IxIt_shift_0
XU12 ND2S $PINS O=n65 I1=FE_OFN1350_IxIt_shift_12 I2=FE_OFN1000_n143
XU15 ND2S $PINS O=n155 I1=FE_OFN855_IxIy_shift_0 I2=FE_OFN1370_IxIt_shift_3
.ENDS

.SUBCKT mult_pipe_0 rst_n A[15] A[14] A[13] A[12] A[11] A[10] A[9] A[8] A[7]
+ A[6] A[5] A[4] A[3] A[2] A[1] A[0] B[15] B[14] B[13] B[12] B[11] B[10] B[9]
+ B[8] B[7] B[6] B[5] B[4] B[3] B[2] B[1] B[0] result[31] result[30] result[29]
+ result[28] result[27] result[26] result[25] result[24] result[23] result[22]
+ result[21] result[20] result[19] result[18] result[17] result[16] result[15]
+ result[14] result[13] result[12] result[11] result[10] result[9] result[8]
+ result[7] result[6] result[5] result[4] result[3] result[2] result[1]
+ result[0] IxIy_shift_4 IxIy_shift_5 FE_OFN109_i_reset_n_i
+ FE_OFN94_i_reset_n_i FE_OFN81_i_reset_n_i FE_OFN78_i_reset_n_i
+ FE_OFN77_i_reset_n_i FE_OFN58_i_reset_n_i FE_OFN56_i_reset_n_i
+ FE_OFN53_i_reset_n_i FE_OFN36_i_reset_n_i FE_OFN35_i_reset_n_i
+ FE_OFN31_i_reset_n_i FE_OFN30_i_reset_n_i FE_OFN19_i_reset_n_i
+ FE_OFN17_i_reset_n_i FE_OFN13_i_reset_n_i FE_OFN11_i_reset_n_i
+ FE_OFN10_i_reset_n_i FE_OFN4_i_reset_n_i FE_OFN126_IxIy_shift_1
+ FE_OFN125_IxIy_shift_1 FE_OFN124_IxIy_shift_1 FE_OFN123_IxIy_shift_1
+ FE_OFN131_IxIy_shift_0 FE_OFN130_IxIy_shift_0 FE_OFN129_IxIy_shift_0
+ FE_OFN128_IxIy_shift_0 FE_OFN146_IxIy_shift_14 FE_OFN148_IxIy_shift_12
+ FE_OFN147_IxIy_shift_12 FE_OFN155_n3310 FE_OFN162_IxIy_shift_13
+ FE_OFN163_IxIy_shift_8 FE_OFN165_IxIy_shift_7 FE_OFN164_IxIy_shift_7
+ FE_OFN179_n2891 FE_OFN214_IxIy_shift_10 FE_OFN216_IxIy_shift_5
+ FE_OFN215_IxIy_shift_5 FE_OFN218_IxIy_shift_4 FE_OFN217_IxIy_shift_4
+ FE_OFN223_IxIy_shift_3 FE_OFN221_IxIy_shift_3 FE_OFN220_IxIy_shift_3
+ FE_OFN245_FE_DBTN30_IxIy_shift_5 FE_OFN244_FE_DBTN30_IxIy_shift_5
+ FE_OFN249_FE_DBTN10_IxIy_shift_4 FE_OFN248_FE_DBTN10_IxIy_shift_4
+ FE_OFN253_IxIy_shift_1 FE_OFN255_IxIy_shift_7 FE_OFN257_IxIy_shift_13
+ FE_OFN264_FE_OFN1323_IxIy_shift_10 FE_OFN265_FE_OFN1124_IxIy_shift_7
+ FE_OFN270_IxIy_shift_3 clk_clone4 clk_clone3 clk_clone2 clk_clone1 clk
XFE_PHC3281_N80 BUF1CK $PINS O=FE_PHN3281_N80 I=N80
XFE_PHC3277_N96 BUF1CK $PINS O=FE_PHN3277_N96 I=N96
XFE_PHC3222_intadd_63_A_22 BUF1CK $PINS O=FE_PHN3222_intadd_63_A_22
+ I=intadd_63/A[22]
XFE_PHC3157_N85 BUF2CK $PINS O=FE_PHN3157_N85 I=N85
XFE_PHC3135_N68 DELB $PINS O=FE_PHN3135_N68 I=N68
XFE_PHC3129_s1_P0_8 DELB $PINS O=FE_PHN3129_s1_P0_8 I=s1_P0[8]
XFE_PHC3108_N71 DELB $PINS O=FE_PHN3108_N71 I=N71
XFE_PHC3094_N72 DELB $PINS O=FE_PHN3094_N72 I=N72
XFE_PHC3084_N73 DELB $PINS O=FE_PHN3084_N73 I=N73
XFE_PHC3008_N70 DELB $PINS O=FE_PHN3008_N70 I=N70
XFE_PHC2976_N75 DELB $PINS O=FE_PHN2976_N75 I=N75
XFE_PHC2948_N74 DELB $PINS O=FE_PHN2948_N74 I=N74
XFE_RC_33_0 MOAI1 $PINS O=n212 A1=FE_OFN4338_n A2=FE_OFN4257_FE_RN_1
+ B1=FE_OFN4338_n B2=FE_OFN4257_FE_RN_1
XFE_RC_10_0 AN2 $PINS O=FE_RN_2_0 I1=FE_RN_5_0 I2=FE_RN_4_0
XFE_RC_9_0 XNR2HS $PINS O=FE_RN_3_0 I1=s1_P0[12] I2=s1_P1[3]
XFE_RC_8_0 MXL2HS $PINS OB=N80 S=intadd_63/n20 A=FE_RN_3_0 B=FE_RN_2_0
XFE_RC_7_0 ND2S $PINS O=FE_RN_4_0 I1=s1_P1[3] I2=s1_P0[12]
XFE_RC_6_0 OR2 $PINS O=FE_RN_5_0 I1=s1_P0[12] I2=s1_P1[3]
XFE_RC_5_0 ND2 $PINS O=FE_RN_6_0 I1=FE_RN_5_0 I2=intadd_63/n20
XFE_RC_4_0 ND2S $PINS O=intadd_63/n19 I1=FE_RN_6_0 I2=FE_RN_4_0
XFE_RC_0_0 MOAI1 $PINS O=n290 A1=FE_OFN1402_FE_DBTN158_n2891
+ A2=FE_OFN979_IxIy_shift_12 B1=FE_OFN1402_FE_DBTN158_n2891
+ B2=FE_OFN979_IxIy_shift_12
XFE_OFC2903_n2620 BUF1 $PINS O=FE_OFN4338_n I=FE_OFN4337_n
XFE_OFC2902_n2620 BUF1 $PINS O=FE_OFN4337_n I=FE_OFN1573_n2620
XFE_OFC2899_FE_DBTN153_n3310 BUF1 $PINS O=FE_OFN4334_FE_DBTN153_n3310
+ I=FE_DBTN153_n3310
XFE_OFC2898_FE_DBTN153_n3310 BUF1 $PINS O=FE_OFN4333_FE_DBTN153_n3310
+ I=FE_DBTN153_n3310
XFE_OFC2887_IxIy_shift_10 BUF1 $PINS O=FE_OFN4322_n I=FE_OFN1563_IxIy_shift_10
XFE_OFC2883_n2620 BUF1 $PINS O=FE_OFN4318_n I=FE_OFN1059_n2620
XFE_OFC2871_n3310 BUF1 $PINS O=FE_OFN4306_n I=FE_OFN4305_n
XFE_OFC2870_n3310 BUF1 $PINS O=FE_OFN4305_n I=A[9]
XFE_OFC2864_n303 BUF1 $PINS O=FE_OFN4299_n303 I=n303
XFE_OFC2863_n303 BUF1 $PINS O=FE_OFN4298_n303 I=n303
XFE_OFC2822_FE_RN_1 BUF1 $PINS O=FE_OFN4257_FE_RN_1 I=FE_RN_1
XFE_OFC2819_FE_OFN1402_FE_DBTN158_n2891 BUF1 $PINS
+ O=FE_OFN4254_FE_OFN1402_FE_DBTN158_n2891 I=FE_OFN1402_FE_DBTN158_n2891
XFE_OFC2812_FE_OFN1101_IxIy_shift_13 BUF1 $PINS
+ O=FE_OFN4247_FE_OFN1101_IxIy_shift_13 I=FE_OFN1101_IxIy_shift_13
XFE_OFC2796_FE_OFN1108_IxIy_shift_8 BUF1 $PINS
+ O=FE_OFN4231_FE_OFN1108_IxIy_shift_8 I=FE_OFN4230_FE_OFN1108_IxIy_shift_8
XFE_OFC2795_FE_OFN1108_IxIy_shift_8 BUF1 $PINS
+ O=FE_OFN4230_FE_OFN1108_IxIy_shift_8 I=FE_OFN1108_IxIy_shift_8
XFE_OFC2783_FE_OFN1583_IxIy_shift_13 BUF1 $PINS
+ O=FE_OFN4218_FE_OFN1583_IxIy_shift_13 I=FE_OFN4217_FE_OFN1583_IxIy_shift_13
XFE_OFC2782_FE_OFN1583_IxIy_shift_13 BUF1 $PINS
+ O=FE_OFN4217_FE_OFN1583_IxIy_shift_13 I=FE_OFN257_IxIy_shift_13
XFE_OFC2756_FE_OFN1124_IxIy_shift_7 INV1S $PINS
+ O=FE_OFN4191_FE_OFN1124_IxIy_shift_7 I=FE_OFN255_IxIy_shift_7
XFE_OFC2749_FE_OFN1323_IxIy_shift_10 INV1S $PINS
+ O=FE_OFN4184_FE_OFN1323_IxIy_shift_10 I=FE_OFN214_IxIy_shift_10
XFE_OFC2748_FE_OFN1323_IxIy_shift_10 INV1S $PINS
+ O=FE_OFN4183_FE_OFN1323_IxIy_shift_10 I=FE_OFN214_IxIy_shift_10
XFE_OFC2332_n1652 BUF1 $PINS O=FE_OFN1706_n1652 I=FE_DBTN164_n1652
XFE_OFC2331_n1652 BUF1 $PINS O=FE_OFN277_FE_DBTN164_n1652 I=FE_DBTN164_n1652
XFE_OFC2330_n1652 INV1S $PINS O=FE_OFN276_FE_DBTN164_n1652 I=FE_DBTN164_n1652
XFE_OFC2329_n1652 INV1S $PINS O=FE_DBTN164_n1652 I=B[6]
XFE_OFC2256_n1650 BUF1 $PINS O=FE_OFN1681_n1650 I=FE_OFN1680_n1650
XFE_OFC2255_n1650 BUF1 $PINS O=FE_OFN1680_n1650 I=FE_OFN1210_n1650
XFE_OFC2254_n1650 INV1S $PINS O=FE_OFN1679_n1650 I=FE_OFN1210_n1650
XFE_OFC2251_n1650 INV1S $PINS O=FE_OFN1211_n1650 I=FE_OFN1210_n1650
XFE_OFC2250_n1650 INV1S $PINS O=FE_OFN1210_n1650 I=B[2]
XFE_OFC2138_IxIy_shift_14 BUF1 $PINS O=FE_RN_1 I=FE_OFN146_IxIy_shift_14
XFE_OFC2137_IxIy_shift_14 INV1S $PINS O=n163 I=FE_OFN146_IxIy_shift_14
XFE_OFC2116_IxIy_shift_3 BUF1 $PINS O=FE_OFN1532_n168 I=FE_OFN221_IxIy_shift_3
XFE_OFC1996_IxIy_shift_0 INV1S $PINS O=FE_OFN1622_IxIy_shift_0
+ I=FE_OFN129_IxIy_shift_0
XFE_OFC1991_IxIy_shift_0 INV1S $PINS O=FE_OFN1621_IxIy_shift_0
+ I=FE_OFN128_IxIy_shift_0
XFE_OFC1990_IxIy_shift_0 INV1S $PINS O=FE_OFN1620_IxIy_shift_0
+ I=FE_OFN128_IxIy_shift_0
XFE_OFC1989_IxIy_shift_0 INV1S $PINS O=FE_OFN1619_IxIy_shift_0
+ I=FE_OFN128_IxIy_shift_0
XFE_OFC1977_IxIy_shift_12 INV1S $PINS O=FE_OFN1614_IxIy_shift_12
+ I=FE_OFN979_IxIy_shift_12
XFE_OFC1973_IxIy_shift_12 INV1S $PINS O=n215 I=A[12]
XFE_OFC1972_IxIy_shift_12 INV1S $PINS O=FE_OFN979_IxIy_shift_12 I=A[12]
XFE_OFC1970_IxIy_shift_12 INV1S $PINS O=FE_OFN1612_IxIy_shift_12 I=A[12]
XFE_OFC1852_IxIy_shift_13 BUF1 $PINS O=FE_OFN1101_IxIy_shift_13
+ I=FE_OFN162_IxIy_shift_13
XFE_OFC1814_IxIy_shift_1 INV1S $PINS O=FE_OFN1577_IxIy_shift_1
+ I=FE_OFN253_IxIy_shift_1
XFE_OFC1808_IxIy_shift_1 BUF1 $PINS O=FE_OFN850_IxIy_shift_1 I=B[1]
XFE_OFC1806_IxIy_shift_1 INV1S $PINS O=n43 I=B[1]
XFE_OFC1753_n2620 INV1S $PINS O=FE_OFN1573_n2620 I=FE_OFN4318_n
XFE_OFC1748_n2620 INV1S $PINS O=FE_OFN1059_n2620 I=A[15]
XFE_OFC1729_IxIy_shift_8 INV1S $PINS O=n303 I=FE_OFN1108_IxIy_shift_8
XFE_OFC1721_IxIy_shift_8 BUF1 $PINS O=FE_OFN1108_IxIy_shift_8 I=A[8]
XFE_OFC1660_IxIy_shift_10 INV1S $PINS O=FE_OFN1563_IxIy_shift_10
+ I=FE_OFN4184_FE_OFN1323_IxIy_shift_10
XFE_OFC1659_IxIy_shift_10 INV1S $PINS O=FE_OFN1562_IxIy_shift_10
+ I=FE_OFN4183_FE_OFN1323_IxIy_shift_10
XFE_OFC1624_n3310 INV1S $PINS O=FE_DBTN153_n3310 I=A[9]
XFE_OFC1583_n2891 INV1S $PINS O=FE_OFN1551_n2891 I=FE_OFN179_n2891
XFE_OFC1582_n2891 INV1S $PINS O=FE_OFN1402_FE_DBTN158_n2891 I=FE_OFN179_n2891
XFE_OFC1576_n2891 INV1S $PINS O=FE_OFN1219_n2891 I=A[11]
XFE_OFC1548_n259 BUF1 $PINS O=FE_OFN1550_n259 I=n259
XFE_OFC1547_n290 BUF1 $PINS O=FE_OFN1549_n290 I=n290
XFE_OFC1506_FE_DBTN10_IxIy_shift_4 INV1S $PINS
+ O=FE_OFN1508_FE_DBTN10_IxIy_shift_4 I=B[4]
XFE_OFC1493_FE_DBTN30_IxIy_shift_5 INV1S $PINS
+ O=FE_OFN1495_FE_DBTN30_IxIy_shift_5 I=FE_OFN244_FE_DBTN30_IxIy_shift_5
XFE_OFC1401_FE_DBTN158_n2891 BUF1 $PINS O=FE_OFN1403_FE_DBTN158_n2891
+ I=FE_OFN4254_FE_OFN1402_FE_DBTN158_n2891
XFE_OFC1210_n1650 INV1S $PINS O=FE_OFN1212_n1650 I=FE_OFN1210_n1650
XFE_OFC1175_FE_DBTN85_n239 BUF1 $PINS O=FE_OFN1177_FE_DBTN85_n239
+ I=FE_DBTN85_n239
XFE_OFC1060_n2620 BUF1 $PINS O=FE_OFN1062_n2620 I=FE_OFN4337_n
XFE_OFC248_i_reset_n_i BUF1 $PINS O=FE_OFN250_i_reset_n_i
+ I=FE_OFN215_i_reset_n_i
XFE_OFC247_i_reset_n_i BUF1 $PINS O=FE_OFN249_i_reset_n_i
+ I=FE_OFN215_i_reset_n_i
XFE_OFC246_i_reset_n_i BUF1 $PINS O=FE_OFN248_i_reset_n_i
+ I=FE_OFN213_i_reset_n_i
XFE_OFC245_i_reset_n_i BUF1 $PINS O=FE_OFN247_i_reset_n_i
+ I=FE_OFN213_i_reset_n_i
XFE_OFC244_i_reset_n_i BUF1 $PINS O=FE_OFN246_i_reset_n_i
+ I=FE_OFN213_i_reset_n_i
XFE_OFC213_i_reset_n_i BUF1 $PINS O=FE_OFN215_i_reset_n_i
+ I=FE_OFN81_i_reset_n_i
XFE_OFC211_i_reset_n_i BUF1 $PINS O=FE_OFN213_i_reset_n_i
+ I=FE_OFN167_i_reset_n_i
XFE_OFC165_i_reset_n_i BUF1 $PINS O=FE_OFN167_i_reset_n_i
+ I=FE_OFN53_i_reset_n_i
XFE_DBTC85_n239 INV1S $PINS O=FE_DBTN85_n239 I=n239
Xs1_P0_reg[15] QDFFRBN $PINS Q=s1_P0[15] D=N16 CK=clk RB=FE_OFN249_i_reset_n_i
Xs1_P0_reg[14] QDFFRBN $PINS Q=s1_P0[14] D=N15 CK=clk RB=FE_OFN215_i_reset_n_i
Xs1_P0_reg[13] QDFFRBN $PINS Q=s1_P0[13] D=N14 CK=clk RB=FE_OFN250_i_reset_n_i
Xs1_P0_reg[12] QDFFRBN $PINS Q=s1_P0[12] D=N13 CK=clk RB=FE_OFN250_i_reset_n_i
Xs1_P0_reg[11] QDFFRBN $PINS Q=s1_P0[11] D=N12 CK=clk RB=FE_OFN109_i_reset_n_i
Xs1_P0_reg[10] QDFFRBN $PINS Q=s1_P0[10] D=N11 CK=clk RB=FE_OFN250_i_reset_n_i
Xs1_P0_reg[9] QDFFRBN $PINS Q=s1_P0[9] D=N10 CK=clk RB=FE_OFN250_i_reset_n_i
Xs1_P0_reg[8] QDFFRBN $PINS Q=s1_P0[8] D=N9 CK=clk RB=FE_OFN109_i_reset_n_i
Xs1_P0_reg[7] QDFFRBN $PINS Q=N75 D=N8 CK=clk_clone3 RB=FE_OFN17_i_reset_n_i
Xs1_P0_reg[6] QDFFRBN $PINS Q=N74 D=N7 CK=clk_clone1 RB=FE_OFN13_i_reset_n_i
Xs1_P0_reg[4] QDFFRBN $PINS Q=N72 D=N5 CK=clk_clone1 RB=FE_OFN13_i_reset_n_i
Xs1_P0_reg[3] QDFFRBN $PINS Q=N71 D=N4 CK=clk_clone3 RB=FE_OFN19_i_reset_n_i
Xs1_P0_reg[2] QDFFRBN $PINS Q=N70 D=N3 CK=clk_clone1 RB=FE_OFN13_i_reset_n_i
Xs1_P0_reg[0] QDFFRBN $PINS Q=N68 D=B[0] CK=clk_clone1 RB=FE_OFN109_i_reset_n_i
Xs1_P1_reg[15] QDFFRBN $PINS Q=s1_P1[15] D=N33 CK=clk RB=FE_OFN213_i_reset_n_i
Xs1_P1_reg[14] QDFFRBN $PINS Q=s1_P1[14] D=N32 CK=clk RB=FE_OFN247_i_reset_n_i
Xs1_P1_reg[13] QDFFRBN $PINS Q=s1_P1[13] D=N31 CK=clk RB=FE_OFN247_i_reset_n_i
Xs1_P1_reg[12] QDFFRBN $PINS Q=s1_P1[12] D=N30 CK=clk RB=FE_OFN246_i_reset_n_i
Xs1_P1_reg[11] QDFFRBN $PINS Q=s1_P1[11] D=N29 CK=clk RB=FE_OFN246_i_reset_n_i
Xs1_P1_reg[10] QDFFRBN $PINS Q=s1_P1[10] D=N28 CK=clk RB=FE_OFN246_i_reset_n_i
Xs1_P1_reg[9] QDFFRBN $PINS Q=intadd_63/A[10] D=N27 CK=clk
+ RB=FE_OFN78_i_reset_n_i
Xs1_P1_reg[8] QDFFRBN $PINS Q=s1_P1[8] D=N26 CK=clk RB=FE_OFN78_i_reset_n_i
Xs1_P1_reg[7] QDFFRBN $PINS Q=s1_P1[7] D=N25 CK=clk RB=FE_OFN78_i_reset_n_i
Xs1_P1_reg[6] QDFFRBN $PINS Q=s1_P1[6] D=N24 CK=clk RB=FE_OFN81_i_reset_n_i
Xs1_P1_reg[4] QDFFRBN $PINS Q=s1_P1[4] D=N22 CK=clk RB=FE_OFN215_i_reset_n_i
Xs1_P1_reg[3] QDFFRBN $PINS Q=s1_P1[3] D=N21 CK=clk RB=FE_OFN215_i_reset_n_i
Xs1_P1_reg[2] QDFFRBN $PINS Q=s1_P1[2] D=N20 CK=clk RB=FE_OFN109_i_reset_n_i
Xs1_P1_reg[1] QDFFRBN $PINS Q=s1_P1[1] D=N19 CK=clk RB=FE_OFN250_i_reset_n_i
Xs1_P1_reg[0] QDFFRBN $PINS Q=intadd_63/n23 D=N18 CK=clk
+ RB=FE_OFN250_i_reset_n_i
Xs1_P2_reg[10] QDFFRBN $PINS Q=s1_P2[10] D=N45 CK=clk RB=FE_OFN246_i_reset_n_i
Xs1_P3_reg[14] QDFFRBN $PINS Q=s1_P3[14] D=N66 CK=clk RB=FE_OFN213_i_reset_n_i
Xs1_P3_reg[13] QDFFRBN $PINS Q=s1_P3[13] D=N65 CK=clk RB=FE_OFN248_i_reset_n_i
Xs1_P3_reg[12] QDFFRBN $PINS Q=s1_P3[12] D=N64 CK=clk RB=FE_OFN248_i_reset_n_i
Xs1_P3_reg[11] QDFFRBN $PINS Q=s1_P3[11] D=N63 CK=clk RB=FE_OFN248_i_reset_n_i
Xs1_P3_reg[10] QDFFRBN $PINS Q=s1_P3[10] D=N62 CK=clk RB=FE_OFN248_i_reset_n_i
Xs1_P3_reg[9] QDFFRBN $PINS Q=s1_P3[9] D=N61 CK=clk RB=FE_OFN248_i_reset_n_i
Xs1_P3_reg[8] QDFFRBN $PINS Q=intadd_63/B[16] D=N60 CK=clk
+ RB=FE_OFN248_i_reset_n_i
Xs1_P3_reg[7] QDFFRBN $PINS Q=intadd_63/B[15] D=N59 CK=clk
+ RB=FE_OFN247_i_reset_n_i
Xs1_P3_reg[5] QDFFRBN $PINS Q=s1_P3[5] D=N57 CK=clk RB=FE_OFN213_i_reset_n_i
Xs1_P3_reg[4] QDFFRBN $PINS Q=s1_P3[4] D=N56 CK=clk RB=FE_OFN167_i_reset_n_i
Xs1_P3_reg[3] QDFFRBN $PINS Q=s1_P3[3] D=N55 CK=clk RB=FE_OFN53_i_reset_n_i
Xs1_P3_reg[2] QDFFRBN $PINS Q=s1_P3[2] D=N54 CK=clk RB=FE_OFN246_i_reset_n_i
Xs1_P3_reg[0] QDFFRBN $PINS Q=s1_P3[0] D=FE_OFN1108_IxIy_shift_8 CK=clk
+ RB=FE_OFN249_i_reset_n_i
Xs2_result_reg[31] QDFFRBN $PINS Q=result[31] D=N99 CK=clk
+ RB=FE_OFN30_i_reset_n_i
Xs2_result_reg[30] QDFFRBN $PINS Q=result[30] D=N98 CK=clk
+ RB=FE_OFN10_i_reset_n_i
Xs2_result_reg[29] QDFFRBN $PINS Q=result[29] D=N97 CK=clk
+ RB=FE_OFN10_i_reset_n_i
Xs2_result_reg[28] QDFFRBN $PINS Q=result[28] D=FE_PHN3277_N96 CK=clk
+ RB=FE_OFN10_i_reset_n_i
Xs2_result_reg[27] QDFFRBN $PINS Q=result[27] D=N95 CK=clk RB=rst_n
Xs2_result_reg[26] QDFFRBN $PINS Q=result[26] D=N94 CK=clk
+ RB=FE_OFN10_i_reset_n_i
Xs2_result_reg[25] QDFFRBN $PINS Q=result[25] D=N93 CK=clk
+ RB=FE_OFN10_i_reset_n_i
Xs2_result_reg[24] QDFFRBN $PINS Q=result[24] D=N92 CK=clk
+ RB=FE_OFN30_i_reset_n_i
Xs2_result_reg[23] QDFFRBN $PINS Q=result[23] D=N91 CK=clk
+ RB=FE_OFN30_i_reset_n_i
Xs2_result_reg[21] QDFFRBN $PINS Q=result[21] D=N89 CK=clk
+ RB=FE_OFN53_i_reset_n_i
Xs2_result_reg[20] QDFFRBN $PINS Q=result[20] D=N88 CK=clk_clone2
+ RB=FE_OFN77_i_reset_n_i
Xs2_result_reg[19] QDFFRBN $PINS Q=result[19] D=N87 CK=clk_clone2
+ RB=FE_OFN94_i_reset_n_i
Xs2_result_reg[18] QDFFRBN $PINS Q=result[18] D=N86 CK=clk_clone2
+ RB=FE_OFN94_i_reset_n_i
Xs2_result_reg[17] QDFFRBN $PINS Q=result[17] D=FE_PHN3157_N85 CK=clk_clone2
+ RB=FE_OFN56_i_reset_n_i
Xs2_result_reg[16] QDFFRBN $PINS Q=result[16] D=N84 CK=clk_clone2
+ RB=FE_OFN56_i_reset_n_i
Xs2_result_reg[15] QDFFRBN $PINS Q=result[15] D=N83 CK=clk_clone1
+ RB=FE_OFN31_i_reset_n_i
Xs2_result_reg[14] QDFFRBN $PINS Q=result[14] D=N82 CK=clk_clone2
+ RB=FE_OFN56_i_reset_n_i
Xs2_result_reg[13] QDFFRBN $PINS Q=result[13] D=N81 CK=clk_clone1
+ RB=FE_OFN11_i_reset_n_i
Xs2_result_reg[12] QDFFRBN $PINS Q=result[12] D=FE_PHN3281_N80 CK=clk_clone1
+ RB=FE_OFN31_i_reset_n_i
Xs2_result_reg[11] QDFFRBN $PINS Q=result[11] D=N79 CK=clk_clone1
+ RB=FE_OFN11_i_reset_n_i
Xs2_result_reg[10] QDFFRBN $PINS Q=result[10] D=N78 CK=clk_clone1
+ RB=FE_OFN11_i_reset_n_i
Xs2_result_reg[9] QDFFRBN $PINS Q=result[9] D=N77 CK=clk_clone1
+ RB=FE_OFN13_i_reset_n_i
Xs2_result_reg[7] QDFFRBN $PINS Q=result[7] D=FE_PHN2976_N75 CK=clk_clone3
+ RB=FE_OFN4_i_reset_n_i
Xs2_result_reg[5] QDFFRBN $PINS Q=result[5] D=FE_PHN3084_N73 CK=clk_clone3
+ RB=FE_OFN35_i_reset_n_i
Xs2_result_reg[4] QDFFRBN $PINS Q=result[4] D=FE_PHN3094_N72 CK=clk_clone3
+ RB=FE_OFN17_i_reset_n_i
Xs2_result_reg[3] QDFFRBN $PINS Q=result[3] D=FE_PHN3108_N71 CK=clk_clone4
+ RB=FE_OFN58_i_reset_n_i
Xs2_result_reg[2] QDFFRBN $PINS Q=result[2] D=FE_PHN3008_N70 CK=clk_clone3
+ RB=FE_OFN17_i_reset_n_i
Xintadd_64/U9 FA1S $PINS S=intadd_64/SUM[0] CO=intadd_64/n8 A=intadd_64/B[0]
+ B=intadd_64/A[0] CI=intadd_64/CI
Xintadd_64/U8 FA1 $PINS S=N58 CO=intadd_64/n7 A=intadd_64/SUM[0]
+ B=intadd_64/A[1] CI=intadd_64/n8
Xintadd_64/U7 FA1 $PINS S=N59 CO=intadd_64/n6 A=intadd_64/B[2] B=intadd_64/A[2]
+ CI=intadd_64/n7
Xintadd_64/U6 FA1 $PINS S=N60 CO=intadd_64/n5 A=intadd_64/B[3] B=intadd_64/A[3]
+ CI=intadd_64/n6
Xintadd_64/U5 FA1S $PINS S=N61 CO=intadd_64/n4 A=intadd_64/B[4]
+ B=intadd_64/A[4] CI=intadd_64/n5
Xintadd_64/U4 FA1S $PINS S=N62 CO=intadd_64/n3 A=intadd_64/B[5]
+ B=intadd_64/A[5] CI=intadd_64/n4
Xintadd_64/U3 FA1S $PINS S=N63 CO=intadd_64/n2 A=intadd_64/B[6]
+ B=intadd_64/A[6] CI=intadd_64/n3
Xintadd_64/U2 FA1S $PINS S=N64 CO=intadd_64/n1 A=intadd_64/B[7]
+ B=intadd_64/A[7] CI=intadd_64/n2
Xintadd_67/U9 FA1S $PINS S=intadd_67/SUM[0] CO=intadd_67/n8 A=intadd_67/B[0]
+ B=intadd_67/A[0] CI=intadd_67/CI
Xintadd_67/U8 FA1S $PINS S=intadd_67/SUM[1] CO=intadd_67/n7 A=intadd_67/B[1]
+ B=intadd_67/A[1] CI=intadd_67/n8
Xintadd_67/U7 FA1S $PINS S=N9 CO=intadd_67/n6 A=intadd_67/B[2] B=intadd_67/A[2]
+ CI=intadd_67/n7
Xintadd_67/U6 FA1S $PINS S=N10 CO=intadd_67/n5 A=intadd_70/n1 B=intadd_67/A[3]
+ CI=intadd_67/n6
Xintadd_67/U5 FA1S $PINS S=N11 CO=intadd_67/n4 A=intadd_67/B[4]
+ B=intadd_67/A[4] CI=intadd_67/n5
Xintadd_67/U4 FA1S $PINS S=N12 CO=intadd_67/n3 A=intadd_67/B[5]
+ B=intadd_67/A[5] CI=intadd_67/n4
Xintadd_67/U3 FA1S $PINS S=N13 CO=intadd_67/n2 A=intadd_67/B[6]
+ B=intadd_67/A[6] CI=intadd_67/n3
Xintadd_67/U2 FA1S $PINS S=N14 CO=intadd_67/n1 A=intadd_67/B[7]
+ B=intadd_67/A[7] CI=intadd_67/n2
Xintadd_68/U5 FA1S $PINS S=intadd_68/SUM[0] CO=intadd_68/n4 A=intadd_68/B[0]
+ B=intadd_68/A[0] CI=intadd_68/CI
Xintadd_68/U4 FA1S $PINS S=intadd_68/SUM[1] CO=intadd_68/n3 A=intadd_68/B[1]
+ B=intadd_68/A[1] CI=intadd_68/n4
Xintadd_68/U3 FA1S $PINS S=intadd_68/SUM[2] CO=intadd_68/n2 A=intadd_68/B[2]
+ B=intadd_68/A[2] CI=intadd_68/n3
Xintadd_68/U2 FA1S $PINS S=intadd_68/SUM[3] CO=intadd_68/n1 A=intadd_68/B[3]
+ B=intadd_68/A[3] CI=intadd_68/n2
Xintadd_69/U5 FA1S $PINS S=intadd_69/SUM[0] CO=intadd_69/n4 A=intadd_69/B[0]
+ B=intadd_69/A[0] CI=intadd_69/CI
Xintadd_69/U4 FA1S $PINS S=intadd_69/SUM[1] CO=intadd_69/n3 A=intadd_69/B[1]
+ B=intadd_69/A[1] CI=intadd_69/n4
Xintadd_69/U3 FA1S $PINS S=intadd_69/SUM[2] CO=intadd_69/n2 A=intadd_68/SUM[0]
+ B=intadd_69/A[2] CI=intadd_69/n3
Xintadd_69/U2 FA1S $PINS S=intadd_69/SUM[3] CO=intadd_69/n1 A=intadd_68/SUM[1]
+ B=intadd_69/A[3] CI=intadd_69/n2
Xintadd_70/U4 FA1S $PINS S=intadd_70/SUM[0] CO=intadd_70/n3 A=intadd_70/B[0]
+ B=B[3] CI=intadd_70/CI
Xintadd_70/U3 FA1S $PINS S=intadd_67/A[1] CO=intadd_70/n2 A=intadd_70/B[1]
+ B=intadd_70/A[1] CI=intadd_70/n3
Xintadd_70/U2 FA1S $PINS S=intadd_67/A[2] CO=intadd_70/n1 A=intadd_70/B[2]
+ B=intadd_70/A[2] CI=intadd_70/n2
Xintadd_71/U4 FA1S $PINS S=intadd_71/SUM[0] CO=intadd_71/n3 A=intadd_71/B[0]
+ B=intadd_71/A[0] CI=intadd_71/CI
Xintadd_71/U3 FA1S $PINS S=intadd_71/SUM[1] CO=intadd_71/n2 A=intadd_71/B[1]
+ B=intadd_71/A[1] CI=intadd_71/n3
Xintadd_71/U2 FA1S $PINS S=intadd_71/SUM[2] CO=intadd_71/n1 A=intadd_71/B[2]
+ B=intadd_69/SUM[2] CI=intadd_71/n2
Xintadd_72/U4 FA1S $PINS S=intadd_72/SUM[0] CO=intadd_72/n3 A=intadd_72/B[0]
+ B=intadd_72/A[0] CI=intadd_72/CI
Xintadd_72/U3 FA1S $PINS S=intadd_72/SUM[1] CO=intadd_72/n2 A=intadd_72/B[1]
+ B=intadd_69/SUM[0] CI=intadd_72/n3
Xintadd_72/U2 FA1S $PINS S=intadd_72/SUM[2] CO=intadd_72/n1 A=intadd_69/SUM[1]
+ B=intadd_71/SUM[1] CI=intadd_72/n2
Xintadd_73/U4 FA1S $PINS S=intadd_68/A[2] CO=intadd_73/n3 A=intadd_73/B[0]
+ B=intadd_73/A[0] CI=intadd_73/CI
Xintadd_73/U3 FA1S $PINS S=intadd_68/A[3] CO=intadd_73/n2 A=intadd_73/B[1]
+ B=intadd_73/A[1] CI=intadd_73/n3
Xintadd_73/U2 FA1S $PINS S=intadd_73/SUM[2] CO=intadd_73/n1 A=intadd_73/B[2]
+ B=intadd_73/A[2] CI=intadd_73/n2
Xintadd_63/U6 FA1 $PINS S=N94 CO=intadd_63/n5 A=intadd_63/B[18] B=s1_P3[9]
+ CI=intadd_63/n6
Xintadd_63/U5 FA1 $PINS S=N95 CO=intadd_63/n4 A=intadd_63/B[19] B=s1_P3[10]
+ CI=intadd_63/n5
Xintadd_63/U4 FA1S $PINS S=N96 CO=intadd_63/n3 A=intadd_63/B[20] B=s1_P3[11]
+ CI=intadd_63/n4
Xintadd_63/U3 FA1S $PINS S=N97 CO=intadd_63/n2 A=intadd_63/B[21] B=s1_P3[12]
+ CI=intadd_63/n3
Xintadd_63/U2 FA1S $PINS S=N98 CO=intadd_63/n1 A=s1_P3[13] B=intadd_63/A[22]
+ CI=intadd_63/n2
Xintadd_65/U9 FA1S $PINS S=intadd_71/B[1] CO=intadd_65/n8 A=intadd_65/B[0]
+ B=intadd_65/A[0] CI=intadd_65/CI
Xintadd_65/U8 FA1S $PINS S=intadd_71/B[2] CO=intadd_65/n7 A=intadd_65/B[1]
+ B=intadd_65/A[1] CI=intadd_65/n8
Xintadd_65/U7 FA1S $PINS S=intadd_69/A[3] CO=intadd_65/n6 A=intadd_65/B[2]
+ B=intadd_65/A[2] CI=intadd_65/n7
Xintadd_65/U6 FA1S $PINS S=intadd_65/SUM[3] CO=intadd_65/n5 A=intadd_65/B[3]
+ B=intadd_68/SUM[2] CI=intadd_65/n6
Xintadd_65/U4 FA1 $PINS S=N30 CO=intadd_65/n3 A=intadd_73/SUM[2] B=intadd_68/n1
+ CI=intadd_65/n4
Xintadd_65/U3 FA1S $PINS S=N31 CO=intadd_65/n2 A=intadd_65/B[6] B=intadd_73/n1
+ CI=intadd_65/n3
Xintadd_66/U9 FA1S $PINS S=N20 CO=intadd_66/n8 A=intadd_66/B[0]
+ B=intadd_66/A[0] CI=intadd_66/CI
Xintadd_66/U8 FA1 $PINS S=N21 CO=intadd_66/n7 A=intadd_66/B[1] B=intadd_66/A[1]
+ CI=intadd_66/n8
Xintadd_66/U7 FA1 $PINS S=N22 CO=intadd_66/n6 A=intadd_66/B[2] B=intadd_66/A[2]
+ CI=intadd_66/n7
Xintadd_66/U6 FA1S $PINS S=N23 CO=intadd_66/n5 A=intadd_66/B[3]
+ B=intadd_66/A[3] CI=intadd_66/n6
Xintadd_66/U5 FA1 $PINS S=N24 CO=intadd_66/n4 A=intadd_66/B[4] B=intadd_66/A[4]
+ CI=intadd_66/n5
Xintadd_66/U4 FA1 $PINS S=N25 CO=intadd_66/n3 A=intadd_72/SUM[2]
+ B=intadd_66/A[5] CI=intadd_66/n4
Xintadd_66/U3 FA1 $PINS S=N26 CO=intadd_66/n2 A=intadd_71/SUM[2] B=intadd_72/n1
+ CI=intadd_66/n3
Xintadd_65/U2 FA1S $PINS S=N32 CO=intadd_65/n1 A=intadd_65/B[7]
+ B=intadd_65/A[7] CI=intadd_65/n2
Xintadd_63/U7 FA1 $PINS S=N93 CO=intadd_63/n6 A=n332 B=intadd_63/A[17]
+ CI=intadd_63/n7
Xintadd_63/U8 FA1 $PINS S=N92 CO=intadd_63/n7 A=intadd_63/B[16] B=s1_P1[15]
+ CI=intadd_63/n8
Xintadd_63/U12 FA1 $PINS S=N88 CO=intadd_63/n11 A=s1_P3[4] B=s1_P1[11]
+ CI=intadd_63/n12
Xintadd_63/U13 FA1 $PINS S=N87 CO=intadd_63/n12 A=s1_P3[3] B=intadd_63/A[11]
+ CI=intadd_63/n13
Xintadd_63/U14 FA1 $PINS S=N86 CO=intadd_63/n13 A=intadd_63/B[10]
+ B=intadd_63/A[10] CI=intadd_63/n14
Xintadd_63/U21 FA1S $PINS S=N79 CO=intadd_63/n20 A=s1_P0[11] B=s1_P1[2]
+ CI=intadd_63/n21
Xintadd_63/U22 FA1S $PINS S=N78 CO=intadd_63/n21 A=s1_P0[10] B=intadd_63/A[2]
+ CI=intadd_63/n22
Xintadd_63/U23 FA1S $PINS S=N77 CO=intadd_63/n22 A=intadd_63/B[1] B=s1_P1[1]
+ CI=intadd_63/n23
Xintadd_63/U17 FA1 $PINS S=N83 CO=intadd_63/n16 A=s1_P0[15] B=s1_P1[6]
+ CI=intadd_63/n17
Xintadd_63/U18 FA1 $PINS S=N82 CO=intadd_63/n17 A=s1_P0[14] B=s1_P1[5]
+ CI=intadd_63/n18
Xintadd_63/U19 FA1 $PINS S=N81 CO=intadd_63/n18 A=s1_P0[13] B=s1_P1[4]
+ CI=intadd_63/n19
Xintadd_63/U16 FA1 $PINS S=N84 CO=intadd_63/n15 A=s1_P3[0] B=s1_P1[7]
+ CI=intadd_63/n16
Xintadd_65/U5 FA1 $PINS S=N29 CO=intadd_65/n4 A=intadd_68/SUM[3]
+ B=intadd_65/A[4] CI=intadd_65/n5
Xintadd_66/U2 FA1 $PINS S=N27 CO=intadd_66/n1 A=intadd_69/SUM[3] B=intadd_71/n1
+ CI=intadd_66/n2
Xs2_result_reg[0] QDFFRBN $PINS Q=result[0] D=FE_PHN3135_N68 CK=clk_clone3
+ RB=FE_OFN36_i_reset_n_i
XU14 MOAI1S $PINS O=n239 A1=FE_OFN1101_IxIy_shift_13 A2=FE_RN_1
+ B1=FE_OFN1101_IxIy_shift_13 B2=FE_RN_1
XU15 MOAI1S $PINS O=n280 A1=n270 A2=n269 B1=n270 B2=n269
XU16 MOAI1S $PINS O=n251 A1=FE_OFN4183_FE_OFN1323_IxIy_shift_10
+ A2=FE_OFN4334_FE_DBTN153_n3310 B1=FE_OFN4183_FE_OFN1323_IxIy_shift_10
+ B2=FE_OFN4334_FE_DBTN153_n3310
XU17 OA112 $PINS O=N4 A1=FE_OFN1619_IxIy_shift_0 B1=n69 C1=FE_OFN1211_n1650
+ C2=FE_OFN125_IxIy_shift_1
XU18 ND2S $PINS O=n77 I1=n43 I2=A[8]
XU19 ND2S $PINS O=n282 I1=n284 I2=n283
XU20 ND2S $PINS O=intadd_67/B[6] I1=n73 I2=n72
XU21 ND2S $PINS O=n73 I1=n95 I2=n21
XU22 ND2S $PINS O=n261 I1=n270 I2=n269
XU23 ND2S $PINS O=n87 I1=intadd_70/SUM[0] I2=n62
XU24 ND2S $PINS O=n21 I1=n92 I2=n91
XU25 ND2S $PINS O=n228 I1=n290 I2=FE_OFN1177_FE_DBTN85_n239
XU26 ND2S $PINS O=n273 I1=FE_OFN4230_FE_OFN1108_IxIy_shift_8 I2=FE_DBTN85_n239
XU27 ND2S $PINS O=n241 I1=FE_OFN1062_n2620 I2=FE_DBTN85_n239
XU28 ND2S $PINS O=n53 I1=n52 I2=FE_OFN1679_n1650
XU29 ND2S $PINS O=n201 I1=FE_OFN162_IxIy_shift_13
+ I2=FE_OFN4191_FE_OFN1124_IxIy_shift_7
XU30 ND2S $PINS O=n82 I1=FE_OFN1577_IxIy_shift_1 I2=FE_OFN162_IxIy_shift_13
XU31 ND2S $PINS O=n72 I1=n71 I2=FE_OFN270_IxIy_shift_3
XU32 ND2S $PINS O=n33 I1=FE_OFN4247_FE_OFN1101_IxIy_shift_13 I2=FE_OFN1549_n290
XU33 ND2S $PINS O=n271 I1=FE_OFN1549_n290 I2=n251
XU35 ND2S $PINS O=n107 I1=intadd_70/B[0] I2=n130
XU36 ND2S $PINS O=n103 I1=n41 I2=n40
XU37 ND3 $PINS O=n144 I1=FE_OFN124_IxIy_shift_1
+ I2=FE_OFN4184_FE_OFN1323_IxIy_shift_10 I3=n138
XU38 ND2S $PINS O=n149 I1=FE_OFN124_IxIy_shift_1 I2=FE_OFN148_IxIy_shift_12
XU39 ND2S $PINS O=n150 I1=FE_OFN129_IxIy_shift_0 I2=FE_OFN148_IxIy_shift_12
XU40 ND2S $PINS O=n84 I1=FE_OFN1508_FE_DBTN10_IxIy_shift_4
+ I2=FE_OFN165_IxIy_shift_7
XU41 ND2S $PINS O=n176 I1=FE_OFN248_FE_DBTN10_IxIy_shift_4
+ I2=FE_OFN1612_IxIy_shift_12
XU42 ND2S $PINS O=n181 I1=FE_OFN147_IxIy_shift_12
+ I2=FE_OFN245_FE_DBTN30_IxIy_shift_5
XU43 ND2S $PINS O=n170 I1=FE_OFN223_IxIy_shift_3 I2=FE_OFN147_IxIy_shift_12
XU44 ND2S $PINS O=n80 I1=FE_OFN155_n3310 I2=FE_OFN265_FE_OFN1124_IxIy_shift_7
XU45 ND2S $PINS O=n79 I1=FE_OFN1679_n1650 I2=FE_OFN146_IxIy_shift_14
XU46 ND2S $PINS O=n40 I1=FE_OFN130_IxIy_shift_0 I2=FE_OFN165_IxIy_shift_7
XU47 ND2S $PINS O=n81 I1=FE_OFN129_IxIy_shift_0 I2=FE_OFN146_IxIy_shift_14
XU48 ND2S $PINS O=n23 I1=FE_OFN165_IxIy_shift_7 I2=FE_OFN277_FE_DBTN164_n1652
XU49 ND2S $PINS O=n134 I1=FE_OFN276_FE_DBTN164_n1652 I2=FE_OFN165_IxIy_shift_7
XU51 ND2S $PINS O=n130 I1=n39 I2=n38
XU52 ND2S $PINS O=n48 I1=FE_OFN1621_IxIy_shift_0 I2=B[3]
XU53 ND2S $PINS O=intadd_65/B[7] I1=FE_OFN4338_n
+ I2=FE_OFN4191_FE_OFN1124_IxIy_shift_7
XU54 ND2S $PINS O=n207 I1=FE_OFN4257_FE_RN_1
+ I2=FE_OFN4191_FE_OFN1124_IxIy_shift_7
XU55 ND2S $PINS O=n200 I1=FE_OFN146_IxIy_shift_14 I2=FE_OFN276_FE_DBTN164_n1652
XU56 ND2S $PINS O=n19 I1=FE_OFN270_IxIy_shift_3 I2=FE_OFN165_IxIy_shift_7
XU57 ND2S $PINS O=n45 I1=FE_OFN123_IxIy_shift_1 I2=B[3]
XU58 ND2S $PINS O=n69 I1=FE_OFN125_IxIy_shift_1 I2=FE_OFN1211_n1650
XU59 ND2S $PINS O=n44 I1=FE_OFN131_IxIy_shift_0
+ I2=FE_OFN1508_FE_DBTN10_IxIy_shift_4
XU60 ND2S $PINS O=n190 I1=FE_OFN223_IxIy_shift_3 I2=A[15]
XU61 ND2S $PINS O=n126 I1=FE_OFN270_IxIy_shift_3
+ I2=FE_OFN1508_FE_DBTN10_IxIy_shift_4
XU62 ND2S $PINS O=n78 I1=FE_OFN1620_IxIy_shift_0 I2=A[9]
XU63 ND2S $PINS O=n42 I1=FE_OFN124_IxIy_shift_1
+ I2=FE_OFN4184_FE_OFN1323_IxIy_shift_10
XU65 ND2S $PINS O=n35 I1=FE_OFN270_IxIy_shift_3 I2=A[8]
XU66 ND2S $PINS O=n151 I1=FE_OFN124_IxIy_shift_1 I2=FE_OFN179_n2891
XU67 ND3 $PINS O=n46 I1=FE_OFN123_IxIy_shift_1 I2=FE_OFN1679_n1650
+ I3=FE_OFN129_IxIy_shift_0
XU68 ND2S $PINS O=n169 I1=FE_OFN248_FE_DBTN10_IxIy_shift_4 I2=FE_OFN179_n2891
XU69 ND2S $PINS O=n142 I1=n43 I2=A[9]
XU71 ND2S $PINS O=n123 I1=FE_OFN131_IxIy_shift_0 I2=B[5]
XU72 ND2S $PINS O=n39 I1=FE_OFN130_IxIy_shift_0 I2=B[6]
XU74 ND2S $PINS O=n92 I1=FE_OFN248_FE_DBTN10_IxIy_shift_4
+ I2=FE_OFN245_FE_DBTN30_IxIy_shift_5
XU75 ND2S $PINS O=intadd_73/B[1] I1=FE_OFN249_FE_DBTN10_IxIy_shift_4
+ I2=FE_OFN1573_n2620
XU77 ND2S $PINS O=n180 I1=FE_OFN179_n2891 I2=FE_OFN276_FE_DBTN164_n1652
XU99 OAI12HS $PINS O=n125 A1=n103 B1=intadd_70/A[1] B2=n105
XU100 OAI12HS $PINS O=n61 A1=n122 B1=n123 B2=n59
XU101 MOAI1S $PINS O=n93 A1=n92 A2=n91 B1=n92 B2=n91
XU102 MOAI1S $PINS O=n98 A1=n95 A2=n93 B1=n95 B2=n93
XU104 FA1 $PINS S=N45 CO=intadd_65/A[4] A=intadd_66/n1 B=intadd_69/n1
+ CI=intadd_65/SUM[3]
XU108 NR2 $PINS O=n95 I1=FE_OFN217_IxIy_shift_4 I2=FE_DBTN164_n1652
XU110 NR2 $PINS O=n94 I1=FE_OFN1681_n1650 I2=FE_OFN164_IxIy_shift_7
XU113 MOAI1S $PINS O=n22 A1=n71 A2=n19 B1=n71 B2=n19
XU115 ND2 $PINS O=n41 I1=FE_OFN126_IxIy_shift_1 I2=B[6]
XU118 NR2 $PINS O=n105 I1=n41 I2=n40
XU119 NR2 $PINS O=n110 I1=FE_OFN221_IxIy_shift_3 I2=IxIy_shift_5
XU120 NR2 $PINS O=n104 I1=FE_OFN1680_n1650 I2=FE_DBTN164_n1652
XU121 NR2 $PINS O=n109 I1=FE_OFN850_IxIy_shift_1 I2=FE_OFN164_IxIy_shift_7
XU122 AN2 $PINS O=n100 I1=n104 I2=n109
XU123 INV1S $PINS O=n91 I=n20
XU124 MOAI1S $PINS O=intadd_67/A[5] A1=n22 A2=n73 B1=n22 B2=n73
XU125 MOAI1 $PINS O=N15 A1=intadd_67/n1 A2=n23 B1=intadd_67/n1 B2=n23
XU132 MOAI1S $PINS O=n263 A1=FE_OFN4247_FE_OFN1101_IxIy_shift_13
+ A2=FE_OFN979_IxIy_shift_12 B1=FE_OFN4247_FE_OFN1101_IxIy_shift_13
+ B2=FE_OFN979_IxIy_shift_12
XU133 NR2 $PINS O=n259 I1=FE_OFN1549_n290 I2=n263
XU140 NR2 $PINS O=n255 I1=FE_OFN1177_FE_DBTN85_n239 I2=n212
XU141 INV1S $PINS O=n227 I=n255
XU142 NR2 $PINS O=n74 I1=FE_OFN1550_n259 I2=n227
XU143 NR2 $PINS O=n24 I1=n74 I2=n212
XU144 MOAI1S $PINS O=N65 A1=intadd_64/n1 A2=n24 B1=intadd_64/n1 B2=n24
XU146 NR2 $PINS O=n25 I1=FE_OFN1495_FE_DBTN30_IxIy_shift_5
+ I2=FE_OFN277_FE_DBTN164_n1652
XU148 MOAI1S $PINS O=intadd_67/A[6] A1=n25 A2=n84 B1=n25 B2=n84
XU152 NR2 $PINS O=N54 I1=FE_OFN1108_IxIy_shift_8 I2=FE_OFN4334_FE_DBTN153_n3310
XU153 MOAI1S $PINS O=n258 A1=FE_OFN264_FE_OFN1323_IxIy_shift_10
+ A2=FE_OFN4218_FE_OFN1583_IxIy_shift_13 B1=FE_OFN264_FE_OFN1323_IxIy_shift_10
+ B2=FE_OFN4218_FE_OFN1583_IxIy_shift_13
XU154 MOAI1S $PINS O=n289 A1=FE_OFN4217_FE_OFN1583_IxIy_shift_13
+ A2=FE_OFN4305_n B1=FE_OFN4217_FE_OFN1583_IxIy_shift_13 B2=FE_OFN4305_n
XU155 AOI22S $PINS O=n30 A1=FE_OFN1549_n290 A2=n258 B1=n259 B2=n289
XU158 MOAI1S $PINS O=n27 A1=FE_RN_1 A2=FE_DBTN153_n3310 B1=FE_RN_1
+ B2=FE_DBTN153_n3310
XU159 AOI22S $PINS O=n272 A1=n27 A2=FE_OFN4231_FE_OFN1108_IxIy_shift_8 B1=N54
+ B2=FE_OFN4217_FE_OFN1583_IxIy_shift_13
XU161 NR2 $PINS O=intadd_64/B[2] I1=n30 I2=n31
XU162 OAI22S $PINS O=n34 A1=n31 A2=intadd_64/B[2] B1=n30 B2=intadd_64/B[2]
XU164 MOAI1S $PINS O=n284 A1=n33 A2=FE_OFN4230_FE_OFN1108_IxIy_shift_8
+ B1=FE_OFN4247_FE_OFN1101_IxIy_shift_13 B2=n259
XU165 INV1S $PINS O=n242 I=N54
XU168 MOAI1S $PINS O=n283 A1=n242 A2=FE_OFN979_IxIy_shift_12 B1=n289
+ B2=FE_OFN4231_FE_OFN1108_IxIy_shift_8
XU169 OR2B1S $PINS O=intadd_64/A[1] I1=n34 B1=n282
XU170 NR2 $PINS O=n137 I1=FE_OFN1681_n1650 I2=FE_OFN4333_FE_DBTN153_n3310
XU171 MOAI1S $PINS O=n36 A1=n137 A2=n35 B1=n137 B2=n35
XU174 NR2 $PINS O=n143 I1=FE_OFN1681_n1650 I2=n303
XU175 ND3 $PINS O=n135 I1=FE_OFN124_IxIy_shift_1 I2=A[9] I3=n143
XU176 MOAI1S $PINS O=intadd_66/B[1] A1=n36 A2=n135 B1=n36 B2=n135
XU192 NR2 $PINS O=intadd_70/B[0] I1=FE_OFN1680_n1650 I2=FE_OFN217_IxIy_shift_4
XU194 ND2 $PINS O=n38 I1=FE_OFN126_IxIy_shift_1 I2=B[5]
XU195 NR2 $PINS O=n129 I1=n39 I2=n38
XU196 NR2 $PINS O=n132 I1=n129 I2=n107
XU197 OR2B1S $PINS O=n121 I1=n105 B1=n103
XU198 MOAI1S $PINS O=intadd_67/B[1] A1=n132 A2=n121 B1=n132 B2=n121
XU199 NR2 $PINS O=n138 I1=FE_OFN1622_IxIy_shift_0 I2=FE_OFN1551_n2891
XU200 MOAI1S $PINS O=intadd_66/A[1] A1=n138 A2=n42 B1=n138 B2=n42
XU202 NR2 $PINS O=n59 I1=n45 I2=n44
XU203 AOI22S $PINS O=n54 A1=FE_OFN123_IxIy_shift_1 A2=B[3]
+ B1=FE_OFN131_IxIy_shift_0 B2=FE_OFN1508_FE_DBTN10_IxIy_shift_4
XU204 NR2 $PINS O=n57 I1=n59 I2=n54
XU205 NR2 $PINS O=n55 I1=n69 I2=n48
XU206 NR2 $PINS O=n47 I1=n55 I2=n46
XU207 MOAI1S $PINS O=n50 A1=n57 A2=n47 B1=n57 B2=n47
XU208 AN2 $PINS O=n49 I1=n69 I2=n48
XU209 MOAI1S $PINS O=n51 A1=FE_OFN1212_n1650 A2=n57 B1=FE_OFN1212_n1650 B2=n57
XU210 XNR3 $PINS O=N5 I1=n50 I2=n49 I3=n51
XU211 INV1S $PINS O=n52 I=n59
XU212 AN2 $PINS O=n64 I1=n123 I2=n52
XU213 MAO222 $PINS O=n66 A1=n51 B1=n50 C1=n49
XU214 NR2 $PINS O=n67 I1=n54 I2=n53
XU215 INV1S $PINS O=n58 I=n67
XU216 NR2 $PINS O=n56 I1=B[1] I2=FE_OFN1622_IxIy_shift_0
XU217 AOI13HS $PINS O=n68 A1=n55 B1=FE_OFN1212_n1650 B2=n57 B3=n56
XU218 OA12 $PINS O=n63 A1=n68 B1=n66 B2=n58
XU219 NR2 $PINS O=n122 I1=FE_OFN850_IxIy_shift_1 I2=IxIy_shift_4
XU220 MOAI1S $PINS O=n60 A1=intadd_67/SUM[0] A2=n61 B1=intadd_67/SUM[0] B2=n61
XU221 MOAI1S $PINS O=n65 A1=n60 A2=intadd_70/SUM[0] B1=n60 B2=intadd_70/SUM[0]
XU222 XNR3 $PINS O=N7 I1=n64 I2=n63 I3=n65
XU223 OR2B1S $PINS O=n62 I1=intadd_67/SUM[0] B1=n61
XU224 MAO222 $PINS O=n86 A1=n65 B1=n64 C1=n63
XU225 XOR3 $PINS O=N8 I1=n87 I2=intadd_67/SUM[1] I3=n86
XU226 INV1S $PINS O=intadd_63/A[22] I=s1_P3[14]
XU227 XOR3 $PINS O=N6 I1=n68 I2=n67 I3=n66
XU228 NR2 $PINS O=intadd_70/A[1] I1=FE_OFN1680_n1650 I2=IxIy_shift_5
XU229 AN2 $PINS O=N66 I1=intadd_64/n1 I2=n74
XU230 AN2 $PINS O=intadd_63/A[2] I1=s1_P1[1] I2=s1_P0[9]
XU232 AOI22S $PINS O=n223 A1=FE_OFN1219_n2891
+ A2=FE_OFN4183_FE_OFN1323_IxIy_shift_10
+ B1=FE_OFN4254_FE_OFN1402_FE_DBTN158_n2891 B2=FE_OFN1562_IxIy_shift_10
XU233 INV1S $PINS O=n314 I=n251
XU234 AN2 $PINS O=intadd_64/A[0] I1=n223 I2=n314
XU235 INV1S $PINS O=n332 I=s1_P1[15]
XU236 INV1S $PINS O=n76 I=intadd_63/n15
XU237 INV1S $PINS O=n75 I=s1_P1[8]
XU238 NR2 $PINS O=intadd_63/n14 I1=n76 I2=n75
XU239 XOR2HS $PINS O=N85 I1=s1_P1[8] I2=intadd_63/n15
XU240 NR2 $PINS O=intadd_66/B[0] I1=n78 I2=n77
XU241 OAI22S $PINS O=N19 A1=n78 A2=intadd_66/B[0] B1=n77 B2=intadd_66/B[0]
XU242 NR2 $PINS O=intadd_68/B[1] I1=n80 I2=n79
XU243 OAI22S $PINS O=intadd_65/A[1] A1=n80 A2=intadd_68/B[1] B1=n79
+ B2=intadd_68/B[1]
XU244 NR2 $PINS O=intadd_69/A[1] I1=n82 I2=n81
XU245 OAI22S $PINS O=intadd_72/B[1] A1=n82 A2=intadd_69/A[1] B1=n81
+ B2=intadd_69/A[1]
XU247 NR2 $PINS O=intadd_71/A[0] I1=n149 I2=n148
XU248 OAI22S $PINS O=intadd_67/B[7] A1=FE_OFN215_IxIy_shift_5
+ A2=FE_OFN277_FE_DBTN164_n1652 B1=n84 B2=FE_OFN277_FE_DBTN164_n1652
XU249 INV1S $PINS O=n85 I=intadd_63/n1
XU250 MOAI1S $PINS O=N99 A1=FE_PHN3222_intadd_63_A_22 A2=n85 B1=intadd_63/A[22]
+ B2=n85
XU251 INV1S $PINS O=n89 I=n86
XU252 INV1S $PINS O=n88 I=n87
XU253 MAO222 $PINS O=intadd_67/B[2] A1=n89 B1=intadd_67/SUM[1] C1=n88
XU254 INV1S $PINS O=intadd_63/A[17] I=s1_P3[9]
XU255 MAO222 $PINS O=intadd_63/A[11] A1=s1_P2[10] B1=s1_P1[10] C1=s1_P3[2]
XU256 INV1S $PINS O=intadd_63/B[21] I=s1_P3[13]
XU257 INV1S $PINS O=intadd_63/B[20] I=s1_P3[12]
XU258 INV1S $PINS O=intadd_63/B[19] I=s1_P3[11]
XU259 INV1S $PINS O=intadd_63/B[18] I=s1_P3[10]
XU260 XOR3 $PINS O=intadd_63/B[10] I1=s1_P3[2] I2=s1_P2[10] I3=s1_P1[10]
XU261 NR2 $PINS O=n90 I1=s1_P0[9] I2=s1_P1[1]
XU262 NR2 $PINS O=intadd_63/B[1] I1=n90 I2=intadd_63/A[2]
XU263 NR2 $PINS O=N3 I1=FE_OFN1620_IxIy_shift_0 I2=B[1]
XU264 NR2 $PINS O=n97 I1=FE_OFN1532_n168 I2=FE_OFN277_FE_DBTN164_n1652
XU265 FA1S $PINS S=n96 CO=n71 A=FE_OFN1495_FE_DBTN30_IxIy_shift_5 B=n95 CI=n94
XU266 FA1S $PINS S=intadd_67/A[4] CO=intadd_67/B[5] A=n98 B=n97 CI=n96
XU267 FA1S $PINS S=n102 CO=n20 A=n101 B=n100 CI=n99
XU268 INV1S $PINS O=n115 I=n102
XU269 MOAI1S $PINS O=n127 A1=n104 A2=n109 B1=n104 B2=n109
XU270 FA1S $PINS S=n106 CO=n101 A=n105 B=n110 CI=n104
XU271 INV1S $PINS O=n119 I=n106
XU272 NR2 $PINS O=n108 I1=n107 I2=n121
XU273 NR2 $PINS O=n118 I1=n129 I2=n108
XU274 FA1S $PINS S=n111 CO=n99 A=FE_OFN248_FE_DBTN10_IxIy_shift_4 B=n110
+ CI=n109
XU275 INV1S $PINS O=n117 I=n111
XU276 INV1S $PINS O=intadd_67/B[4] I=n112
XU277 FA1S $PINS S=n116 CO=n112 A=n115 B=n114 CI=n113
XU278 INV1S $PINS O=intadd_67/A[3] I=n116
XU279 FA1S $PINS S=n120 CO=n113 A=n119 B=n118 CI=n117
XU280 INV1S $PINS O=intadd_70/A[2] I=n120
XU281 MOAI1S $PINS O=intadd_70/B[1] A1=intadd_70/A[1] A2=n121 B1=intadd_70/A[1]
+ B2=n121
XU282 INV1S $PINS O=n124 I=n122
XU283 NR2 $PINS O=intadd_70/CI I1=n124 I2=n123
XU284 FA1S $PINS S=n128 CO=n114 A=n127 B=n126 CI=n125
XU285 INV1S $PINS O=intadd_70/B[2] I=n128
XU286 AN2B1S $PINS O=intadd_67/A[0] I1=n130 B1=n129
XU287 NR2 $PINS O=n131 I1=intadd_70/B[0] I2=intadd_67/A[0]
XU288 NR2 $PINS O=intadd_67/B[0] I1=n132 I2=n131
XU289 NR2 $PINS O=intadd_67/CI I1=FE_OFN1680_n1650 I2=FE_OFN1532_n168
XU290 NR2 $PINS O=intadd_67/A[7] I1=IxIy_shift_5 I2=FE_OFN164_IxIy_shift_7
XU291 OR2B1S $PINS O=N16 I1=intadd_67/n1 B1=n134
XU293 NR2 $PINS O=intadd_72/A[0] I1=FE_OFN1532_n168 I2=FE_OFN4322_n
XU294 NR2 $PINS O=intadd_72/B[0] I1=FE_OFN4299_n303 I2=FE_OFN215_IxIy_shift_5
XU295 NR2 $PINS O=intadd_72/CI I1=FE_OFN1681_n1650 I2=FE_OFN1551_n2891
XU296 MOAI1S $PINS O=n146 A1=n151 A2=n150 B1=n151 B2=n150
XU297 INV1S $PINS O=n136 I=n135
XU298 AOI13HS $PINS O=n145 A1=n136 B1=A[8] B2=FE_OFN270_IxIy_shift_3 B3=n137
XU299 INV1S $PINS O=intadd_66/B[3] I=n140
XU300 MOAI1S $PINS O=intadd_66/A[0] A1=n143 A2=n142 B1=n143 B2=n142
XU301 NR2 $PINS O=intadd_66/CI I1=FE_OFN1622_IxIy_shift_0 I2=FE_OFN4322_n
XU302 FA1S $PINS S=n147 CO=n140 A=n146 B=n145 CI=n144
XU303 INV1S $PINS O=intadd_66/A[2] I=n147
XU304 NR2 $PINS O=n154 I1=IxIy_shift_4 I2=n303
XU305 NR2 $PINS O=n153 I1=FE_OFN1532_n168 I2=FE_OFN4333_FE_DBTN153_n3310
XU306 NR2 $PINS O=n152 I1=FE_OFN1681_n1650 I2=FE_OFN4322_n
XU307 OAI22S $PINS O=n159 A1=n149 A2=intadd_71/A[0] B1=n148 B2=intadd_71/A[0]
XU308 NR2 $PINS O=n158 I1=IxIy_shift_4 I2=FE_OFN4333_FE_DBTN153_n3310
XU309 NR2 $PINS O=n157 I1=n151 I2=n150
XU310 FA1S $PINS S=intadd_66/B[2] CO=n155 A=n154 B=n153 CI=n152
XU311 FA1S $PINS S=intadd_66/A[3] CO=intadd_66/A[4] A=n156 B=n155
+ CI=intadd_72/SUM[0]
XU312 NR2 $PINS O=intadd_69/A[0] I1=FE_OFN4333_FE_DBTN153_n3310
+ I2=FE_OFN215_IxIy_shift_5
XU313 NR2 $PINS O=intadd_69/B[0] I1=FE_OFN4299_n303
+ I2=FE_OFN277_FE_DBTN164_n1652
XU314 NR2 $PINS O=intadd_69/CI I1=FE_OFN1681_n1650 I2=FE_OFN1614_IxIy_shift_12
XU315 NR2 $PINS O=intadd_71/B[0] I1=IxIy_shift_4 I2=FE_OFN4322_n
XU316 NR2 $PINS O=intadd_71/CI I1=FE_OFN1532_n168 I2=FE_OFN1551_n2891
XU317 FA1S $PINS S=n156 CO=n160 A=n159 B=n158 CI=n157
XU318 FA1S $PINS S=intadd_66/B[4] CO=intadd_66/A[5] A=intadd_72/SUM[1] B=n160
+ CI=intadd_71/SUM[0]
XU319 NR2 $PINS O=n171 I1=FE_OFN1622_IxIy_shift_0 I2=FE_OFN1059_n2620
XU320 INV1S $PINS O=intadd_71/A[1] I=n161
XU321 NR2 $PINS O=intadd_65/A[0] I1=FE_OFN1563_IxIy_shift_10
+ I2=FE_OFN215_IxIy_shift_5
XU322 NR2 $PINS O=intadd_65/B[0] I1=FE_OFN4333_FE_DBTN153_n3310
+ I2=FE_OFN1706_n1652
XU323 NR2 $PINS O=intadd_65/CI I1=FE_OFN850_IxIy_shift_1 I2=n163
XU324 NR2 $PINS O=n165 I1=FE_OFN4299_n303 I2=FE_OFN164_IxIy_shift_7
XU325 AOI22S $PINS O=n178 A1=FE_OFN1679_n1650 A2=FE_OFN162_IxIy_shift_13
+ B1=FE_OFN163_IxIy_shift_8 B2=FE_OFN265_FE_OFN1124_IxIy_shift_7
XU326 AO13S $PINS O=intadd_69/B[1] A1=n178 B1=FE_OFN162_IxIy_shift_13
+ B2=FE_OFN1679_n1650 B3=n165
XU327 NR2 $PINS O=n177 I1=FE_OFN850_IxIy_shift_1 I2=FE_OFN4318_n
XU328 INV1S $PINS O=intadd_69/A[2] I=n167
XU329 NR2 $PINS O=intadd_68/A[0] I1=FE_OFN1402_FE_DBTN158_n2891
+ I2=FE_OFN216_IxIy_shift_5
XU330 NR2 $PINS O=intadd_68/B[0] I1=FE_OFN221_IxIy_shift_3
+ I2=FE_OFN257_IxIy_shift_13
XU331 NR2 $PINS O=intadd_68/CI I1=FE_OFN1563_IxIy_shift_10 I2=FE_OFN1706_n1652
XU332 FA1S $PINS S=n161 CO=n172 A=n171 B=n170 CI=n169
XU333 INV1S $PINS O=intadd_65/B[1] I=n172
XU334 NR2 $PINS O=n182 I1=FE_OFN1680_n1650 I2=FE_OFN1059_n2620
XU335 INV1S $PINS O=intadd_65/A[2] I=n175
XU336 FA1S $PINS S=n167 CO=n179 A=n178 B=n177 CI=n176
XU337 INV1S $PINS O=intadd_65/B[2] I=n179
XU338 NR2 $PINS O=intadd_73/A[0] I1=FE_OFN4218_FE_OFN1583_IxIy_shift_13
+ I2=FE_OFN216_IxIy_shift_5
XU339 NR2 $PINS O=intadd_73/B[0] I1=FE_OFN1402_FE_DBTN158_n2891 I2=A[7]
XU340 NR2 $PINS O=intadd_73/CI I1=FE_OFN218_IxIy_shift_4 I2=n163
XU341 FA1S $PINS S=n175 CO=n183 A=n182 B=n181 CI=n180
XU342 INV1S $PINS O=intadd_68/B[2] I=n183
XU343 NR2 $PINS O=n188 I1=FE_OFN217_IxIy_shift_4 I2=FE_OFN257_IxIy_shift_13
XU344 NR2 $PINS O=n187 I1=FE_OFN1563_IxIy_shift_10 I2=A[7]
XU345 NR2 $PINS O=n186 I1=FE_OFN221_IxIy_shift_3 I2=n163
XU346 FA1S $PINS S=intadd_68/A[1] CO=n192 A=n188 B=n187 CI=n186
XU347 NR2 $PINS O=n191 I1=FE_OFN1614_IxIy_shift_12 I2=FE_OFN1706_n1652
XU348 FA1S $PINS S=intadd_65/B[3] CO=intadd_68/B[3] A=n192 B=n191 CI=n190
XU349 NR2 $PINS O=n202 I1=FE_OFN215_IxIy_shift_5 I2=FE_OFN4318_n
XU350 INV1S $PINS O=intadd_73/A[2] I=n194
XU351 NR2 $PINS O=n199 I1=FE_OFN257_IxIy_shift_13 I2=FE_OFN1706_n1652
XU352 NR2 $PINS O=n198 I1=FE_OFN1614_IxIy_shift_12 I2=A[7]
XU353 NR2 $PINS O=n197 I1=FE_OFN216_IxIy_shift_5 I2=n163
XU354 FA1S $PINS S=intadd_73/A[1] CO=intadd_73/B[2] A=n199 B=n198 CI=n197
XU355 FA1S $PINS S=n194 CO=n208 A=n202 B=n201 CI=n200
XU356 NR2 $PINS O=n206 I1=FE_OFN4318_n I2=FE_OFN1706_n1652
XU357 INV1S $PINS O=intadd_65/B[6] I=n205
XU358 FA1S $PINS S=n205 CO=n209 A=n208 B=n207 CI=n206
XU359 INV1S $PINS O=intadd_65/A[7] I=n209
XU360 MOAI1S $PINS O=n210 A1=intadd_66/n1 A2=intadd_69/n1 B1=intadd_66/n1
+ B2=intadd_69/n1
XU361 MOAI1S $PINS O=N28 A1=intadd_65/SUM[3] A2=n210 B1=intadd_65/SUM[3]
+ B2=n210
XU362 NR2 $PINS O=N18 I1=FE_OFN1622_IxIy_shift_0 I2=n303
XU363 INV1S $PINS O=N33 I=intadd_65/n1
XU364 OR2 $PINS O=intadd_64/A[7] I1=n212 I2=FE_OFN1550_n259
XU365 INV1S $PINS O=n292 I=n259
XU366 AOI22S $PINS O=n217 A1=FE_OFN4217_FE_OFN1583_IxIy_shift_13
+ A2=FE_OFN4318_n B1=FE_OFN1101_IxIy_shift_13 B2=FE_OFN4337_n
XU367 MOAI1S $PINS O=n295 A1=n292 A2=n239 B1=n290 B2=n217
XU369 MOAI1S $PINS O=n221 A1=FE_OFN4338_n A2=FE_OFN1614_IxIy_shift_12
+ B1=FE_OFN4338_n B2=FE_OFN1614_IxIy_shift_12
XU370 AOI22S $PINS O=n294 A1=FE_OFN1177_FE_DBTN85_n239 A2=n217 B1=n255 B2=n221
XU371 AOI22S $PINS O=n226 A1=FE_OFN4254_FE_OFN1402_FE_DBTN158_n2891
+ A2=FE_OFN4318_n B1=FE_OFN1219_n2891 B2=FE_OFN4337_n
XU372 AOI22S $PINS O=n237 A1=FE_OFN1219_n2891 A2=FE_OFN4257_FE_RN_1
+ B1=FE_OFN4254_FE_OFN1402_FE_DBTN158_n2891 B2=n163
XU373 AOI22S $PINS O=n235 A1=n251 A2=n226 B1=n237 B2=intadd_64/A[0]
XU374 AOI22S $PINS O=n229 A1=FE_OFN1177_FE_DBTN85_n239 A2=n221 B1=n255 B2=n226
XU375 INV1S $PINS O=intadd_64/B[7] I=n222
XU376 OAI12HS $PINS O=n233 A1=n226 B1=n251 B2=n223
XU377 MOAI1S $PINS O=n238 A1=FE_OFN4183_FE_OFN1323_IxIy_shift_10
+ A2=FE_OFN1062_n2620 B1=FE_OFN4183_FE_OFN1323_IxIy_shift_10 B2=FE_OFN4338_n
XU378 MOAI1S $PINS O=n234 A1=n227 A2=n238 B1=FE_OFN1177_FE_DBTN85_n239 B2=n226
XU379 FA1S $PINS S=n230 CO=n293 A=n235 B=n229 CI=n228
XU380 INV1S $PINS O=n231 I=n230
XU381 FA1S $PINS S=intadd_64/A[5] CO=intadd_64/A[6] A=n233 B=n232 CI=n231
XU382 FA1S $PINS S=n236 CO=n232 A=FE_OFN1550_n259 B=n235 CI=n234
XU383 INV1S $PINS O=n246 I=n236
XU384 MOAI1S $PINS O=n260 A1=FE_OFN1101_IxIy_shift_13
+ A2=FE_OFN4254_FE_OFN1402_FE_DBTN158_n2891 B1=FE_OFN1101_IxIy_shift_13
+ B2=FE_OFN4254_FE_OFN1402_FE_DBTN158_n2891
XU385 AO22 $PINS O=n250 A1=n251 A2=n237 B1=n260 B2=intadd_64/A[0]
XU386 MOAI1S $PINS O=n256 A1=FE_OFN1062_n2620 A2=FE_OFN4334_FE_DBTN153_n3310
+ B1=FE_OFN1062_n2620 B2=FE_OFN4334_FE_DBTN153_n3310
XU387 MOAI1S $PINS O=n248 A1=n239 A2=n238 B1=n255 B2=n256
XU388 NR2 $PINS O=n249 I1=n250 I2=n248
XU389 OA12 $PINS O=n262 A1=n256 B1=FE_OFN4230_FE_OFN1108_IxIy_shift_8
+ B2=FE_OFN4305_n
XU390 MOAI1S $PINS O=n270 A1=n241 A2=FE_OFN4230_FE_OFN1108_IxIy_shift_8
+ B1=FE_OFN1062_n2620 B2=n255
XU391 MOAI1S $PINS O=n269 A1=FE_RN_1 A2=n242 B1=FE_OFN1108_IxIy_shift_8 B2=n256
XU392 INV1S $PINS O=intadd_64/B[5] I=n244
XU393 FA1S $PINS S=n247 CO=n244 A=n246 B=n249 CI=n245
XU394 INV1S $PINS O=intadd_64/A[4] I=n247
XU395 OAI22S $PINS O=n267 A1=n250 A2=n249 B1=n248 B2=n249
XU396 AOI22S $PINS O=n276 A1=n290 A2=intadd_64/A[0] B1=n260 B2=n251
XU397 MOAI1S $PINS O=n254 A1=FE_OFN4337_n A2=FE_OFN4298_n303 B1=FE_OFN4337_n
+ B2=FE_OFN4298_n303
XU398 AOI22S $PINS O=n275 A1=FE_DBTN85_n239 A2=n256 B1=n255 B2=n254
XU399 AOI22S $PINS O=n274 A1=FE_OFN1549_n290 A2=n260 B1=FE_OFN1550_n259 B2=n258
XU400 FA1S $PINS S=n265 CO=n245 A=n263 B=n262 CI=n261
XU401 INV1S $PINS O=intadd_64/B[4] I=n264
XU402 FA1S $PINS S=n268 CO=n264 A=n267 B=n266 CI=n265
XU403 INV1S $PINS O=intadd_64/A[3] I=n268
XU404 FA1S $PINS S=n31 CO=n279 A=n273 B=n272 CI=n271
XU405 FA1S $PINS S=n278 CO=n266 A=n276 B=n275 CI=n274
XU406 INV1S $PINS O=intadd_64/B[3] I=n277
XU407 FA1S $PINS S=n281 CO=n277 A=n280 B=n279 CI=n278
XU408 INV1S $PINS O=intadd_64/A[2] I=n281
XU409 OA12 $PINS O=intadd_64/B[0] A1=n282 B1=n284 B2=n283
XU410 MOAI1S $PINS O=n291 A1=FE_OFN4247_FE_OFN1101_IxIy_shift_13
+ A2=FE_OFN4230_FE_OFN1108_IxIy_shift_8 B1=FE_OFN4247_FE_OFN1101_IxIy_shift_13
+ B2=FE_OFN1108_IxIy_shift_8
XU411 MOAI1S $PINS O=intadd_64/CI A1=n292 A2=n291 B1=FE_OFN1549_n290 B2=n289
XU412 FA1S $PINS S=n296 CO=n222 A=n295 B=n294 CI=n293
XU413 INV1S $PINS O=intadd_64/B[6] I=n296
XU414 MOAI1S $PINS O=n299 A1=n215 A2=FE_OFN4306_n B1=n215 B2=FE_OFN4306_n
XU415 MOAI1S $PINS O=n305 A1=n299 A2=FE_OFN4298_n303 B1=N54
+ B2=FE_OFN1403_FE_DBTN158_n2891
XU416 MOAI1S $PINS O=n302 A1=FE_OFN1219_n2891 A2=FE_OFN4306_n
+ B1=FE_OFN1219_n2891 B2=FE_OFN4306_n
XU417 MOAI1S $PINS O=n304 A1=FE_OFN4298_n303 A2=n302 B1=N54
+ B2=FE_OFN1562_IxIy_shift_10
XU418 NR2 $PINS O=n306 I1=n305 I2=n304
XU419 NR2 $PINS O=N57 I1=intadd_64/SUM[0] I2=n306
XU420 NR2 $PINS O=n310 I1=FE_OFN4298_n303 I2=FE_OFN1403_FE_DBTN158_n2891
XU421 MUX3 $PINS O=N56 S0=FE_OFN4298_n303 S1=FE_OFN1562_IxIy_shift_10
+ A=FE_OFN1403_FE_DBTN158_n2891 B=FE_OFN4334_FE_DBTN153_n3310 C=n310
XU422 NR2 $PINS O=N55 I1=n314 I2=n303
XU423 FA1 $PINS S=N89 CO=intadd_63/n10 A=s1_P3[5] B=s1_P1[12] CI=intadd_63/n11
XU424 FA1 $PINS S=N90 CO=intadd_63/n9 A=s1_P3[6] B=s1_P1[13] CI=intadd_63/n10
XU425 FA1 $PINS S=N91 CO=intadd_63/n8 A=intadd_63/B[15] B=s1_P1[14]
+ CI=intadd_63/n9
Xs2_result_reg[8] QDFFRBS $PINS Q=result[8] D=FE_PHN3129_s1_P0_8 CK=clk_clone1
+ RB=FE_OFN13_i_reset_n_i
Xs1_P0_reg[5] QDFFRBS $PINS Q=N73 D=N6 CK=clk_clone3 RB=FE_OFN4_i_reset_n_i
Xs1_P1_reg[5] QDFFRBS $PINS Q=s1_P1[5] D=N23 CK=clk RB=FE_OFN215_i_reset_n_i
Xs1_P3_reg[6] QDFFRBS $PINS Q=s1_P3[6] D=N58 CK=clk RB=FE_OFN247_i_reset_n_i
Xs2_result_reg[22] QDFFRBS $PINS Q=result[22] D=N90 CK=clk
+ RB=FE_OFN30_i_reset_n_i
Xs2_result_reg[6] QDFFRBS $PINS Q=result[6] D=FE_PHN2948_N74 CK=clk_clone3
+ RB=FE_OFN17_i_reset_n_i
XU7 ND2S $PINS O=n148 I1=FE_OFN129_IxIy_shift_0 I2=A[13]
.ENDS

.SUBCKT LOD_W2_15 in[1] in[0] pos[0] valid
*.CONNECT pos[0] in[1]
XU2 OR2 $PINS O=valid I1=in[0] I2=in[1]
.ENDS

.SUBCKT LOD_W2_14 in[1] in[0] pos[0] valid
*.CONNECT pos[0] in[1]
XU2 OR2 $PINS O=valid I1=in[0] I2=in[1]
.ENDS

.SUBCKT LOD_W4_7 in[3] in[2] in[1] in[0] pos[1] pos[0] valid
*.CONNECT pos[1] recursive_case.left_valid
XU1 OR2 $PINS O=valid I1=recursive_case.right_valid
+ I2=recursive_case.left_valid
XU2 MUX2 $PINS O=pos[0] S=recursive_case.left_valid
+ A=recursive_case.right_pos[0] B=recursive_case.left_pos[0]
Xrecursive_case.LOD_left LOD_W2_15 $PINS in[1]=in[3] in[0]=in[2]
+ pos[0]=recursive_case.left_pos[0] valid=recursive_case.left_valid
Xrecursive_case.LOD_right LOD_W2_14 $PINS in[1]=in[1] in[0]=in[0]
+ pos[0]=recursive_case.right_pos[0] valid=recursive_case.right_valid
.ENDS

.SUBCKT LOD_W2_13 in[1] in[0] pos[0] valid
*.CONNECT pos[0] in[1]
XU2 OR2 $PINS O=valid I1=in[0] I2=in[1]
.ENDS

.SUBCKT LOD_W2_12 in[1] in[0] pos[0] valid
*.CONNECT pos[0] in[1]
XU2 OR2 $PINS O=valid I1=in[0] I2=in[1]
.ENDS

.SUBCKT LOD_W4_6 in[3] in[2] in[1] in[0] pos[1] pos[0] valid
*.CONNECT pos[1] recursive_case.left_valid
XU1 OR2 $PINS O=valid I1=recursive_case.right_valid
+ I2=recursive_case.left_valid
XU2 MUX2 $PINS O=pos[0] S=recursive_case.left_valid
+ A=recursive_case.right_pos[0] B=recursive_case.left_pos[0]
Xrecursive_case.LOD_left LOD_W2_13 $PINS in[1]=in[3] in[0]=in[2]
+ pos[0]=recursive_case.left_pos[0] valid=recursive_case.left_valid
Xrecursive_case.LOD_right LOD_W2_12 $PINS in[1]=in[1] in[0]=in[0]
+ pos[0]=recursive_case.right_pos[0] valid=recursive_case.right_valid
.ENDS

.SUBCKT LOD_W8_3 in[7] in[6] in[5] in[4] in[3] in[2] in[1] in[0] pos[2] pos[1]
+ pos[0] valid
*.CONNECT pos[2] recursive_case.left_valid
XU1 OR2 $PINS O=valid I1=recursive_case.right_valid
+ I2=recursive_case.left_valid
XU2 MUX2 $PINS O=pos[0] S=recursive_case.left_valid
+ A=recursive_case.right_pos[0] B=recursive_case.left_pos[0]
XU3 MUX2 $PINS O=pos[1] S=recursive_case.left_valid
+ A=recursive_case.right_pos[1] B=recursive_case.left_pos[1]
Xrecursive_case.LOD_left LOD_W4_7 $PINS in[3]=in[7] in[2]=in[6] in[1]=in[5]
+ in[0]=in[4] pos[1]=recursive_case.left_pos[1] pos[0]=recursive_case.left_pos[0]
+ valid=recursive_case.left_valid
Xrecursive_case.LOD_right LOD_W4_6 $PINS in[3]=in[3] in[2]=in[2] in[1]=in[1]
+ in[0]=in[0] pos[1]=recursive_case.right_pos[1]
+ pos[0]=recursive_case.right_pos[0] valid=recursive_case.right_valid
.ENDS

.SUBCKT LOD_W2_11 in[1] in[0] pos[0] valid
*.CONNECT pos[0] in[1]
XU2 OR2 $PINS O=valid I1=in[0] I2=in[1]
.ENDS

.SUBCKT LOD_W2_10 in[1] in[0] pos[0] valid
*.CONNECT pos[0] in[1]
XU2 OR2 $PINS O=valid I1=in[0] I2=in[1]
.ENDS

.SUBCKT LOD_W4_5 in[3] in[2] in[1] in[0] pos[1] pos[0] valid
*.CONNECT pos[1] recursive_case.left_valid
XU1 OR2 $PINS O=valid I1=recursive_case.right_valid
+ I2=recursive_case.left_valid
XU2 MUX2 $PINS O=pos[0] S=recursive_case.left_valid
+ A=recursive_case.right_pos[0] B=recursive_case.left_pos[0]
Xrecursive_case.LOD_left LOD_W2_11 $PINS in[1]=in[3] in[0]=in[2]
+ pos[0]=recursive_case.left_pos[0] valid=recursive_case.left_valid
Xrecursive_case.LOD_right LOD_W2_10 $PINS in[1]=in[1] in[0]=in[0]
+ pos[0]=recursive_case.right_pos[0] valid=recursive_case.right_valid
.ENDS

.SUBCKT LOD_W2_9 in[1] in[0] pos[0] valid
*.CONNECT pos[0] in[1]
XU2 OR2 $PINS O=valid I1=in[0] I2=in[1]
.ENDS

.SUBCKT LOD_W2_8 in[1] in[0] pos[0] valid
*.CONNECT pos[0] in[1]
XU2 OR2 $PINS O=valid I1=in[0] I2=in[1]
.ENDS

.SUBCKT LOD_W4_4 in[3] in[2] in[1] in[0] pos[1] pos[0] valid
*.CONNECT pos[1] recursive_case.left_valid
XU1 OR2 $PINS O=valid I1=recursive_case.right_valid
+ I2=recursive_case.left_valid
XU2 MUX2 $PINS O=pos[0] S=recursive_case.left_valid
+ A=recursive_case.right_pos[0] B=recursive_case.left_pos[0]
Xrecursive_case.LOD_left LOD_W2_9 $PINS in[1]=in[3] in[0]=in[2]
+ pos[0]=recursive_case.left_pos[0] valid=recursive_case.left_valid
Xrecursive_case.LOD_right LOD_W2_8 $PINS in[1]=in[1] in[0]=in[0]
+ pos[0]=recursive_case.right_pos[0] valid=recursive_case.right_valid
.ENDS

.SUBCKT LOD_W8_2 in[7] in[6] in[5] in[4] in[3] in[2] in[1] in[0] pos[2] pos[1]
+ pos[0] valid
*.CONNECT pos[2] recursive_case.left_valid
XU1 OR2 $PINS O=valid I1=recursive_case.right_valid
+ I2=recursive_case.left_valid
XU2 MUX2 $PINS O=pos[0] S=recursive_case.left_valid
+ A=recursive_case.right_pos[0] B=recursive_case.left_pos[0]
XU3 MUX2 $PINS O=pos[1] S=recursive_case.left_valid
+ A=recursive_case.right_pos[1] B=recursive_case.left_pos[1]
Xrecursive_case.LOD_left LOD_W4_5 $PINS in[3]=in[7] in[2]=in[6] in[1]=in[5]
+ in[0]=in[4] pos[1]=recursive_case.left_pos[1] pos[0]=recursive_case.left_pos[0]
+ valid=recursive_case.left_valid
Xrecursive_case.LOD_right LOD_W4_4 $PINS in[3]=in[3] in[2]=in[2] in[1]=in[1]
+ in[0]=in[0] pos[1]=recursive_case.right_pos[1]
+ pos[0]=recursive_case.right_pos[0] valid=recursive_case.right_valid
.ENDS

.SUBCKT LOD_W16_1 in[15] in[14] in[13] in[12] in[11] in[10] in[9] in[8] in[7]
+ in[6] in[5] in[4] in[3] in[2] in[1] in[0] pos[3] pos[2] pos[1] pos[0] valid
*.CONNECT pos[3] recursive_case.left_valid
XU1 OR2T $PINS O=valid I1=recursive_case.right_valid
+ I2=recursive_case.left_valid
XU2 MUX2 $PINS O=pos[0] S=recursive_case.left_valid
+ A=recursive_case.right_pos[0] B=recursive_case.left_pos[0]
XU3 MUX2 $PINS O=pos[1] S=recursive_case.left_valid
+ A=recursive_case.right_pos[1] B=recursive_case.left_pos[1]
XU4 MUX2 $PINS O=pos[2] S=recursive_case.left_valid
+ A=recursive_case.right_pos[2] B=recursive_case.left_pos[2]
Xrecursive_case.LOD_left LOD_W8_3 $PINS in[7]=in[15] in[6]=in[14] in[5]=in[13]
+ in[4]=in[12] in[3]=in[11] in[2]=in[10] in[1]=in[9] in[0]=in[8]
+ pos[2]=recursive_case.left_pos[2] pos[1]=recursive_case.left_pos[1]
+ pos[0]=recursive_case.left_pos[0] valid=recursive_case.left_valid
Xrecursive_case.LOD_right LOD_W8_2 $PINS in[7]=in[7] in[6]=in[6] in[5]=in[5]
+ in[4]=in[4] in[3]=in[3] in[2]=in[2] in[1]=in[1] in[0]=in[0]
+ pos[2]=recursive_case.right_pos[2] pos[1]=recursive_case.right_pos[1]
+ pos[0]=recursive_case.right_pos[0] valid=recursive_case.right_valid
.ENDS

.SUBCKT LOD_W2_7 in[1] in[0] pos[0] valid
*.CONNECT pos[0] in[1]
XU2 OR2 $PINS O=valid I1=in[0] I2=in[1]
.ENDS

.SUBCKT LOD_W2_6 in[1] in[0] pos[0] valid
*.CONNECT pos[0] in[1]
XU2 OR2 $PINS O=valid I1=in[0] I2=in[1]
.ENDS

.SUBCKT LOD_W4_3 in[3] in[2] in[1] in[0] pos[1] pos[0] valid
*.CONNECT pos[1] recursive_case.left_valid
XU1 OR2 $PINS O=valid I1=recursive_case.right_valid
+ I2=recursive_case.left_valid
XU2 MUX2 $PINS O=pos[0] S=recursive_case.left_valid
+ A=recursive_case.right_pos[0] B=recursive_case.left_pos[0]
Xrecursive_case.LOD_left LOD_W2_7 $PINS in[1]=in[3] in[0]=in[2]
+ pos[0]=recursive_case.left_pos[0] valid=recursive_case.left_valid
Xrecursive_case.LOD_right LOD_W2_6 $PINS in[1]=in[1] in[0]=in[0]
+ pos[0]=recursive_case.right_pos[0] valid=recursive_case.right_valid
.ENDS

.SUBCKT LOD_W2_5 in[1] in[0] pos[0] valid
*.CONNECT pos[0] in[1]
XU2 OR2 $PINS O=valid I1=in[0] I2=in[1]
.ENDS

.SUBCKT LOD_W2_4 in[1] in[0] pos[0] valid
*.CONNECT pos[0] in[1]
XU2 OR2 $PINS O=valid I1=in[0] I2=in[1]
.ENDS

.SUBCKT LOD_W4_2 in[3] in[2] in[1] in[0] pos[1] pos[0] valid
*.CONNECT pos[1] recursive_case.left_valid
XU1 OR2 $PINS O=valid I1=recursive_case.right_valid
+ I2=recursive_case.left_valid
XU2 MUX2 $PINS O=pos[0] S=recursive_case.left_valid
+ A=recursive_case.right_pos[0] B=recursive_case.left_pos[0]
Xrecursive_case.LOD_left LOD_W2_5 $PINS in[1]=in[3] in[0]=in[2]
+ pos[0]=recursive_case.left_pos[0] valid=recursive_case.left_valid
Xrecursive_case.LOD_right LOD_W2_4 $PINS in[1]=in[1] in[0]=in[0]
+ pos[0]=recursive_case.right_pos[0] valid=recursive_case.right_valid
.ENDS

.SUBCKT LOD_W8_1 in[7] in[6] in[5] in[4] in[3] in[2] in[1] in[0] pos[2] pos[1]
+ pos[0] valid
*.CONNECT pos[2] recursive_case.left_valid
XU1 OR2 $PINS O=valid I1=recursive_case.right_valid
+ I2=recursive_case.left_valid
XU2 MUX2 $PINS O=pos[0] S=recursive_case.left_valid
+ A=recursive_case.right_pos[0] B=recursive_case.left_pos[0]
XU3 MUX2 $PINS O=pos[1] S=recursive_case.left_valid
+ A=recursive_case.right_pos[1] B=recursive_case.left_pos[1]
Xrecursive_case.LOD_left LOD_W4_3 $PINS in[3]=in[7] in[2]=in[6] in[1]=in[5]
+ in[0]=in[4] pos[1]=recursive_case.left_pos[1] pos[0]=recursive_case.left_pos[0]
+ valid=recursive_case.left_valid
Xrecursive_case.LOD_right LOD_W4_2 $PINS in[3]=in[3] in[2]=in[2] in[1]=in[1]
+ in[0]=in[0] pos[1]=recursive_case.right_pos[1]
+ pos[0]=recursive_case.right_pos[0] valid=recursive_case.right_valid
.ENDS

.SUBCKT LOD_W2_3 in[1] in[0] pos[0] valid
*.CONNECT pos[0] in[1]
XU2 OR2 $PINS O=valid I1=in[0] I2=in[1]
.ENDS

.SUBCKT LOD_W2_2 in[1] in[0] pos[0] valid
*.CONNECT pos[0] in[1]
XU2 OR2 $PINS O=valid I1=in[0] I2=in[1]
.ENDS

.SUBCKT LOD_W4_1 in[3] in[2] in[1] in[0] pos[1] pos[0] valid
*.CONNECT pos[1] recursive_case.left_valid
XU1 OR2P $PINS O=valid I1=recursive_case.right_valid
+ I2=recursive_case.left_valid
XU2 MUX2 $PINS O=pos[0] S=recursive_case.left_valid
+ A=recursive_case.right_pos[0] B=recursive_case.left_pos[0]
Xrecursive_case.LOD_left LOD_W2_3 $PINS in[1]=in[3] in[0]=in[2]
+ pos[0]=recursive_case.left_pos[0] valid=recursive_case.left_valid
Xrecursive_case.LOD_right LOD_W2_2 $PINS in[1]=in[1] in[0]=in[0]
+ pos[0]=recursive_case.right_pos[0] valid=recursive_case.right_valid
.ENDS

.SUBCKT LOD_W2_1 in[1] in[0] pos[0] valid
*.CONNECT pos[0] in[1]
XU2 OR2 $PINS O=valid I1=in[0] I2=in[1]
.ENDS

.SUBCKT LOD_W2_0 in[1] in[0] pos[0] valid
*.CONNECT pos[0] in[1]
XU2 OR2 $PINS O=valid I1=in[0] I2=in[1]
.ENDS

.SUBCKT LOD_W4_0 in[3] in[2] in[1] in[0] pos[1] pos[0] valid
*.CONNECT pos[1] recursive_case.left_valid
XU1 OR2 $PINS O=valid I1=recursive_case.right_valid
+ I2=recursive_case.left_valid
XU2 MUX2 $PINS O=pos[0] S=recursive_case.left_valid
+ A=recursive_case.right_pos[0] B=recursive_case.left_pos[0]
Xrecursive_case.LOD_left LOD_W2_1 $PINS in[1]=in[3] in[0]=in[2]
+ pos[0]=recursive_case.left_pos[0] valid=recursive_case.left_valid
Xrecursive_case.LOD_right LOD_W2_0 $PINS in[1]=in[1] in[0]=in[0]
+ pos[0]=recursive_case.right_pos[0] valid=recursive_case.right_valid
.ENDS

.SUBCKT LOD_W8_0 in[7] in[6] in[5] in[4] in[3] in[2] in[1] in[0] pos[2] pos[1]
+ pos[0] valid
*.CONNECT pos[2] recursive_case.left_valid
XU1 OR2 $PINS O=valid I1=recursive_case.right_valid
+ I2=recursive_case.left_valid
XU2 MUX2 $PINS O=pos[0] S=recursive_case.left_valid
+ A=recursive_case.right_pos[0] B=recursive_case.left_pos[0]
XU3 MUX2 $PINS O=pos[1] S=recursive_case.left_valid
+ A=recursive_case.right_pos[1] B=recursive_case.left_pos[1]
Xrecursive_case.LOD_left LOD_W4_1 $PINS in[3]=in[7] in[2]=in[6] in[1]=in[5]
+ in[0]=in[4] pos[1]=recursive_case.left_pos[1] pos[0]=recursive_case.left_pos[0]
+ valid=recursive_case.left_valid
Xrecursive_case.LOD_right LOD_W4_0 $PINS in[3]=in[3] in[2]=in[2] in[1]=in[1]
+ in[0]=in[0] pos[1]=recursive_case.right_pos[1]
+ pos[0]=recursive_case.right_pos[0] valid=recursive_case.right_valid
.ENDS

.SUBCKT LOD_W16_0 in[15] in[14] in[13] in[12] in[11] in[10] in[9] in[8] in[7]
+ in[6] in[5] in[4] in[3] in[2] in[1] in[0] pos[3] pos[2] pos[1] pos[0] valid
*.CONNECT pos[3] recursive_case.left_valid
XU1 OR2P $PINS O=valid I1=recursive_case.right_valid
+ I2=recursive_case.left_valid
XU2 MUX2 $PINS O=pos[0] S=recursive_case.left_valid
+ A=recursive_case.right_pos[0] B=recursive_case.left_pos[0]
XU3 MUX2 $PINS O=pos[1] S=recursive_case.left_valid
+ A=recursive_case.right_pos[1] B=recursive_case.left_pos[1]
XU4 MUX2 $PINS O=pos[2] S=recursive_case.left_valid
+ A=recursive_case.right_pos[2] B=recursive_case.left_pos[2]
Xrecursive_case.LOD_left LOD_W8_1 $PINS in[7]=in[15] in[6]=in[14] in[5]=in[13]
+ in[4]=in[12] in[3]=in[11] in[2]=in[10] in[1]=in[9] in[0]=in[8]
+ pos[2]=recursive_case.left_pos[2] pos[1]=recursive_case.left_pos[1]
+ pos[0]=recursive_case.left_pos[0] valid=recursive_case.left_valid
Xrecursive_case.LOD_right LOD_W8_0 $PINS in[7]=in[7] in[6]=in[6] in[5]=in[5]
+ in[4]=in[4] in[3]=in[3] in[2]=in[2] in[1]=in[1] in[0]=in[0]
+ pos[2]=recursive_case.right_pos[2] pos[1]=recursive_case.right_pos[1]
+ pos[0]=recursive_case.right_pos[0] valid=recursive_case.right_valid
.ENDS

.SUBCKT LOD_W32_0 in[31] in[30] in[29] in[28] in[27] in[26] in[25] in[24]
+ in[23] in[22] in[21] in[20] in[19] in[18] in[17] in[16] in[15] in[14] in[13]
+ in[12] in[11] in[10] in[9] in[8] in[7] in[6] in[5] in[4] in[3] in[2] in[1]
+ in[0] pos[4] pos[3] pos[2] pos[1] pos[0] valid
*.CONNECT pos[4] recursive_case.left_valid
XU1 OR2T $PINS O=valid I1=recursive_case.right_valid
+ I2=recursive_case.left_valid
XU2 MUX2 $PINS O=pos[0] S=recursive_case.left_valid
+ A=recursive_case.right_pos[0] B=recursive_case.left_pos[0]
XU3 MUX2 $PINS O=pos[1] S=recursive_case.left_valid
+ A=recursive_case.right_pos[1] B=recursive_case.left_pos[1]
XU4 MUX2 $PINS O=pos[2] S=recursive_case.left_valid
+ A=recursive_case.right_pos[2] B=recursive_case.left_pos[2]
XU5 MUX2 $PINS O=pos[3] S=recursive_case.left_valid
+ A=recursive_case.right_pos[3] B=recursive_case.left_pos[3]
Xrecursive_case.LOD_left LOD_W16_1 $PINS in[15]=in[31] in[14]=in[30]
+ in[13]=in[29] in[12]=in[28] in[11]=in[27] in[10]=in[26] in[9]=in[25]
+ in[8]=in[24] in[7]=in[23] in[6]=in[22] in[5]=in[21] in[4]=in[20] in[3]=in[19]
+ in[2]=in[18] in[1]=in[17] in[0]=in[16] pos[3]=recursive_case.left_pos[3]
+ pos[2]=recursive_case.left_pos[2] pos[1]=recursive_case.left_pos[1]
+ pos[0]=recursive_case.left_pos[0] valid=recursive_case.left_valid
Xrecursive_case.LOD_right LOD_W16_0 $PINS in[15]=in[15] in[14]=in[14]
+ in[13]=in[13] in[12]=in[12] in[11]=in[11] in[10]=in[10] in[9]=in[9] in[8]=in[8]
+ in[7]=in[7] in[6]=in[6] in[5]=in[5] in[4]=in[4] in[3]=in[3] in[2]=in[2]
+ in[1]=in[1] in[0]=in[0] pos[3]=recursive_case.right_pos[3]
+ pos[2]=recursive_case.right_pos[2] pos[1]=recursive_case.right_pos[1]
+ pos[0]=recursive_case.right_pos[0] valid=recursive_case.right_valid
.ENDS

.SUBCKT LOD_W33 in[32] in[31] in[30] in[29] in[28] in[27] in[26] in[25] in[24]
+ in[23] in[22] in[21] in[20] in[19] in[18] in[17] in[16] in[15] in[14] in[13]
+ in[12] in[11] in[10] in[9] in[8] in[7] in[6] in[5] in[4] in[3] in[2] in[1]
+ in[0] pos[5] pos[4] pos[3] pos[2] pos[1] pos[0] valid
*.CONNECT pos[4] recursive_case.right_pos[4]
Xrecursive_case.LOD_right LOD_W32_0 $PINS in[31]=in[31] in[30]=in[30]
+ in[29]=in[29] in[28]=in[28] in[27]=in[27] in[26]=in[26] in[25]=in[25]
+ in[24]=in[24] in[23]=in[23] in[22]=in[22] in[21]=in[21] in[20]=in[20]
+ in[19]=in[19] in[18]=in[18] in[17]=in[17] in[16]=in[16] in[15]=in[15]
+ in[14]=in[14] in[13]=in[13] in[12]=in[12] in[11]=in[11] in[10]=in[10]
+ in[9]=in[9] in[8]=in[8] in[7]=in[7] in[6]=in[6] in[5]=in[5] in[4]=in[4]
+ in[3]=in[3] in[2]=in[2] in[1]=in[1] in[0]=in[0]
+ pos[4]=recursive_case.right_pos[4] pos[3]=pos[3] pos[2]=pos[2] pos[1]=pos[1]
+ pos[0]=pos[0] valid=valid
.ENDS

.SUBCKT Harris_width8 Ix2[15] Ix2[14] Ix2[13] Ix2[12] Ix2[11] Ix2[10] Ix2[9]
+ Ix2[8] Ix2[7] Ix2[6] Ix2[5] Ix2[4] Ix2[3] Ix2[2] Ix2[1] Ix2[0] Iy2[15]
+ Iy2[14] Iy2[13] Iy2[12] Iy2[11] Iy2[10] Iy2[9] Iy2[8] Iy2[7] Iy2[6] Iy2[5]
+ Iy2[4] Iy2[3] Iy2[2] Iy2[1] Iy2[0] det[32] det[31] det[30] det[29] det[28]
+ det[27] det[26] det[25] det[24] det[23] det[22] det[21] det[20] det[19]
+ det[18] det[17] det[16] det[15] det[14] det[13] det[12] det[11] det[10]
+ det[9] det[8] det[7] det[6] det[5] det[4] det[3] det[2] det[1] det[0] clk
+ rst_n corner IN0 FE_OFN110_i_reset_n_i FE_OFN97_i_reset_n_i
+ FE_OFN76_i_reset_n_i FE_OFN16_i_reset_n_i FE_OFN14_i_reset_n_i
+ FE_OFN5_i_reset_n_i FE_OFN2_i_reset_n_i FE_OFN1_i_reset_n_i
+ FE_OFN0_i_reset_n_i clk_clone4 clk_clone3 clk_clone2 clk_clone1
XFE_PHC3302_s1_P2_10 BUF1CK $PINS O=FE_PHN3302_s1_P2_10 I=s1_P2[10]
XFE_PHC3294_trace_sq_28 BUF1S $PINS O=FE_PHN3294_trace_sq_28 I=trace_sq[28]
XFE_PHC3290_trace_sq_33 DELA $PINS O=trace_sq[33] I=FE_PHN3290_trace_sq_33
XFE_PHC3278_trace_sq_25 BUF1CK $PINS O=FE_PHN3278_trace_sq_25 I=trace_sq[25]
XFE_PHC3269_trace_sq_14 BUF1CK $PINS O=FE_PHN3269_trace_sq_14 I=trace_sq[14]
XFE_PHC3264_trace_sq_13 BUF1CK $PINS O=FE_PHN3264_trace_sq_13 I=trace_sq[13]
XFE_PHC3259_s1_P2_9 BUF1CK $PINS O=s1_P2[9] I=FE_PHN3259_s1_P2_9
XFE_PHC3258_trace_sq_21 BUF1CK $PINS O=trace_sq[21] I=FE_PHN3258_trace_sq_21
XFE_PHC3250_trace_sq_20 BUF1CK $PINS O=FE_PHN3250_trace_sq_20 I=trace_sq[20]
XFE_PHC3242_trace_sq_11 BUF1CK $PINS O=FE_PHN3242_trace_sq_11 I=trace_sq[11]
XFE_PHC3241_trace_sq_24 BUF1CK $PINS O=FE_PHN3241_trace_sq_24 I=trace_sq[24]
XFE_PHC3240_trace_sq_18 BUF1CK $PINS O=trace_sq[18] I=FE_PHN3240_trace_sq_18
XFE_PHC3235_trace_sq_26 BUF1CK $PINS O=trace_sq[26] I=FE_PHN3235_trace_sq_26
XFE_PHC3234_trace_sq_12 BUF1CK $PINS O=FE_PHN3234_trace_sq_12 I=trace_sq[12]
XFE_PHC3232_trace_sq_16 BUF1CK $PINS O=FE_PHN3232_trace_sq_16 I=trace_sq[16]
XFE_PHC3226_trace_sq_15 BUF1CK $PINS O=FE_PHN3226_trace_sq_15 I=trace_sq[15]
XFE_PHC3223_trace_sq_17 BUF1CK $PINS O=FE_PHN3223_trace_sq_17 I=trace_sq[17]
XFE_PHC3217_s1_P2_14 BUF1CK $PINS O=s1_P2[14] I=FE_PHN3217_s1_P2_14
XFE_PHC3213_s1_P2_12 BUF2CK $PINS O=FE_PHN3213_s1_P2_12 I=s1_P2[12]
XFE_PHC3209_s1_P2_13 BUF1S $PINS O=FE_PHN3209_s1_P2_13 I=s1_P2[13]
XFE_PHC3186_det_1 BUF1CK $PINS O=FE_PHN3186_det_1 I=det[1]
XFE_PHC3168_trace_sq_10 DELA $PINS O=FE_PHN3168_trace_sq_10 I=trace_sq[10]
XFE_PHC3146_n4365 BUF2CK $PINS O=FE_PHN3146_n4365 I=IN0
XFE_PHC3139_trace_sq_9 DELB $PINS O=FE_PHN3139_trace_sq_9 I=trace_sq[9]
XFE_PHC3126_s1_P2_11 BUF1S $PINS O=FE_PHN3126_s1_P2_11 I=s1_P2[11]
XFE_PHC3104_s1_det_23 DELB $PINS O=s1_det[23] I=FE_PHN3104_s1_det_23
XFE_PHC3085_s1_det_8 DELB $PINS O=FE_PHN3085_s1_det_8 I=s1_det[8]
XFE_PHC3080_n725 DELB $PINS O=FE_PHN3080_n725 I=n725
XFE_PHC3073_s1_det_2 DELB $PINS O=FE_PHN3073_s1_det_2 I=s1_det[2]
XFE_PHC3072_trace_sq_8 DELB $PINS O=FE_PHN3072_trace_sq_8 I=trace_sq[8]
XFE_PHC3071_trace_sq_6 DELB $PINS O=FE_PHN3071_trace_sq_6 I=trace_sq[6]
XFE_PHC3068_s1_det_1 DELB $PINS O=FE_PHN3068_s1_det_1 I=s1_det[1]
XFE_PHC3059_s1_det_11 DELB $PINS O=FE_PHN3059_s1_det_11 I=s1_det[11]
XFE_PHC3042_s1_det_13 DELB $PINS O=FE_PHN3042_s1_det_13 I=s1_det[13]
XFE_PHC3030_s1_det_25 DELB $PINS O=s1_det[25] I=FE_PHN3030_s1_det_25
XFE_PHC3024_trace_sq_5 DELB $PINS O=FE_PHN3024_trace_sq_5 I=trace_sq[5]
XFE_PHC3014_s1_det_16 DELB $PINS O=FE_PHN3014_s1_det_16 I=s1_det[16]
XFE_PHC3011_s1_det_30 DELB $PINS O=FE_PHN3011_s1_det_30 I=s1_det[30]
XFE_PHC3006_s1_det_7 DELB $PINS O=FE_PHN3006_s1_det_7 I=s1_det[7]
XFE_PHC3005_trace_sq_7 DELB $PINS O=FE_PHN3005_trace_sq_7 I=trace_sq[7]
XFE_PHC3000_s1_det_14 DELB $PINS O=FE_PHN3000_s1_det_14 I=s1_det[14]
XFE_PHC2999_s1_det_15 DELB $PINS O=FE_PHN2999_s1_det_15 I=s1_det[15]
XFE_PHC2995_s1_det_9 DELB $PINS O=FE_PHN2995_s1_det_9 I=s1_det[9]
XFE_PHC2988_s1_det_12 DELB $PINS O=s1_det[12] I=FE_PHN2988_s1_det_12
XFE_PHC2987_s1_det_27 DELB $PINS O=FE_PHN2987_s1_det_27 I=s1_det[27]
XFE_PHC2984_s1_det_4 DELB $PINS O=FE_PHN2984_s1_det_4 I=s1_det[4]
XFE_PHC2983_s1_det_21 DELB $PINS O=FE_PHN2983_s1_det_21 I=s1_det[21]
XFE_PHC2982_s1_det_10 DELB $PINS O=FE_PHN2982_s1_det_10 I=s1_det[10]
XFE_PHC2975_s1_det_31 DELB $PINS O=FE_PHN2975_s1_det_31 I=s1_det[31]
XFE_PHC2971_s1_det_6 DELB $PINS O=FE_PHN2971_s1_det_6 I=s1_det[6]
XFE_PHC2965_s1_det_3 DELB $PINS O=FE_PHN2965_s1_det_3 I=s1_det[3]
XFE_PHC2964_s1_det_29 DELB $PINS O=FE_PHN2964_s1_det_29 I=s1_det[29]
XFE_PHC2962_s1_det_22 DELB $PINS O=s1_det[22] I=FE_PHN2962_s1_det_22
XFE_PHC2961_s1_det_5 DELB $PINS O=FE_PHN2961_s1_det_5 I=s1_det[5]
XFE_PHC2959_s1_det_18 DELB $PINS O=FE_PHN2959_s1_det_18 I=s1_det[18]
XFE_PHC2958_s1_det_28 DELB $PINS O=s1_det[28] I=FE_PHN2958_s1_det_28
XFE_PHC2957_s1_det_24 DELB $PINS O=FE_PHN2957_s1_det_24 I=s1_det[24]
XFE_PHC2956_s1_det_17 DELB $PINS O=FE_PHN2956_s1_det_17 I=s1_det[17]
XFE_PHC2955_s1_det_26 DELB $PINS O=FE_PHN2955_s1_det_26 I=s1_det[26]
XFE_PHC2951_trace_sq_19 BUF1S $PINS O=FE_PHN2951_trace_sq_19 I=trace_sq[19]
XFE_PHC2950_s1_det_19 DELB $PINS O=s1_det[19] I=FE_PHN2950_s1_det_19
XFE_PHC2949_s1_det_20 DELB $PINS O=FE_PHN2949_s1_det_20 I=s1_det[20]
XFE_RC_27_0 INV1S $PINS O=FE_RN_7_0 I=n334
XFE_RC_26_1 INV1S $PINS O=FE_RN_8_0 I=n336
XFE_RC_24_1 ND2 $PINS O=FE_RN_10_0 I1=FE_RN_8_0 I2=n335
XFE_RC_23_0 OAI12HS $PINS O=FE_RN_11_0 A1=FE_RN_10_0 B1=FE_RN_8_0 B2=n335
XFE_RC_22_0 ND2S $PINS O=FE_RN_12_1 I1=FE_RN_11_0 I2=FE_RN_7_0
XFE_RC_21_0 ND2 $PINS O=FE_RN_13_1 I1=n336 I2=n335
XFE_RC_20_0 ND2S $PINS O=FE_RN_14_1 I1=FE_RN_13_1 I2=FE_RN_18_1
XFE_RC_19_0 ND2 $PINS O=FE_RN_15_0 I1=FE_RN_14_1 I2=n334
XFE_RC_18_0 ND2S $PINS O=N45 I1=FE_RN_15_0 I2=FE_RN_12_1
XFE_RC_15_1 OR2B1S $PINS O=FE_RN_18_1 I1=n335 B1=FE_RN_8_0
XFE_RC_14_1 ND2S $PINS O=FE_RN_19_0 I1=FE_RN_18_1 I2=n334
XFE_RC_13_1 ND2 $PINS O=n331 I1=FE_RN_19_0 I2=FE_RN_13_1
XFE_RC_3_0 OR2 $PINS O=FE_RN_0_0 I1=FE_RN_61_0 I2=FE_RN_60_0
XFE_RC_2_0 ND2P $PINS O=n397 I1=FE_RN_63_0 I2=FE_RN_0_0
XFE_OCPC2946_n403 BUF1S $PINS O=FE_OCPN2946_n403 I=n403
XFE_OCPC2945_n393 BUF1S $PINS O=FE_OCPN2945_n393 I=n393
XFE_OCPC2943_n654 BUF1S $PINS O=FE_OCPN2943_n654 I=n654
XFE_RC_106_0 NR2 $PINS O=FE_RN_54_0 I1=FE_RN_60_0 I2=FE_RN_61_0
XFE_RC_105_0 INV1S $PINS O=FE_RN_55_0 I=FE_RN_62_0
XFE_RC_104_0 NR2 $PINS O=FE_RN_56_0 I1=FE_RN_54_0 I2=FE_RN_55_0
XFE_RC_101_0 AOI22S $PINS O=FE_RN_59_0 A1=FE_RN_61_0 A2=n401 B1=n402
+ B2=FE_RN_60_0
XFE_RC_100_0 MXL2HS $PINS OB=N32 S=n400 A=FE_RN_59_0 B=FE_RN_56_0
XFE_RC_99_0 INV1S $PINS O=FE_RN_60_0 I=n401
XFE_RC_98_0 INV1S $PINS O=FE_RN_61_0 I=n402
XFE_RC_97_0 OR2 $PINS O=FE_RN_62_0 I1=n401 I2=n402
XFE_RC_96_0 ND2P $PINS O=FE_RN_63_0 I1=FE_RN_62_0 I2=n400
XFE_RC_73_0 OR2 $PINS O=FE_RN_35_0 I1=FE_RN_18_0 I2=FE_RN_12_0
XFE_RC_72_0 ND2P $PINS O=n400 I1=FE_RN_21_0 I2=FE_RN_35_0
XFE_RC_55_0 INV1S $PINS O=FE_RN_12_0 I=n404
XFE_RC_54_0 AN2B1S $PINS O=FE_RN_13_0 I1=n405 B1=FE_RN_12_0
XFE_RC_53_0 AN2B1S $PINS O=FE_RN_14_0 I1=FE_RN_20_0 B1=FE_RN_13_0
XFE_RC_51_0 MXL2HS $PINS OB=FE_RN_16_0 S=n405 A=n404 B=FE_RN_12_0
XFE_RC_50_0 MXL2HS $PINS OB=N31 S=FE_OCPN2946_n403 A=FE_RN_16_0 B=FE_RN_14_0
XFE_RC_48_0 INV1S $PINS O=FE_RN_18_0 I=n405
XFE_RC_46_0 OR2B1S $PINS O=FE_RN_20_0 I1=n405 B1=FE_RN_12_0
XFE_RC_45_0 ND2 $PINS O=FE_RN_21_0 I1=FE_RN_20_0 I2=n403
XFE_RC_43_0 XOR3 $PINS O=N24 I1=n431 I2=n430 I3=n429
XFE_RC_42_0 MAO222 $PINS O=n426 A1=n431 B1=n430 C1=n429
XFE_RC_35_0 AOI12HP $PINS O=n75 A1=n58 B1=n145 B2=n59
XFE_RC_30_0 XOR3 $PINS O=N25 I1=n428 I2=n427 I3=n426
XFE_RC_29_0 MAO222 $PINS O=n423 A1=n428 B1=n427 C1=n426
XFE_RC_26_0 AOI12H $PINS O=n121 A1=n69 B1=n165 B2=n66
XFE_RC_25_0 XOR3 $PINS O=N26 I1=n425 I2=n424 I3=n423
XFE_RC_24_0 MAO222P $PINS O=n420 A1=n425 B1=n424 C1=n423
XFE_RC_15_0 XOR3 $PINS O=N27 I1=n422 I2=n421 I3=n420
XFE_RC_14_0 MAO222T $PINS O=DP_OP_16J1_125_1356/n124 A1=n422 B1=n421 C1=n420
XFE_RC_13_0 OAI12H $PINS O=n84 A1=n119 B1=n121 B2=n118
XFE_RC_11_0 AOI12HP $PINS O=n185 A1=n72 B1=n138 B2=n63
XFE_OFC2743_FE_DBTN75_n296 BUF1CK $PINS O=FE_OFN2743_FE_DBTN75_n296
+ I=FE_OFN2725_FE_DBTN75_n296
XFE_OFC2838_FE_OFN1143_n89 BUF1 $PINS O=FE_OFN4273_FE_OFN1143_n89
+ I=FE_OFN1143_n89
XFE_OFC2725_FE_DBTN75_n296 BUF2 $PINS O=FE_OFN2725_FE_DBTN75_n296
+ I=FE_OFN314_FE_DBTN75_n296
XFE_OFC2815_FE_OFN307_FE_DBTN77_n272 BUF1 $PINS
+ O=FE_OFN4250_FE_OFN307_FE_DBTN77_n272 I=FE_OFN307_FE_DBTN77_n272
XFE_OFC2814_FE_OFN307_FE_DBTN77_n272 BUF1 $PINS
+ O=FE_OFN4249_FE_OFN307_FE_DBTN77_n272 I=FE_OFN307_FE_DBTN77_n272
XFE_OFC2803_FE_DBTN74_n360 BUF1 $PINS O=FE_OFN4238_FE_DBTN74_n360
+ I=FE_DBTN74_n360
XFE_OFC2802_FE_DBTN74_n360 BUF1 $PINS O=FE_OFN4237_FE_DBTN74_n360
+ I=FE_DBTN74_n360
XFE_OFC2713_n280 BUF2 $PINS O=FE_OFN4156_n280 I=FE_OFN304_FE_DBTN79_n280
XFE_OFC2712_n280 INV1S $PINS O=FE_OFN4147_n280 I=FE_OFN304_FE_DBTN79_n280
XFE_OFC2711_n280 INV2 $PINS O=FE_OFN304_FE_DBTN79_n280 I=n280
XFE_OFC2687_n304 BUF1 $PINS O=FE_OFN4150_n304 I=FE_OFN311_FE_DBTN76_n304
XFE_OFC2686_n304 INV1S $PINS O=FE_OFN309_FE_DBTN76_n304
+ I=FE_OFN311_FE_DBTN76_n304
XFE_OFC2685_n304 INV2 $PINS O=FE_OFN311_FE_DBTN76_n304 I=n304
XFE_OFC2673_n280 INV1S $PINS O=FE_OFN4148_n280 I=FE_OFN4146_n280
XFE_OFC2671_n280 INV2 $PINS O=FE_OFN4146_n280 I=FE_OFN4147_n280
XFE_OFC2670_n280 INV1S $PINS O=FE_OFN303_FE_DBTN79_n280 I=FE_OFN4147_n280
XFE_OFC2669_n280 INV1S $PINS O=FE_DBTN79_n280 I=FE_OFN4147_n280
XFE_OFC2667_FE_DBTN78_n275 BUF1 $PINS O=FE_OFN4145_FE_DBTN78_n275
+ I=FE_OFN306_FE_DBTN78_n275
XFE_OFC2666_FE_DBTN78_n275 BUF2 $PINS O=FE_OFN305_FE_DBTN78_n275
+ I=FE_DBTN78_n275
XFE_OFC2665_FE_DBTN78_n275 BUF1 $PINS O=FE_OFN306_FE_DBTN78_n275
+ I=FE_DBTN78_n275
XFE_OFC2633_FE_DBTN77_n272 BUF1 $PINS O=FE_OFN308_FE_DBTN77_n272
+ I=FE_OFN307_FE_DBTN77_n272
XFE_OFC2611_FE_DBTN82_n75 BUF6 $PINS O=FE_DBTN82_n75 I=FE_OFN296_FE_DBTN82_n75
XFE_OFC2600_n360 BUF2 $PINS O=FE_OFN4125_n360 I=FE_DBTN74_n360
XFE_OFC2598_n360 INV1S $PINS O=FE_OFN676_FE_DBTN74_n360
+ I=FE_OFN4237_FE_DBTN74_n360
XFE_OFC2597_n360 INV2 $PINS O=FE_DBTN74_n360 I=n360
XFE_OFC2551_n296 BUF3 $PINS O=FE_OFN314_FE_DBTN75_n296 I=FE_DBTN75_n296
XFE_OFC2550_n296 INV1S $PINS O=FE_OFN313_FE_DBTN75_n296 I=FE_DBTN75_n296
XFE_OFC2549_n296 INV3 $PINS O=FE_DBTN75_n296 I=n296
XFE_OFC2453_n691 BUF1 $PINS O=FE_OFN298_FE_DBTN81_n691
+ I=FE_OFN297_FE_DBTN81_n691
XFE_OFC2452_n691 BUF1 $PINS O=FE_OFN297_FE_DBTN81_n691 I=FE_DBTN81_n691
XFE_OFC2451_n691 INV1S $PINS O=FE_DBTN81_n691 I=n691
XFE_OFC2370_n640 BUF1 $PINS O=FE_OFN667_n700 I=n700
XFE_OFC2369_n640 BUF1 $PINS O=n700 I=FE_OFN669_n700
XFE_OFC2368_n640 INV1S $PINS O=FE_OFN669_n700 I=n640
XFE_OFC2293_n304 BUF1 $PINS O=FE_OFN310_FE_DBTN76_n304 I=FE_OFN4150_n304
XFE_OFC2291_n304 BUF1 $PINS O=FE_DBTN76_n304 I=FE_OFN311_FE_DBTN76_n304
XFE_OFC2247_n272 INV2 $PINS O=FE_OFN307_FE_DBTN77_n272 I=n272
XFE_OFC2244_n275 INV2 $PINS O=FE_DBTN78_n275 I=n275
XFE_OFC2232_FE_DBTN84_N36 BUF1 $PINS O=FE_OFN672_FE_DBTN84_N36
+ I=FE_OFN671_FE_DBTN84_N36
XFE_OFC2231_FE_DBTN84_N36 BUF1 $PINS O=FE_OFN671_FE_DBTN84_N36 I=FE_DBTN84_N36
XFE_OFC2214_n449 BUF1 $PINS O=FE_DBTN80_n449 I=FE_OFN300_FE_DBTN80_n449
XFE_OFC2213_n449 INV2 $PINS O=FE_OFN300_FE_DBTN80_n449 I=n449
XFE_OFC2212_n449 INV1S $PINS O=FE_OFN302_FE_DBTN80_n449 I=n449
XFE_OFC2157_n637 BUF1 $PINS O=FE_OFN1144_n637 I=FE_OFN1179_FE_DBTN71_n637
XFE_OFC2156_n637 BUF1 $PINS O=FE_OFN1179_FE_DBTN71_n637 I=FE_DBTN71_n637
XFE_OFC2155_n637 INV1S $PINS O=FE_DBTN71_n637 I=n637
XFE_OFC2154_n637 BUF1 $PINS O=FE_OFN1180_FE_DBTN71_n637 I=n637
XFE_OFC2134_n89 BUF1 $PINS O=FE_OFN1143_n89 I=n89
XFE_OFC2133_n89 INV1S $PINS O=n696 I=n89
XFE_OFC1800_n75 INV3 $PINS O=FE_OFN296_FE_DBTN82_n75 I=n75
XFE_OFC1176_FE_DBTN73_n695 BUF1 $PINS O=FE_OFN1178_FE_DBTN73_n695
+ I=FE_DBTN73_n695
XFE_OFC1144_n695 BUF1 $PINS O=FE_OFN1146_n695 I=n695
XFE_OFC1143_n653 BUF1 $PINS O=FE_OFN1145_n653 I=n653
XFE_OFC999_n168 BUF1 $PINS O=FE_OFN1001_n168 I=n168
XFE_OFC880_n365 INV1S $PINS O=FE_OFN882_n365 I=FE_OFN880_n365
XFE_OFC879_n365 INV1S $PINS O=FE_OFN881_n365 I=FE_OFN880_n365
XFE_OFC878_n365 INV1S $PINS O=FE_OFN880_n365 I=n365
XFE_OFC672_FE_DBTN83_n654 BUF1 $PINS O=FE_OFN674_FE_DBTN83_n654
+ I=FE_OFN673_FE_DBTN83_n654
XFE_OFC671_FE_DBTN83_n654 BUF1 $PINS O=FE_OFN673_FE_DBTN83_n654
+ I=FE_DBTN83_n654
XFE_OFC668_n701 BUF1 $PINS O=FE_OFN670_n701 I=n701
XFE_OFC664_n654 BUF1 $PINS O=FE_OFN666_n654 I=n654
XFE_OFC314_FE_DBTN72_n655 BUF1 $PINS O=FE_OFN316_FE_DBTN72_n655
+ I=FE_OFN315_FE_DBTN72_n655
XFE_OFC313_FE_DBTN72_n655 BUF1 $PINS O=FE_OFN315_FE_DBTN72_n655
+ I=FE_DBTN72_n655
XFE_OFC221_i_reset_n_i BUF1 $PINS O=FE_OFN223_i_reset_n_i
+ I=FE_OFN179_i_reset_n_i
XFE_OFC177_i_reset_n_i BUF1 $PINS O=FE_OFN179_i_reset_n_i
+ I=FE_OFN134_i_reset_n_i
XFE_OFC176_i_reset_n_i BUF1 $PINS O=FE_OFN178_i_reset_n_i
+ I=FE_OFN134_i_reset_n_i
XFE_OFC171_i_reset_n_i BUF1 $PINS O=FE_OFN173_i_reset_n_i
+ I=FE_OFN123_i_reset_n_i
XFE_OFC170_i_reset_n_i BUF1 $PINS O=FE_OFN172_i_reset_n_i
+ I=FE_OFN123_i_reset_n_i
XFE_OFC132_i_reset_n_i BUF1 $PINS O=FE_OFN134_i_reset_n_i
+ I=FE_OFN87_i_reset_n_i
XFE_OFC131_i_reset_n_i BUF1 $PINS O=FE_OFN133_i_reset_n_i
+ I=FE_OFN86_i_reset_n_i
XFE_OFC130_i_reset_n_i BUF1 $PINS O=FE_OFN132_i_reset_n_i
+ I=FE_OFN86_i_reset_n_i
XFE_OFC121_i_reset_n_i BUF1 $PINS O=FE_OFN123_i_reset_n_i
+ I=FE_OFN78_i_reset_n_i
XFE_OFC120_i_reset_n_i BUF1 $PINS O=FE_OFN122_i_reset_n_i
+ I=FE_OFN78_i_reset_n_i
XFE_OFC119_i_reset_n_i BUF1 $PINS O=FE_OFN121_i_reset_n_i
+ I=FE_OFN77_i_reset_n_i
XFE_OFC85_i_reset_n_i BUF1 $PINS O=FE_OFN87_i_reset_n_i I=FE_OFN51_i_reset_n_i
XFE_OFC84_i_reset_n_i BUF1 $PINS O=FE_OFN86_i_reset_n_i I=FE_OFN49_i_reset_n_i
XFE_OFC83_i_reset_n_i BUF1 $PINS O=FE_OFN85_i_reset_n_i I=FE_OFN49_i_reset_n_i
XFE_OFC82_i_reset_n_i BUF1 $PINS O=FE_OFN84_i_reset_n_i I=FE_OFN48_i_reset_n_i
XFE_OFC77_i_reset_n_i BUF1 $PINS O=FE_OFN78_i_reset_n_i I=FE_OFN43_i_reset_n_i
XFE_OFC76_i_reset_n_i BUF1 $PINS O=FE_OFN77_i_reset_n_i I=FE_OFN42_i_reset_n_i
XFE_OFC50_i_reset_n_i BUF1 $PINS O=FE_OFN51_i_reset_n_i I=FE_OFN23_i_reset_n_i
XFE_OFC49_i_reset_n_i BUF1 $PINS O=FE_OFN50_i_reset_n_i I=FE_OFN5_i_reset_n_i
XFE_OFC48_i_reset_n_i BUF1 $PINS O=FE_OFN49_i_reset_n_i I=FE_OFN21_i_reset_n_i
XFE_OFC47_i_reset_n_i BUF1 $PINS O=FE_OFN48_i_reset_n_i I=FE_OFN21_i_reset_n_i
XFE_OFC42_i_reset_n_i BUF1 $PINS O=FE_OFN43_i_reset_n_i I=FE_OFN17_i_reset_n_i
XFE_OFC41_i_reset_n_i BUF1 $PINS O=FE_OFN42_i_reset_n_i I=FE_OFN17_i_reset_n_i
XFE_OFC22_i_reset_n_i BUF1 $PINS O=FE_OFN23_i_reset_n_i I=FE_OFN1_i_reset_n_i
XFE_OFC20_i_reset_n_i BUF1 $PINS O=FE_OFN21_i_reset_n_i I=FE_OFN6_i_reset_n_i
XFE_OFC19_i_reset_n_i BUF1 $PINS O=FE_OFN20_i_reset_n_i I=FE_OFN6_i_reset_n_i
XFE_OFC16_i_reset_n_i INV1S $PINS O=FE_OFN17_i_reset_n_i I=FE_OFN0_i_reset_n_i
XFE_OFC5_i_reset_n_i INV1S $PINS O=FE_OFN6_i_reset_n_i I=rst_n
XFE_DBTC84_N36 INV1S $PINS O=FE_DBTN84_N36 I=N36
XFE_DBTC83_n654 INV1S $PINS O=FE_DBTN83_n654 I=FE_OFN666_n654
XFE_DBTC73_n695 INV1S $PINS O=FE_DBTN73_n695 I=FE_OFN1146_n695
XFE_DBTC72_n655 INV1S $PINS O=FE_DBTN72_n655 I=n655
Xs1_P0_reg[17] QDFFRBN $PINS Q=s1_P0[17] D=n719 CK=clk_clone2
+ RB=FE_OFN43_i_reset_n_i
Xs1_P0_reg[16] QDFFRBN $PINS Q=s1_P0[16] D=N17 CK=clk_clone4
+ RB=FE_OFN43_i_reset_n_i
Xs1_P0_reg[15] QDFFRBN $PINS Q=s1_P0[15] D=N16 CK=clk_clone4
+ RB=FE_OFN43_i_reset_n_i
Xs1_P0_reg[14] QDFFRBN $PINS Q=s1_P0[14] D=N15 CK=clk_clone4
+ RB=FE_OFN42_i_reset_n_i
Xs1_P0_reg[13] QDFFRBN $PINS Q=s1_P0[13] D=N14 CK=clk_clone4
+ RB=FE_OFN42_i_reset_n_i
Xs1_P0_reg[12] QDFFRBN $PINS Q=s1_P0[12] D=N13 CK=clk_clone4
+ RB=FE_OFN77_i_reset_n_i
Xs1_P0_reg[11] QDFFRBN $PINS Q=s1_P0[11] D=N12 CK=clk_clone4
+ RB=FE_OFN121_i_reset_n_i
Xs1_P0_reg[10] QDFFRBN $PINS Q=s1_P0[10] D=N11 CK=clk_clone4
+ RB=FE_OFN121_i_reset_n_i
Xs1_P0_reg[8] QDFFRBN $PINS Q=trace_sq[8] D=N9 CK=clk_clone3
+ RB=FE_OFN172_i_reset_n_i
Xs1_P0_reg[7] QDFFRBN $PINS Q=trace_sq[7] D=N8 CK=clk_clone3
+ RB=FE_OFN121_i_reset_n_i
Xs1_P0_reg[6] QDFFRBN $PINS Q=trace_sq[6] D=N7 CK=clk_clone3
+ RB=FE_OFN97_i_reset_n_i
Xs1_P0_reg[5] QDFFRBN $PINS Q=trace_sq[5] D=N6 CK=clk_clone3
+ RB=FE_OFN16_i_reset_n_i
Xs1_P2_reg[15] QDFFRBN $PINS Q=s1_P2[15] D=N51 CK=clk_clone2
+ RB=FE_OFN21_i_reset_n_i
Xs1_P2_reg[14] QDFFRBN $PINS Q=FE_PHN3217_s1_P2_14 D=N50 CK=clk_clone2
+ RB=FE_OFN21_i_reset_n_i
Xs1_P2_reg[13] QDFFRBN $PINS Q=s1_P2[13] D=N49 CK=clk_clone1
+ RB=FE_OFN21_i_reset_n_i
Xs1_P2_reg[12] QDFFRBN $PINS Q=s1_P2[12] D=N48 CK=clk_clone2
+ RB=FE_OFN6_i_reset_n_i
Xs1_P2_reg[11] QDFFRBN $PINS Q=s1_P2[11] D=N47 CK=clk_clone2
+ RB=FE_OFN50_i_reset_n_i
Xs1_P2_reg[10] QDFFRBN $PINS Q=s1_P2[10] D=N46 CK=clk_clone2
+ RB=FE_OFN50_i_reset_n_i
Xs1_P2_reg[9] QDFFRBN $PINS Q=FE_PHN3259_s1_P2_9 D=N45 CK=clk_clone2
+ RB=FE_OFN50_i_reset_n_i
Xs1_P2_reg[8] QDFFRBN $PINS Q=s1_P2[8] D=N44 CK=clk_clone2
+ RB=FE_OFN5_i_reset_n_i
Xs1_P2_reg[7] QDFFRBN $PINS Q=s1_P2[7] D=N43 CK=clk_clone2
+ RB=FE_OFN23_i_reset_n_i
Xs1_P2_reg[6] QDFFRBN $PINS Q=s1_P2[6] D=N42 CK=clk_clone2
+ RB=FE_OFN23_i_reset_n_i
Xs1_P2_reg[4] QDFFRBN $PINS Q=s1_P2[4] D=N40 CK=clk_clone2
+ RB=FE_OFN23_i_reset_n_i
Xs1_P2_reg[3] QDFFRBN $PINS Q=s1_P2[3] D=N39 CK=clk_clone2
+ RB=FE_OFN51_i_reset_n_i
Xs1_P2_reg[2] QDFFRBN $PINS Q=s1_P2[2] D=n54 CK=clk_clone2
+ RB=FE_OFN87_i_reset_n_i
Xs1_P2_reg[0] QDFFRBN $PINS Q=s1_P2[0] D=N36 CK=clk_clone2
+ RB=FE_OFN87_i_reset_n_i
Xs1_P1_reg[16] QDFFRBN $PINS Q=s1_P1[16] D=N35 CK=clk_clone2
+ RB=FE_OFN1_i_reset_n_i
Xs1_P1_reg[15] QDFFRBN $PINS Q=s1_P1[15] D=N34 CK=clk_clone2
+ RB=FE_OFN5_i_reset_n_i
Xs1_P1_reg[14] QDFFRBN $PINS Q=s1_P1[14] D=N33 CK=clk_clone2
+ RB=FE_OFN1_i_reset_n_i
Xs1_P1_reg[13] QDFFRBN $PINS Q=s1_P1[13] D=N32 CK=clk_clone2
+ RB=FE_OFN1_i_reset_n_i
Xs1_P1_reg[12] QDFFRBN $PINS Q=s1_P1[12] D=N31 CK=clk_clone2
+ RB=FE_OFN23_i_reset_n_i
Xs1_P1_reg[11] QDFFRBN $PINS Q=s1_P1[11] D=N30 CK=clk_clone2
+ RB=FE_OFN51_i_reset_n_i
Xs1_P1_reg[10] QDFFRBN $PINS Q=s1_P1[10] D=N29 CK=clk_clone2
+ RB=FE_OFN51_i_reset_n_i
Xs1_P1_reg[9] QDFFRBN $PINS Q=s1_P1[9] D=N28 CK=clk_clone2
+ RB=FE_OFN51_i_reset_n_i
Xs1_P1_reg[8] QDFFRBN $PINS Q=s1_P1[8] D=N27 CK=clk_clone2
+ RB=FE_OFN51_i_reset_n_i
Xs1_P1_reg[7] QDFFRBN $PINS Q=s1_P1[7] D=N26 CK=clk_clone2
+ RB=FE_OFN87_i_reset_n_i
Xs1_P1_reg[5] QDFFRBN $PINS Q=s1_P1[5] D=N24 CK=clk_clone4
+ RB=FE_OFN17_i_reset_n_i
Xs1_P1_reg[4] QDFFRBN $PINS Q=s1_P1[4] D=N23 CK=clk_clone4
+ RB=FE_OFN42_i_reset_n_i
Xs1_P1_reg[3] QDFFRBN $PINS Q=s1_P1[3] D=N22 CK=clk_clone4
+ RB=FE_OFN42_i_reset_n_i
Xs1_P1_reg[2] QDFFRBN $PINS Q=s1_P1[2] D=N21 CK=clk_clone4
+ RB=FE_OFN42_i_reset_n_i
Xs1_P1_reg[1] QDFFRBN $PINS Q=s1_P1[1] D=N20 CK=clk_clone4
+ RB=FE_OFN77_i_reset_n_i
Xs1_P1_reg[0] QDFFRBN $PINS Q=s1_P1[0] D=N19 CK=clk_clone4
+ RB=FE_OFN77_i_reset_n_i
Xs1_det_reg[31] QDFFRBN $PINS Q=s1_det[31] D=det[31] CK=clk_clone1
+ RB=FE_OFN76_i_reset_n_i
Xs1_det_reg[30] QDFFRBN $PINS Q=s1_det[30] D=det[30] CK=clk_clone1
+ RB=FE_OFN86_i_reset_n_i
Xs1_det_reg[29] QDFFRBN $PINS Q=s1_det[29] D=det[29] CK=clk_clone1
+ RB=FE_OFN132_i_reset_n_i
Xs1_det_reg[28] QDFFRBN $PINS Q=FE_PHN2958_s1_det_28 D=det[28] CK=clk_clone1
+ RB=FE_OFN132_i_reset_n_i
Xs1_det_reg[27] QDFFRBN $PINS Q=s1_det[27] D=det[27] CK=clk_clone1
+ RB=FE_OFN132_i_reset_n_i
Xs1_det_reg[26] QDFFRBN $PINS Q=s1_det[26] D=det[26] CK=clk_clone1
+ RB=FE_OFN132_i_reset_n_i
Xs1_det_reg[25] QDFFRBN $PINS Q=FE_PHN3030_s1_det_25 D=det[25] CK=clk_clone1
+ RB=FE_OFN85_i_reset_n_i
Xs1_det_reg[24] QDFFRBN $PINS Q=s1_det[24] D=det[24] CK=clk_clone1
+ RB=FE_OFN49_i_reset_n_i
Xs1_det_reg[22] QDFFRBN $PINS Q=FE_PHN2962_s1_det_22 D=det[22] CK=clk_clone1
+ RB=FE_OFN49_i_reset_n_i
Xs1_det_reg[21] QDFFRBN $PINS Q=s1_det[21] D=det[21] CK=clk_clone1
+ RB=FE_OFN49_i_reset_n_i
Xs1_det_reg[20] QDFFRBN $PINS Q=s1_det[20] D=det[20] CK=clk_clone1
+ RB=FE_OFN48_i_reset_n_i
Xs1_det_reg[19] QDFFRBN $PINS Q=FE_PHN2950_s1_det_19 D=det[19] CK=clk_clone1
+ RB=FE_OFN48_i_reset_n_i
Xs1_det_reg[18] QDFFRBN $PINS Q=s1_det[18] D=det[18] CK=clk_clone1
+ RB=FE_OFN48_i_reset_n_i
Xs1_det_reg[17] QDFFRBN $PINS Q=s1_det[17] D=det[17] CK=clk_clone1
+ RB=FE_OFN84_i_reset_n_i
Xs1_det_reg[16] QDFFRBN $PINS Q=s1_det[16] D=det[16] CK=clk_clone2
+ RB=FE_OFN84_i_reset_n_i
Xs1_det_reg[15] QDFFRBN $PINS Q=s1_det[15] D=det[15] CK=clk_clone2
+ RB=FE_OFN223_i_reset_n_i
Xs1_det_reg[14] QDFFRBN $PINS Q=s1_det[14] D=det[14] CK=clk_clone2
+ RB=FE_OFN223_i_reset_n_i
Xs1_det_reg[13] QDFFRBN $PINS Q=s1_det[13] D=det[13] CK=clk_clone4
+ RB=FE_OFN223_i_reset_n_i
Xs1_det_reg[12] QDFFRBN $PINS Q=FE_PHN2988_s1_det_12 D=det[12] CK=clk_clone4
+ RB=FE_OFN179_i_reset_n_i
Xs1_det_reg[11] QDFFRBN $PINS Q=s1_det[11] D=det[11] CK=clk_clone4
+ RB=FE_OFN179_i_reset_n_i
Xs1_det_reg[10] QDFFRBN $PINS Q=s1_det[10] D=det[10] CK=clk_clone4
+ RB=FE_OFN134_i_reset_n_i
Xs1_det_reg[9] QDFFRBN $PINS Q=s1_det[9] D=det[9] CK=clk_clone4
+ RB=FE_OFN122_i_reset_n_i
Xs1_det_reg[7] QDFFRBN $PINS Q=s1_det[7] D=det[7] CK=clk_clone4
+ RB=FE_OFN122_i_reset_n_i
Xs1_det_reg[6] QDFFRBN $PINS Q=s1_det[6] D=det[6] CK=clk_clone4
+ RB=FE_OFN123_i_reset_n_i
Xs1_det_reg[5] QDFFRBN $PINS Q=s1_det[5] D=det[5] CK=clk_clone4
+ RB=FE_OFN123_i_reset_n_i
Xs1_det_reg[4] QDFFRBN $PINS Q=s1_det[4] D=det[4] CK=clk_clone4
+ RB=FE_OFN123_i_reset_n_i
Xs1_det_reg[3] QDFFRBN $PINS Q=s1_det[3] D=det[3] CK=clk_clone3
+ RB=FE_OFN172_i_reset_n_i
Xs1_det_reg[2] QDFFRBN $PINS Q=s1_det[2] D=det[2] CK=clk_clone3
+ RB=FE_OFN172_i_reset_n_i
Xs1_det_reg[1] QDFFRBN $PINS Q=s1_det[1] D=FE_PHN3186_det_1 CK=clk_clone3
+ RB=FE_OFN14_i_reset_n_i
Xtrace_sq_reg_reg[33] QDFFRBN $PINS Q=trace_sq_reg[33] D=trace_sq[33]
+ CK=clk_clone1 RB=FE_OFN85_i_reset_n_i
Xtrace_sq_reg_reg[32] QDFFRBN $PINS Q=trace_sq_reg[32] D=trace_sq[32]
+ CK=clk_clone1 RB=FE_OFN85_i_reset_n_i
Xtrace_sq_reg_reg[31] QDFFRBN $PINS Q=trace_sq_reg[31] D=trace_sq[31]
+ CK=clk_clone2 RB=FE_OFN20_i_reset_n_i
Xtrace_sq_reg_reg[30] QDFFRBN $PINS Q=trace_sq_reg[30] D=trace_sq[30]
+ CK=clk_clone2 RB=FE_OFN20_i_reset_n_i
Xtrace_sq_reg_reg[29] QDFFRBN $PINS Q=trace_sq_reg[29] D=trace_sq[29]
+ CK=clk_clone2 RB=FE_OFN20_i_reset_n_i
Xtrace_sq_reg_reg[28] QDFFRBN $PINS Q=trace_sq_reg[28] D=FE_PHN3294_trace_sq_28
+ CK=clk_clone2 RB=FE_OFN6_i_reset_n_i
Xtrace_sq_reg_reg[27] QDFFRBN $PINS Q=trace_sq_reg[27] D=n721 CK=clk_clone2
+ RB=FE_OFN6_i_reset_n_i
Xtrace_sq_reg_reg[25] QDFFRBN $PINS Q=trace_sq_reg[25] D=FE_PHN3278_trace_sq_25
+ CK=clk_clone2 RB=FE_OFN50_i_reset_n_i
Xtrace_sq_reg_reg[24] QDFFRBN $PINS Q=trace_sq_reg[24] D=FE_PHN3241_trace_sq_24
+ CK=clk_clone2 RB=FE_OFN50_i_reset_n_i
Xtrace_sq_reg_reg[23] QDFFRBN $PINS Q=trace_sq_reg[23] D=trace_sq[23]
+ CK=clk_clone2 RB=FE_OFN6_i_reset_n_i
Xtrace_sq_reg_reg[22] QDFFRBN $PINS Q=trace_sq_reg[22] D=trace_sq[22]
+ CK=clk_clone2 RB=FE_OFN178_i_reset_n_i
Xtrace_sq_reg_reg[21] QDFFRBN $PINS Q=trace_sq_reg[21] D=trace_sq[21]
+ CK=clk_clone2 RB=FE_OFN178_i_reset_n_i
Xtrace_sq_reg_reg[20] QDFFRBN $PINS Q=trace_sq_reg[20] D=FE_PHN3250_trace_sq_20
+ CK=clk_clone2 RB=FE_OFN178_i_reset_n_i
Xtrace_sq_reg_reg[19] QDFFRBN $PINS Q=trace_sq_reg[19] D=FE_PHN2951_trace_sq_19
+ CK=clk_clone2 RB=FE_OFN178_i_reset_n_i
Xtrace_sq_reg_reg[18] QDFFRBN $PINS Q=trace_sq_reg[18] D=trace_sq[18]
+ CK=clk_clone2 RB=FE_OFN134_i_reset_n_i
Xtrace_sq_reg_reg[17] QDFFRBN $PINS Q=trace_sq_reg[17] D=FE_PHN3223_trace_sq_17
+ CK=clk_clone2 RB=FE_OFN87_i_reset_n_i
Xtrace_sq_reg_reg[16] QDFFRBN $PINS Q=trace_sq_reg[16] D=FE_PHN3232_trace_sq_16
+ CK=clk_clone2 RB=FE_OFN87_i_reset_n_i
Xtrace_sq_reg_reg[15] QDFFRBN $PINS Q=trace_sq_reg[15] D=FE_PHN3226_trace_sq_15
+ CK=clk_clone4 RB=FE_OFN78_i_reset_n_i
Xtrace_sq_reg_reg[14] QDFFRBN $PINS Q=trace_sq_reg[14] D=FE_PHN3269_trace_sq_14
+ CK=clk_clone4 RB=FE_OFN43_i_reset_n_i
Xtrace_sq_reg_reg[13] QDFFRBN $PINS Q=trace_sq_reg[13] D=FE_PHN3264_trace_sq_13
+ CK=clk_clone4 RB=FE_OFN78_i_reset_n_i
Xtrace_sq_reg_reg[12] QDFFRBN $PINS Q=trace_sq_reg[12] D=FE_PHN3234_trace_sq_12
+ CK=clk_clone4 RB=FE_OFN77_i_reset_n_i
Xtrace_sq_reg_reg[10] QDFFRBN $PINS Q=trace_sq_reg[10] D=FE_PHN3168_trace_sq_10
+ CK=clk_clone4 RB=FE_OFN121_i_reset_n_i
Xtrace_sq_reg_reg[9] QDFFRBN $PINS Q=trace_sq_reg[9] D=FE_PHN3139_trace_sq_9
+ CK=clk_clone4 RB=FE_OFN173_i_reset_n_i
Xtrace_sq_reg_reg[8] QDFFRBN $PINS Q=trace_sq_reg[8] D=FE_PHN3072_trace_sq_8
+ CK=clk_clone3 RB=FE_OFN172_i_reset_n_i
Xtrace_sq_reg_reg[7] QDFFRBN $PINS Q=trace_sq_reg[7] D=FE_PHN3005_trace_sq_7
+ CK=clk_clone3 RB=FE_OFN97_i_reset_n_i
Xtrace_sq_reg_reg[6] QDFFRBN $PINS Q=trace_sq_reg[6] D=FE_PHN3071_trace_sq_6
+ CK=clk_clone3 RB=FE_OFN97_i_reset_n_i
Xtrace_sq_reg_reg[5] QDFFRBN $PINS Q=trace_sq_reg[5] D=FE_PHN3024_trace_sq_5
+ CK=clk_clone3 RB=FE_OFN16_i_reset_n_i
Xdet_reg_reg[32] QDFFRBN $PINS Q=det_reg[32] D=FE_PHN3146_n4365 CK=clk
+ RB=FE_OFN110_i_reset_n_i
Xdet_reg_reg[31] QDFFRBN $PINS Q=det_reg[31] D=FE_PHN2975_s1_det_31
+ CK=clk_clone1 RB=FE_OFN76_i_reset_n_i
Xdet_reg_reg[30] QDFFRBN $PINS Q=det_reg[30] D=FE_PHN3011_s1_det_30
+ CK=clk_clone1 RB=FE_OFN86_i_reset_n_i
Xdet_reg_reg[29] QDFFRBN $PINS Q=det_reg[29] D=FE_PHN2964_s1_det_29
+ CK=clk_clone1 RB=FE_OFN86_i_reset_n_i
Xdet_reg_reg[28] QDFFRBN $PINS Q=det_reg[28] D=s1_det[28] CK=clk_clone1
+ RB=FE_OFN133_i_reset_n_i
Xdet_reg_reg[27] QDFFRBN $PINS Q=det_reg[27] D=FE_PHN2987_s1_det_27
+ CK=clk_clone1 RB=FE_OFN132_i_reset_n_i
Xdet_reg_reg[26] QDFFRBN $PINS Q=det_reg[26] D=FE_PHN2955_s1_det_26
+ CK=clk_clone1 RB=FE_OFN133_i_reset_n_i
Xdet_reg_reg[25] QDFFRBN $PINS Q=det_reg[25] D=s1_det[25] CK=clk_clone1
+ RB=FE_OFN85_i_reset_n_i
Xdet_reg_reg[22] QDFFRBN $PINS Q=det_reg[22] D=s1_det[22] CK=clk_clone1
+ RB=FE_OFN48_i_reset_n_i
Xdet_reg_reg[21] QDFFRBN $PINS Q=det_reg[21] D=FE_PHN2983_s1_det_21
+ CK=clk_clone1 RB=FE_OFN48_i_reset_n_i
Xdet_reg_reg[20] QDFFRBN $PINS Q=det_reg[20] D=FE_PHN2949_s1_det_20
+ CK=clk_clone2 RB=FE_OFN84_i_reset_n_i
Xdet_reg_reg[19] QDFFRBN $PINS Q=det_reg[19] D=s1_det[19] CK=clk_clone2
+ RB=FE_OFN84_i_reset_n_i
Xdet_reg_reg[18] QDFFRBN $PINS Q=det_reg[18] D=FE_PHN2959_s1_det_18
+ CK=clk_clone1 RB=FE_OFN84_i_reset_n_i
Xdet_reg_reg[17] QDFFRBN $PINS Q=det_reg[17] D=FE_PHN2956_s1_det_17
+ CK=clk_clone2 RB=FE_OFN84_i_reset_n_i
Xdet_reg_reg[16] QDFFRBN $PINS Q=det_reg[16] D=FE_PHN3014_s1_det_16
+ CK=clk_clone2 RB=FE_OFN223_i_reset_n_i
Xdet_reg_reg[15] QDFFRBN $PINS Q=det_reg[15] D=FE_PHN2999_s1_det_15
+ CK=clk_clone2 RB=FE_OFN223_i_reset_n_i
Xdet_reg_reg[14] QDFFRBN $PINS Q=det_reg[14] D=FE_PHN3000_s1_det_14
+ CK=clk_clone2 RB=FE_OFN223_i_reset_n_i
Xdet_reg_reg[13] QDFFRBN $PINS Q=det_reg[13] D=FE_PHN3042_s1_det_13
+ CK=clk_clone4 RB=FE_OFN179_i_reset_n_i
Xdet_reg_reg[12] QDFFRBN $PINS Q=det_reg[12] D=s1_det[12] CK=clk_clone4
+ RB=FE_OFN179_i_reset_n_i
Xdet_reg_reg[11] QDFFRBN $PINS Q=det_reg[11] D=FE_PHN3059_s1_det_11
+ CK=clk_clone4 RB=FE_OFN134_i_reset_n_i
Xdet_reg_reg[10] QDFFRBN $PINS Q=det_reg[10] D=FE_PHN2982_s1_det_10
+ CK=clk_clone4 RB=FE_OFN134_i_reset_n_i
Xdet_reg_reg[9] QDFFRBN $PINS Q=det_reg[9] D=FE_PHN2995_s1_det_9 CK=clk_clone4
+ RB=FE_OFN122_i_reset_n_i
Xdet_reg_reg[7] QDFFRBN $PINS Q=det_reg[7] D=FE_PHN3006_s1_det_7 CK=clk_clone4
+ RB=FE_OFN78_i_reset_n_i
Xdet_reg_reg[6] QDFFRBN $PINS Q=det_reg[6] D=FE_PHN2971_s1_det_6 CK=clk_clone4
+ RB=FE_OFN78_i_reset_n_i
Xdet_reg_reg[5] QDFFRBN $PINS Q=det_reg[5] D=FE_PHN2961_s1_det_5 CK=clk_clone4
+ RB=FE_OFN123_i_reset_n_i
Xdet_reg_reg[4] QDFFRBN $PINS Q=det_reg[4] D=FE_PHN2984_s1_det_4 CK=clk_clone4
+ RB=FE_OFN173_i_reset_n_i
Xdet_reg_reg[3] QDFFRBN $PINS Q=det_reg[3] D=FE_PHN2965_s1_det_3 CK=clk_clone3
+ RB=FE_OFN172_i_reset_n_i
Xdet_reg_reg[2] QDFFRBN $PINS Q=det_reg[2] D=FE_PHN3073_s1_det_2 CK=clk_clone3
+ RB=FE_OFN14_i_reset_n_i
Xdet_reg_reg[1] QDFFRBN $PINS Q=det_reg[1] D=FE_PHN3068_s1_det_1 CK=clk_clone3
+ RB=FE_OFN14_i_reset_n_i
Xintadd_60/U10 FA1S $PINS S=N8 CO=intadd_60/n9 A=intadd_60/B[0]
+ B=intadd_60/A[0] CI=intadd_60/CI
Xintadd_60/U9 FA1S $PINS S=N9 CO=intadd_60/n8 A=intadd_60/B[1] B=intadd_60/A[1]
+ CI=intadd_60/n9
Xintadd_60/U8 FA1S $PINS S=N10 CO=intadd_60/n7 A=intadd_60/B[2]
+ B=intadd_60/A[2] CI=intadd_60/n8
XR_116 DFFSBN $PINS Q=n725 D=n723 CK=clk_clone3 SB=FE_OFN2_i_reset_n_i
Xintadd_62/U2 FA1S $PINS S=FE_PHN3235_trace_sq_26 CO=intadd_62/n1 A=s1_P1[16]
+ B=s1_P2[8] CI=intadd_62/n2
Xintadd_62/U3 FA1S $PINS S=trace_sq[25] CO=intadd_62/n2 A=s1_P1[15] B=s1_P2[7]
+ CI=intadd_62/n3
Xintadd_62/U4 FA1S $PINS S=trace_sq[24] CO=intadd_62/n3 A=s1_P1[14] B=s1_P2[6]
+ CI=intadd_62/n4
Xintadd_62/U5 FA1S $PINS S=trace_sq[23] CO=intadd_62/n4 A=s1_P1[13] B=s1_P2[5]
+ CI=intadd_62/n5
Xintadd_62/U6 FA1S $PINS S=trace_sq[22] CO=intadd_62/n5 A=s1_P1[12] B=s1_P2[4]
+ CI=intadd_62/n6
Xintadd_62/U7 FA1S $PINS S=FE_PHN3258_trace_sq_21 CO=intadd_62/n6 A=s1_P1[11]
+ B=s1_P2[3] CI=intadd_62/n7
Xintadd_62/U8 FA1S $PINS S=trace_sq[20] CO=intadd_62/n7 A=s1_P1[10] B=s1_P2[2]
+ CI=intadd_62/CI
Xintadd_61/U3 FA1S $PINS S=trace_sq[17] CO=intadd_61/n2 A=s1_P1[7] B=s1_P0[17]
+ CI=intadd_61/n3
Xintadd_61/U4 FA1S $PINS S=trace_sq[16] CO=intadd_61/n3 A=s1_P1[6] B=s1_P0[16]
+ CI=intadd_61/n4
Xintadd_61/U5 FA1S $PINS S=trace_sq[15] CO=intadd_61/n4 A=s1_P1[5] B=s1_P0[15]
+ CI=intadd_61/n5
Xintadd_61/U6 FA1S $PINS S=trace_sq[14] CO=intadd_61/n5 A=s1_P1[4] B=s1_P0[14]
+ CI=intadd_61/n6
Xintadd_61/U7 FA1S $PINS S=trace_sq[13] CO=intadd_61/n6 A=s1_P1[3] B=s1_P0[13]
+ CI=intadd_61/n7
Xintadd_61/U8 FA1S $PINS S=trace_sq[12] CO=intadd_61/n7 A=s1_P1[2] B=s1_P0[12]
+ CI=intadd_61/n8
Xintadd_61/U9 FA1S $PINS S=trace_sq[11] CO=intadd_61/n8 A=s1_P1[1] B=s1_P0[11]
+ CI=n720
Xintadd_61/U2 FA1S $PINS S=FE_PHN3240_trace_sq_18 CO=intadd_61/n1 A=s1_P1[8]
+ B=s1_P2[0] CI=intadd_61/n2
Xintadd_60/U2 FA1 $PINS S=N16 CO=intadd_60/n1 A=intadd_60/B[8] B=intadd_60/A[8]
+ CI=intadd_60/n2
Xintadd_60/U3 FA1S $PINS S=N15 CO=intadd_60/n2 A=intadd_60/B[7]
+ B=intadd_60/A[7] CI=intadd_60/n3
Xintadd_60/U4 FA1S $PINS S=N14 CO=intadd_60/n3 A=intadd_60/B[6]
+ B=intadd_60/A[6] CI=intadd_60/n4
Xintadd_60/U5 FA1 $PINS S=N13 CO=intadd_60/n4 A=intadd_60/B[5] B=intadd_60/A[5]
+ CI=intadd_60/n5
Xintadd_60/U6 FA1 $PINS S=N12 CO=intadd_60/n5 A=intadd_60/B[4] B=intadd_60/A[4]
+ CI=intadd_60/n6
Xintadd_60/U7 FA1S $PINS S=N11 CO=intadd_60/n6 A=intadd_60/B[3]
+ B=intadd_60/A[3] CI=intadd_60/n7
XDP_OP_16J1_125_1356/U107 FACS1S $PINS S=N29 CO0=DP_OP_16J1_125_1356/n121
+ CO1=DP_OP_16J1_125_1356/n120 A=DP_OP_16J1_125_1356/n162
+ B=DP_OP_16J1_125_1356/n153 CI0=DP_OP_16J1_125_1356/n123
+ CI1=DP_OP_16J1_125_1356/n122 CS=DP_OP_16J1_125_1356/n124
XU3 FA1 $PINS S=DP_OP_16J1_125_1356/n153 CO=n390 A=n445 B=n444 CI=n443
XU4 FA1 $PINS S=n418 CO=DP_OP_16J1_125_1356/n162 A=n448 B=n447 CI=n446
XU5 FA1 $PINS S=n427 CO=n425 A=n212 B=n211 CI=n210
XU7 INV1S $PINS O=n139 I=n138
XU37 INV1S $PINS O=n96 I=n155
XU41 FA1 $PINS S=n413 CO=n417 A=n260 B=n259 CI=n258
XU42 INV1S $PINS O=n365 I=FE_OFN670_n701
XU43 ND2 $PINS O=n168 I1=Ix2[0] I2=Iy2[0]
XU45 FA1 $PINS S=n444 CO=n387 A=n257 B=n256 CI=n255
XU46 FA1 $PINS S=n433 CO=n431 A=n225 B=n224 CI=n223
XU48 FA1 $PINS S=N50 CO=N51 A=FE_OFN676_FE_DBTN74_n360 B=n319 CI=n318
XU49 INV1S $PINS O=n317 I=n329
XU50 ND2S $PINS O=n327 I1=n316 I2=n315
XU51 AOI12HS $PINS O=n98 A1=n96 B1=FE_DBTN82_n75 B2=n97
XU52 AOI12HS $PINS O=n128 A1=n126 B1=FE_DBTN82_n75 B2=n127
XU53 AOI12HS $PINS O=n156 A1=n161 B1=FE_DBTN82_n75 B2=n158
XU54 XNR2HS $PINS O=n640 I1=n187 I2=n186
XU55 XOR2HS $PINS O=n654 I1=n140 I2=n139
XU58 XNR2HS $PINS O=n691 I1=n170 I2=n169
XU60 OAI12HS $PINS O=n161 A1=n153 B1=n155 B2=n154
XU61 NR2 $PINS O=n158 I1=n154 I2=n148
XU63 AOI12HS $PINS O=n155 A1=n94 B1=n133 B2=n95
XU64 INV2 $PINS O=n69 I=n163
XU65 XOR2HS $PINS O=n690 I1=n101 I2=FE_OFN1001_n168
XU66 ND2S $PINS O=n170 I1=n66 I2=n163
XU67 OAI12HS $PINS O=n133 A1=n91 B1=n93 B2=n92
XU68 NR2 $PINS O=n134 I1=n90 I2=n93
XU69 ND2S $PINS O=n154 I1=n56 I2=n147
XU70 ND2S $PINS O=n119 I1=Iy2[4] I2=Ix2[4]
XU71 ND2S $PINS O=n187 I1=n68 I2=n182
XU72 ND2S $PINS O=n182 I1=Iy2[8] I2=Ix2[8]
XU73 NR2 $PINS O=n130 I1=Iy2[11] I2=Ix2[11]
XU74 ND2S $PINS O=n149 I1=Iy2[13] I2=Ix2[13]
XU75 ND2S $PINS O=n157 I1=n62 I2=n159
XU76 ND2S $PINS O=n92 I1=Iy2[9] I2=Ix2[9]
XU77 ND2S $PINS O=n131 I1=Ix2[11] I2=Iy2[11]
XU78 ND2S $PINS O=n103 I1=Iy2[12] I2=Ix2[12]
XU79 ND2S $PINS O=n82 I1=Ix2[5] I2=Iy2[5]
XU80 ND2S $PINS O=n129 I1=n56 I2=n150
XU81 INV1S $PINS O=n151 I=n150
XU82 ND2S $PINS O=n150 I1=Ix2[14] I2=Iy2[14]
XU83 OAI12HS $PINS O=n323 A1=n327 B1=n317 B2=n326
XU84 AOI12H $PINS O=n393 A1=n268 B1=DP_OP_16J1_125_1356/n124
+ B2=DP_OP_16J1_125_1356/n120
XU85 FA1S $PINS S=n421 CO=n419 A=n408 B=n407 CI=n406
XU86 NR2 $PINS O=n326 I1=n315 I2=n316
XU87 XOR2H $PINS O=n275 I1=n129 I2=n128
XU88 XOR2HS $PINS O=n272 I1=n157 I2=n156
XU89 AOI12HS $PINS O=n109 A1=n107 B1=FE_DBTN82_n75 B2=n108
XU90 AOI12HS $PINS O=n135 A1=n133 B1=FE_DBTN82_n75 B2=n134
XU91 XNR2HS $PINS O=N36 I1=n76 I2=FE_OFN296_FE_DBTN82_n75
XU92 AOI12HS $PINS O=n80 A1=n78 B1=FE_OFN296_FE_DBTN82_n75 B2=n79
XU94 OAI12HS $PINS O=n186 A1=n183 B1=n185 B2=n184
XU96 OAI112H $PINS O=n138 A1=n70 B1=n82 C1=n71 C2=n168
XU97 INV1S $PINS O=n85 I=n84
XU99 NR2 $PINS O=n83 I1=n122 I2=n118
XU100 OAI12HS $PINS O=n169 A1=n166 B1=FE_OFN1001_n168 B2=n167
XU101 OAI12HS $PINS O=n107 A1=n131 B1=n106 B2=n130
XU102 INV1S $PINS O=n166 I=n165
XU103 OAI12HS $PINS O=n126 A1=n149 B1=n155 B2=n125
XU104 NR2 $PINS O=n127 I1=n125 I2=n148
XU105 INV1S $PINS O=n97 I=n148
XU106 INV1S $PINS O=n106 I=n133
XU107 OAI12HS $PINS O=n165 A1=n112 B1=n111 B2=n114
XU108 ND2 $PINS O=n163 I1=Ix2[3] I2=Iy2[3]
XU109 ND2 $PINS O=n112 I1=Iy2[2] I2=Ix2[2]
XU110 INV1S $PINS O=n120 I=n118
XU111 ND2S $PINS O=n101 I1=n100 I2=n114
XU112 AOI12HS $PINS O=n153 A1=n151 B1=n56 B2=n152
XU113 OAI12HS $PINS O=n94 A1=n103 B1=n102 B2=n131
XU114 INV1S $PINS O=n144 I=n184
XU115 ND2S $PINS O=n183 I1=Iy2[7] I2=Ix2[7]
XU116 INV1S $PINS O=n72 I=n137
XU117 INV1S $PINS O=n152 I=n149
XU118 INV1S $PINS O=n160 I=n159
XU119 INV1S $PINS O=n79 I=n90
XU120 INV1S $PINS O=n147 I=n125
XU121 NR2 $PINS O=n125 I1=Ix2[13] I2=Iy2[13]
XU122 ND2S $PINS O=n137 I1=Ix2[6] I2=Iy2[6]
XU123 ND2S $PINS O=n159 I1=Iy2[15] I2=Ix2[15]
XU124 ND2 $PINS O=n114 I1=Ix2[1] I2=Iy2[1]
XU125 NR2 $PINS O=n115 I1=Iy2[1] I2=Ix2[1]
XU126 NR2 $PINS O=n90 I1=Ix2[9] I2=Iy2[9]
XU127 FA1 $PINS S=N49 CO=n318 A=n322 B=n321 CI=n320
XU128 FA1 $PINS S=N48 CO=n320 A=n325 B=n324 CI=n323
XU129 MOAI1H $PINS O=n403 A1=n393 A2=n392 B1=n391 B2=n390
XU130 INV1S $PINS O=n267 I=DP_OP_16J1_125_1356/n121
XU132 FA1S $PINS S=N44 CO=n334 A=n339 B=n338 CI=n337
XU133 NR2 $PINS O=n392 I1=n391 I2=n390
XU134 FA1S $PINS S=N43 CO=n337 A=n342 B=n341 CI=n340
XU135 ND2S $PINS O=DP_OP_16J1_125_1356/n123 I1=n418 I2=n419
XU136 FA1S $PINS S=n391 CO=n404 A=n389 B=n388 CI=n387
XU137 ND2S $PINS O=n330 I1=n328 I2=n327
XU139 FA1S $PINS S=N42 CO=n340 A=n345 B=n344 CI=n343
XU140 FA1S $PINS S=n406 CO=n447 A=n414 B=n413 CI=n412
XU141 ND2S $PINS O=n350 I1=n348 I2=n347
XU142 FA1 $PINS S=n424 CO=n422 A=n206 B=n205 CI=n204
XU143 FA1S $PINS S=n405 CO=n401 A=n386 B=n385 CI=n384
XU144 FA1 $PINS S=n446 CO=n443 A=n417 B=n416 CI=n415
XU145 ND2S $PINS O=n622 I1=n620 I2=n619
XU146 FA1 $PINS S=N23 CO=n429 A=n434 B=n433 CI=n432
XU147 FA1S $PINS S=n428 CO=n206 A=n209 B=n208 CI=n207
XU148 FA1S $PINS S=n205 CO=n412 A=n192 B=n191 CI=n190
XU149 FA1S $PINS S=n407 CO=n415 A=n266 B=n265 CI=n264
XU150 FA1S $PINS S=n430 CO=n210 A=n219 B=n218 CI=n217
XU151 FA1 $PINS S=N22 CO=n432 A=n437 B=n436 CI=n435
XU152 FA1S $PINS S=n335 CO=n332 A=n286 B=n285 CI=n284
XU153 FA1S $PINS S=n338 CO=n336 A=n291 B=n290 CI=n289
XU154 FA1S $PINS S=n445 CO=n389 A=n254 B=n253 CI=n252
XU155 FA1S $PINS S=n204 CO=n408 A=n175 B=n174 CI=n173
XU156 FA1S $PINS S=n402 CO=n398 A=n374 B=n373 CI=n372
XU157 FA1S $PINS S=n448 CO=n255 A=n411 B=n410 CI=n409
XU158 FA1S $PINS S=n388 CO=n384 A=n383 B=n382 CI=n381
XU159 FA1S $PINS S=n341 CO=n339 A=n294 B=n293 CI=n292
XU160 FA1S $PINS S=n289 CO=n285 A=n283 B=n282 CI=n281
XU161 ND2S $PINS O=n347 I1=n308 I2=n307
XU162 FA1S $PINS S=n333 CO=n316 A=n314 B=n313 CI=n312
XU163 FA1S $PINS S=n315 CO=n324 A=n311 B=n310 CI=n309
XU164 FA1S $PINS S=n218 CO=n208 A=n200 B=n199 CI=n198
XU165 ND2S $PINS O=n354 I1=n61 I2=n353
XU166 FA1S $PINS S=n399 CO=n395 A=n358 B=n357 CI=n356
XU167 FA1S $PINS S=n344 CO=n342 A=n299 B=n298 CI=n297
XU168 FA1S $PINS S=n211 CO=n173 A=n197 B=n196 CI=n195
XU169 FA1S $PINS S=n217 CO=n212 A=n203 B=n202 CI=n201
XU170 FA1S $PINS S=n175 CO=n266 A=n178 B=n177 CI=n176
XU171 FA1 $PINS S=N21 CO=n436 A=n440 B=n439 CI=n438
XU172 FA1S $PINS S=n253 CO=n383 A=n238 B=n237 CI=n236
XU173 FA1S $PINS S=n409 CO=n252 A=n251 B=n250 CI=n249
XU174 FA1S $PINS S=n381 CO=n386 A=n377 B=n376 CI=n375
XU175 FA1S $PINS S=n385 CO=n372 A=n380 B=n379 CI=n378
XU176 FA1S $PINS S=n207 CO=n191 A=n143 B=n142 CI=n141
XU177 FA1S $PINS S=n258 CO=n411 A=n245 B=n244 CI=n243
XU178 FA1S $PINS S=n325 CO=n321 A=n272 B=n271 CI=n270
XU179 FA1S $PINS S=n373 CO=n356 A=n364 B=n363 CI=n362
XU180 FA1S $PINS S=n284 CO=n313 A=n278 B=n277 CI=n276
XU181 HA1 $PINS S=n438 C=n231 A=n228 B=n227
XU182 FA1S $PINS S=n257 CO=n375 A=n242 B=n241 CI=n240
XU183 FA1S $PINS S=n264 CO=n410 A=n248 B=n247 CI=n246
XU184 ND2S $PINS O=n353 I1=n351 I2=n352
XU185 FA1S $PINS S=n378 CO=n374 A=n371 B=n370 CI=n369
XU186 FA1S $PINS S=n416 CO=n256 A=n263 B=n262 CI=n261
XU187 FA1S $PINS S=n312 CO=n309 A=n275 B=n274 CI=n273
XU188 FA1S $PINS S=n382 CO=n379 A=n368 B=n367 CI=n366
XU189 FA1S $PINS S=n174 CO=n414 A=n181 B=n180 CI=n179
XU190 NR2 $PINS O=n310 I1=FE_OFN4250_FE_OFN307_FE_DBTN77_n272
+ I2=FE_OFN303_FE_DBTN79_n280
XU191 FA1S $PINS S=n434 CO=n219 A=n222 B=n221 CI=n220
XU192 NR2 $PINS O=n314 I1=FE_OFN4145_FE_DBTN78_n275 I2=FE_OFN4146_n280
XU193 NR2 $PINS O=n234 I1=FE_OFN308_FE_DBTN77_n272 I2=FE_OFN298_FE_DBTN81_n691
XU194 ND3 $PINS O=n623 I1=n625 I2=FE_OFN670_n701 I3=FE_OFN673_FE_DBTN83_n654
XU195 ND2S $PINS O=n624 I1=intadd_60/A[8] I2=FE_OFN1180_FE_DBTN71_n637
XU196 AO12 $PINS O=n360 A1=n64 B1=FE_DBTN82_n75 B2=n65
XU197 ND2S $PINS O=n649 I1=n701 I2=n696
XU198 ND2S $PINS O=n677 I1=n648 I2=n647
XU199 ND2S $PINS O=n631 I1=FE_OFN670_n701 I2=n691
XU200 ND2S $PINS O=n633 I1=n640 I2=FE_OFN1146_n695
XU201 ND2S $PINS O=n635 I1=n640 I2=n690
XU202 ND2S $PINS O=n625 I1=n640 I2=FE_OFN1180_FE_DBTN71_n637
XU203 ND2S $PINS O=n636 I1=FE_OFN670_n701 I2=FE_OFN1146_n695
XU204 ND2S $PINS O=n648 I1=n687 I2=FE_OFN666_n654
XU205 ND2 $PINS O=n646 I1=FE_OFN666_n654 I2=FE_OFN1146_n695
XU206 ND2S $PINS O=n632 I1=FE_OFN666_n654 I2=n655
XU207 ND2S $PINS O=n645 I1=n637 I2=n691
XU208 ND2S $PINS O=n689 I1=n687 I2=n683
XU209 ND3 $PINS O=n706 I1=n708 I2=s1_P2[14] I3=FE_PHN3209_s1_P2_13
XU210 INV3 $PINS O=n145 I=n185
XU211 ND2S $PINS O=n717 I1=n697 I2=n696
XU212 ND2S $PINS O=n693 I1=n691 I2=n690
XU213 ND2S $PINS O=n692 I1=n655 I2=n696
XU214 ND2S $PINS O=n718 I1=n695 I2=n690
XU215 OAI12HS $PINS O=n123 A1=n121 B1=FE_OFN1001_n168 B2=n122
XU216 ND2S $PINS O=n117 I1=n113 I2=n112
XU217 ND2 $PINS O=n89 I1=n67 I2=FE_OFN1001_n168
XU219 ND2S $PINS O=n124 I1=n120 I2=n119
XU220 ND2S $PINS O=n146 I1=n144 I2=n183
XU221 NR2 $PINS O=n164 I1=n115 I2=n111
XU222 ND2S $PINS O=n136 I1=n132 I2=n131
XU223 ND2S $PINS O=n110 I1=n104 I2=n103
XU224 ND2S $PINS O=n81 I1=n77 I2=n91
XU225 ND2S $PINS O=n99 I1=n147 I2=n149
XU226 NR2P $PINS O=n111 I1=Ix2[2] I2=Iy2[2]
XU227 ND2S $PINS O=n76 I1=n79 I2=n92
XU228 INV1S $PINS O=n74 I=n183
XU229 INV1S $PINS O=n73 I=n182
XU230 ND2S $PINS O=n91 I1=Iy2[10] I2=Ix2[10]
XU231 ND2S $PINS O=n88 I1=n60 I2=n82
XU232 ND2S $PINS O=n140 I1=n63 I2=n137
XU233 INV1S $PINS O=n78 I=n92
XU234 ND2S $PINS O=n539 I1=n538 I2=n537
XU235 ND2S $PINS O=n551 I1=n550 I2=n549
XU236 ND2S $PINS O=n563 I1=n562 I2=n561
XU237 ND2S $PINS O=n575 I1=n574 I2=n573
XU238 ND2S $PINS O=n587 I1=n586 I2=n585
XU239 ND2S $PINS O=n599 I1=n598 I2=n597
XU240 ND2S $PINS O=n611 I1=n610 I2=n609
XU241 ND2S $PINS O=n704 I1=s1_P2[11] I2=s1_P2[12]
XU243 XNR2HS $PINS O=n701 I1=n146 I2=n145
XU260 XNR2HS $PINS O=n695 I1=n117 I2=n116
XU261 OAI12HS $PINS O=n116 A1=n114 B1=FE_OFN1001_n168 B2=n115
XU263 XNR2HS $PINS O=n637 I1=n88 I2=n87
XU264 OAI12HS $PINS O=n87 A1=n85 B1=n168 B2=n86
XU266 NR2 $PINS O=n184 I1=Ix2[7] I2=Iy2[7]
XU267 NR2P $PINS O=n118 I1=Ix2[4] I2=Iy2[4]
XU271 XOR2HS $PINS O=n304 I1=n136 I2=n135
XU274 NR2 $PINS O=n273 I1=FE_OFN4249_FE_OFN307_FE_DBTN77_n272 I2=FE_DBTN75_n296
XU275 NR2 $PINS O=n286 I1=FE_OFN4145_FE_DBTN78_n275 I2=FE_DBTN75_n296
XU276 NR2 $PINS O=n367 I1=FE_OFN314_FE_DBTN75_n296 I2=FE_OFN667_n700
XU277 NR2 $PINS O=n283 I1=FE_OFN4146_n280 I2=FE_DBTN75_n296
XU278 NR2 $PINS O=n262 I1=FE_OFN2725_FE_DBTN75_n296 I2=FE_OFN674_FE_DBTN83_n654
XU279 NR2 $PINS O=n176 I1=FE_OFN2725_FE_DBTN75_n296 I2=FE_OFN316_FE_DBTN72_n655
XU280 NR2 $PINS O=n305 I1=FE_OFN314_FE_DBTN75_n296 I2=FE_OFN302_FE_DBTN80_n449
XU281 NR2 $PINS O=n299 I1=FE_OFN314_FE_DBTN75_n296 I2=FE_DBTN76_n304
XU282 NR2 $PINS O=n303 I1=FE_DBTN84_N36 I2=FE_OFN314_FE_DBTN75_n296
XU284 XOR2HS $PINS O=n296 I1=n110 I2=n109
XU285 NR2 $PINS O=n93 I1=Ix2[10] I2=Iy2[10]
XU289 NR2 $PINS O=n311 I1=FE_OFN4237_FE_DBTN74_n360 I2=FE_DBTN75_n296
XU290 NR2 $PINS O=n274 I1=FE_DBTN74_n360 I2=FE_DBTN76_n304
XU291 NR2 $PINS O=n278 I1=FE_DBTN74_n360 I2=FE_OFN302_FE_DBTN80_n449
XU292 NR2 $PINS O=n279 I1=FE_DBTN84_N36 I2=FE_DBTN74_n360
XU293 NR2 $PINS O=n368 I1=FE_OFN4125_n360 I2=FE_OFN316_FE_DBTN72_n655
XU294 NR2 $PINS O=n235 I1=FE_OFN4125_n360 I2=FE_OFN1178_FE_DBTN73_n695
XU295 NR2 $PINS O=n189 I1=FE_OFN4273_FE_OFN1143_n89 I2=FE_OFN4125_n360
XU296 AN2 $PINS O=n54 I1=n449 I2=n55
XU297 OR2 $PINS O=n55 I1=FE_OFN671_FE_DBTN84_N36 I2=FE_OFN300_FE_DBTN80_n449
XU298 OR2 $PINS O=n56 I1=Iy2[14] I2=Ix2[14]
XU299 OR2 $PINS O=n57 I1=FE_OFN671_FE_DBTN84_N36 I2=FE_OFN311_FE_DBTN76_n304
XU300 AO12 $PINS O=n58 A1=n73 B1=n68 B2=n74
XU301 AN2 $PINS O=n59 I1=n68 I2=n144
XU302 OR2 $PINS O=n60 I1=Iy2[5] I2=Ix2[5]
XU303 OR2 $PINS O=n61 I1=n352 I2=n351
XU304 OR2 $PINS O=n62 I1=Ix2[15] I2=Iy2[15]
XU305 OR2 $PINS O=n63 I1=Iy2[6] I2=Ix2[6]
XU306 AO12 $PINS O=n64 A1=n160 B1=n161 B2=n62
XU307 AN2 $PINS O=n65 I1=n158 I2=n62
XU308 OR2T $PINS O=n66 I1=Iy2[3] I2=Ix2[3]
XU309 OR2 $PINS O=n67 I1=Iy2[0] I2=Ix2[0]
XU311 OR2 $PINS O=n68 I1=Ix2[8] I2=Iy2[8]
XU312 NR2 $PINS O=n95 I1=n130 I2=n102
XU313 ND2 $PINS O=n71 I1=n83 I2=n60
XU314 INV1S $PINS O=n77 I=n93
XU315 NR2 $PINS O=n102 I1=Ix2[12] I2=Iy2[12]
XU316 NR2 $PINS O=n246 I1=FE_OFN310_FE_DBTN76_n304 I2=FE_OFN674_FE_DBTN83_n654
XU317 NR2 $PINS O=n238 I1=FE_OFN4125_n360 I2=FE_OFN298_FE_DBTN81_n691
XU318 NR2 $PINS O=n108 I1=n130 I2=n105
XU319 XOR2HS $PINS O=n449 I1=n81 I2=n80
XU320 NR2 $PINS O=n254 I1=FE_OFN314_FE_DBTN75_n296 I2=FE_OFN882_n365
XU321 XOR2HS $PINS O=n280 I1=n99 I2=n98
XU322 XNR2HS $PINS O=n655 I1=n124 I2=n123
XU324 NR2 $PINS O=n221 I1=FE_OFN4150_n304 I2=FE_OFN1178_FE_DBTN73_n695
XU325 NR2 $PINS O=n268 I1=n267 I2=DP_OP_16J1_125_1356/n124
XU326 NR2 $PINS O=n294 I1=FE_OFN4145_FE_DBTN78_n275 I2=FE_OFN302_FE_DBTN80_n449
XU327 NR2 $PINS O=n271 I1=FE_OFN4237_FE_DBTN74_n360 I2=FE_DBTN79_n280
XU328 MOAI1S $PINS O=n666 A1=n630 A2=n636 B1=n629 B2=FE_OFN1180_FE_DBTN71_n637
XU329 FA1 $PINS S=n435 CO=n223 A=n231 B=n230 CI=n229
XU330 XOR2HS $PINS O=n269 I1=n391 I2=n390
XU331 NR2 $PINS O=N19 I1=n89 I2=FE_OFN672_FE_DBTN84_N36
XU333 FA1 $PINS S=N46 CO=n329 A=n333 B=n332 CI=n331
XU334 INV1S $PINS O=n86 I=n83
XU335 NR2 $PINS O=n209 I1=FE_OFN300_FE_DBTN80_n449 I2=FE_OFN1179_FE_DBTN71_n637
XU336 NR2 $PINS O=n214 I1=FE_OFN4273_FE_OFN1143_n89 I2=FE_OFN4156_n280
XU337 INV1S $PINS O=n100 I=n115
XU338 INV1S $PINS O=n104 I=n102
XU339 INV1S $PINS O=n105 I=n134
XU340 NR2 $PINS O=n213 I1=FE_OFN1145_n653 I2=FE_OFN2725_FE_DBTN75_n296
XU341 INV1S $PINS O=n113 I=n111
XU342 NR2 $PINS O=n199 I1=FE_OFN2743_FE_DBTN75_n296
+ I2=FE_OFN1178_FE_DBTN73_n695
XU343 NR2 $PINS O=n198 I1=FE_DBTN80_n449 I2=FE_OFN315_FE_DBTN72_n655
XU344 NR2 $PINS O=n194 I1=FE_OFN1145_n653 I2=FE_OFN4156_n280
XU345 NR2 $PINS O=n193 I1=FE_OFN4273_FE_OFN1143_n89 I2=FE_OFN305_FE_DBTN78_n275
XU346 NR2 $PINS O=n142 I1=FE_OFN4156_n280 I2=FE_OFN1178_FE_DBTN73_n695
XU347 INV1S $PINS O=n132 I=n130
XU348 NR2 $PINS O=n141 I1=FE_OFN4150_n304 I2=FE_OFN316_FE_DBTN72_n655
XU349 NR2 $PINS O=n192 I1=FE_OFN300_FE_DBTN80_n449 I2=FE_OFN673_FE_DBTN83_n654
XU350 NR2 $PINS O=n190 I1=FE_OFN671_FE_DBTN84_N36 I2=n365
XU351 NR2 $PINS O=n172 I1=FE_OFN4273_FE_OFN1143_n89 I2=FE_OFN308_FE_DBTN77_n272
XU352 NR2 $PINS O=n171 I1=FE_OFN1145_n653 I2=FE_OFN305_FE_DBTN78_n275
XU353 NR2 $PINS O=n188 I1=FE_OFN1145_n653 I2=FE_OFN308_FE_DBTN77_n272
XU354 NR2 $PINS O=n181 I1=FE_OFN305_FE_DBTN78_n275 I2=FE_OFN1178_FE_DBTN73_n695
XU355 INV1S $PINS O=n167 I=n164
XU356 NR2 $PINS O=n180 I1=FE_OFN4156_n280 I2=FE_OFN298_FE_DBTN81_n691
XU357 NR2 $PINS O=n179 I1=FE_OFN310_FE_DBTN76_n304 I2=FE_OFN1144_n637
XU358 HA1 $PINS S=n197 C=n178 A=n172 B=n171
XU359 NR2 $PINS O=n196 I1=FE_OFN2743_FE_DBTN75_n296 I2=FE_OFN298_FE_DBTN81_n691
XU360 NR2 $PINS O=n195 I1=FE_OFN671_FE_DBTN84_N36 I2=FE_OFN673_FE_DBTN83_n654
XU361 NR2 $PINS O=n265 I1=FE_OFN300_FE_DBTN80_n449 I2=FE_OFN882_n365
XU362 NR2 $PINS O=n248 I1=FE_OFN4156_n280 I2=FE_OFN316_FE_DBTN72_n655
XU363 NR2 $PINS O=n247 I1=FE_OFN2725_FE_DBTN75_n296 I2=FE_OFN1144_n637
XU364 NR2 $PINS O=n260 I1=FE_OFN305_FE_DBTN78_n275 I2=FE_OFN298_FE_DBTN81_n691
XU365 NR2 $PINS O=n259 I1=FE_OFN671_FE_DBTN84_N36 I2=FE_OFN667_n700
XU366 NR2 $PINS O=n245 I1=FE_OFN1145_n653 I2=FE_OFN4125_n360
XU367 HA1 $PINS S=n177 C=n244 A=n189 B=n188
XU368 NR2 $PINS O=n243 I1=FE_OFN308_FE_DBTN77_n272 I2=FE_OFN1178_FE_DBTN73_n695
XU369 HA1 $PINS S=n203 C=n143 A=n194 B=n193
XU370 NR2 $PINS O=n202 I1=FE_OFN4150_n304 I2=FE_OFN297_FE_DBTN81_n691
XU371 NR2 $PINS O=n201 I1=FE_OFN672_FE_DBTN84_N36 I2=FE_OFN1179_FE_DBTN71_n637
XU372 NR2 $PINS O=n216 I1=FE_OFN4273_FE_OFN1143_n89
+ I2=FE_OFN2725_FE_DBTN75_n296
XU373 NR2 $PINS O=n215 I1=FE_OFN1145_n653 I2=FE_OFN4150_n304
XU374 NR2 $PINS O=n220 I1=FE_OFN672_FE_DBTN84_N36 I2=FE_OFN315_FE_DBTN72_n655
XU375 HA1 $PINS S=n225 C=n200 A=n214 B=n213
XU376 NR2 $PINS O=n224 I1=FE_DBTN80_n449 I2=FE_OFN298_FE_DBTN81_n691
XU377 NR2 $PINS O=n228 I1=FE_OFN1143_n89 I2=FE_OFN4150_n304
XU378 NR2 $PINS O=n227 I1=n653 I2=FE_DBTN80_n449
XU379 NR2 $PINS O=n230 I1=FE_DBTN80_n449 I2=FE_DBTN73_n695
XU380 HA1 $PINS S=n229 C=n222 A=n216 B=n215
XU381 NR2 $PINS O=n437 I1=FE_OFN672_FE_DBTN84_N36 I2=FE_OFN297_FE_DBTN81_n691
XU382 NR2 $PINS O=n442 I1=n653 I2=FE_OFN672_FE_DBTN84_N36
XU383 NR2 $PINS O=n441 I1=FE_OFN1143_n89 I2=FE_DBTN80_n449
XU384 NR2 $PINS O=n439 I1=FE_OFN672_FE_DBTN84_N36 I2=FE_DBTN73_n695
XU385 NR2 $PINS O=n237 I1=FE_OFN310_FE_DBTN76_n304 I2=FE_OFN667_n700
XU386 NR2 $PINS O=n251 I1=FE_OFN305_FE_DBTN78_n275 I2=FE_OFN316_FE_DBTN72_n655
XU387 NR2 $PINS O=n250 I1=FE_OFN300_FE_DBTN80_n449 I2=FE_OFN667_n700
XU388 HA1 $PINS S=n249 C=n236 A=n235 B=n234
XU389 NR2 $PINS O=n366 I1=FE_DBTN78_n275 I2=FE_OFN674_FE_DBTN83_n654
XU390 NR2 $PINS O=n377 I1=FE_OFN308_FE_DBTN77_n272 I2=FE_OFN1144_n637
XU391 NR2 $PINS O=n376 I1=FE_OFN304_FE_DBTN79_n280 I2=FE_OFN881_n365
XU392 NR2 $PINS O=n242 I1=FE_OFN308_FE_DBTN77_n272 I2=FE_OFN316_FE_DBTN72_n655
XU393 NR2 $PINS O=n241 I1=FE_OFN305_FE_DBTN78_n275 I2=FE_OFN1144_n637
XU394 NR2 $PINS O=n240 I1=FE_OFN304_FE_DBTN79_n280 I2=FE_OFN674_FE_DBTN83_n654
XU395 NR2 $PINS O=n263 I1=FE_OFN4156_n280 I2=FE_OFN1144_n637
XU396 NR2 $PINS O=n261 I1=FE_OFN310_FE_DBTN76_n304 I2=FE_OFN882_n365
XU397 XNR2HS $PINS O=N30 I1=n269 I2=FE_OCPN2945_n393
XU398 NR2 $PINS O=n319 I1=FE_OFN4237_FE_DBTN74_n360
+ I2=FE_OFN4250_FE_OFN307_FE_DBTN77_n272
XU399 NR2 $PINS O=n322 I1=FE_OFN4237_FE_DBTN74_n360 I2=FE_OFN306_FE_DBTN78_n275
XU400 NR2 $PINS O=n270 I1=FE_OFN4250_FE_OFN307_FE_DBTN77_n272
+ I2=FE_OFN306_FE_DBTN78_n275
XU401 NR2 $PINS O=n277 I1=FE_OFN4249_FE_OFN307_FE_DBTN77_n272 I2=FE_DBTN76_n304
XU402 NR2 $PINS O=n282 I1=FE_OFN4249_FE_OFN307_FE_DBTN77_n272
+ I2=FE_OFN302_FE_DBTN80_n449
XU403 NR2 $PINS O=n288 I1=FE_DBTN84_N36 I2=FE_OFN4249_FE_OFN307_FE_DBTN77_n272
XU404 NR2 $PINS O=n287 I1=FE_OFN4146_n280 I2=FE_DBTN76_n304
XU405 NR2 $PINS O=n291 I1=FE_OFN4145_FE_DBTN78_n275 I2=FE_DBTN76_n304
XU406 HA1 $PINS S=n290 C=n276 A=FE_OFN4148_n280 B=n279
XU407 NR2 $PINS O=n295 I1=FE_DBTN84_N36 I2=FE_OFN306_FE_DBTN78_n275
XU408 HA1 $PINS S=n292 C=n281 A=n288 B=n287
XU409 NR2 $PINS O=n298 I1=FE_OFN4146_n280 I2=FE_OFN302_FE_DBTN80_n449
XU410 NR2 $PINS O=n306 I1=FE_DBTN84_N36 I2=FE_OFN4146_n280
XU411 HA1 $PINS S=n345 C=n293 A=FE_OFN313_FE_DBTN75_n296 B=n295
XU412 NR2 $PINS O=n355 I1=n57 I2=n55
XU413 NR2 $PINS O=n352 I1=FE_OFN311_FE_DBTN76_n304 I2=FE_OFN302_FE_DBTN80_n449
XU414 INV1S $PINS O=n302 I=n353
XU415 NR2 $PINS O=n349 I1=n355 I2=n302
XU416 HA1 $PINS S=n351 C=n307 A=FE_OFN309_FE_DBTN76_n304 B=n303
XU417 HA1 $PINS S=n308 C=n297 A=n306 B=n305
XU418 NR2 $PINS O=n346 I1=n307 I2=n308
XU419 OAI12HS $PINS O=n343 A1=n347 B1=n349 B2=n346
XU420 INV1S $PINS O=n328 I=n326
XU421 XNR2HS $PINS O=N47 I1=n330 I2=n329
XU422 INV1S $PINS O=n348 I=n346
XU423 XOR2HS $PINS O=N41 I1=n350 I2=n349
XU424 XNR2HS $PINS O=N40 I1=n355 I2=n354
XU425 XOR2HS $PINS O=N39 I1=n55 I2=n57
XU426 NR2 $PINS O=n396 I1=FE_OFN4238_FE_DBTN74_n360 I2=n700
XU427 NR2 $PINS O=n358 I1=FE_OFN307_FE_DBTN77_n272 I2=n700
XU428 NR2 $PINS O=n357 I1=FE_OFN4238_FE_DBTN74_n360 I2=FE_OFN881_n365
XU429 NR2 $PINS O=n364 I1=FE_DBTN78_n275 I2=n700
XU430 NR2 $PINS O=n363 I1=FE_OFN4238_FE_DBTN74_n360 I2=FE_OFN674_FE_DBTN83_n654
XU431 NR2 $PINS O=n362 I1=FE_OFN307_FE_DBTN77_n272 I2=FE_OFN881_n365
XU432 NR2 $PINS O=n371 I1=FE_OFN304_FE_DBTN79_n280 I2=n700
XU433 NR2 $PINS O=n370 I1=FE_OFN4125_n360 I2=FE_OFN1144_n637
XU434 NR2 $PINS O=n369 I1=FE_OFN307_FE_DBTN77_n272 I2=FE_OFN674_FE_DBTN83_n654
XU435 NR2 $PINS O=n380 I1=FE_DBTN78_n275 I2=FE_OFN881_n365
XU436 FA1 $PINS S=N34 CO=N35 A=n396 B=n395 CI=n394
XU437 FA1 $PINS S=N33 CO=n394 A=n399 B=n398 CI=n397
XU439 XOR3 $PINS O=N28 I1=n419 I2=n418 I3=DP_OP_16J1_125_1356/n124
XU440 NR2 $PINS O=DP_OP_16J1_125_1356/n122 I1=n419 I2=n418
XU444 HA1 $PINS S=N20 C=n440 A=n442 B=n441
XU447 NR2 $PINS O=n658 I1=FE_OFN1179_FE_DBTN71_n637 I2=n365
XU448 MOAI1S $PINS O=intadd_60/B[8] A1=n365 A2=FE_OFN673_FE_DBTN83_n654 B1=n658
+ B2=n640
XU477 NR2 $PINS O=intadd_60/A[8] I1=FE_OFN673_FE_DBTN83_n654 I2=FE_OFN669_n700
XU478 INV1S $PINS O=n653 I=n690
XU479 OAI12HS $PINS O=n453 A1=FE_OFN1146_n695 B1=n653 B2=n696
XU480 NR2 $PINS O=n683 I1=n89 I2=FE_DBTN81_n691
XU481 XOR2HS $PINS O=n454 I1=n453 I2=n683
XU482 ND2S $PINS O=n723 I1=n454 I2=det[0]
XU483 AN2 $PINS O=intadd_62/CI I1=intadd_61/n1 I2=s1_P1[9]
XU484 NR2 $PINS O=n455 I1=n365 I2=n700
XU485 OR2 $PINS O=n719 I1=n455 I2=intadd_60/n1
XU486 AN2 $PINS O=n720 I1=s1_P0[10] I2=s1_P1[0]
XU488 OA12 $PINS O=n721 A1=n713 B1=intadd_62/n1 B2=s1_P2[9]
XU489 INV1S $PINS O=n456 I=trace_sq_reg[5]
XU490 NR2 $PINS O=n458 I1=det_reg[1] I2=n456
XU491 ND2S $PINS O=n457 I1=n456 I2=det_reg[1]
XU492 OAI12HS $PINS O=n462 A1=n457 B1=n458 B2=DP_OP_18J1_127_8258/n162
XU493 INV1S $PINS O=n459 I=trace_sq_reg[6]
XU494 OR2 $PINS O=n461 I1=det_reg[2] I2=n459
XU495 AN2 $PINS O=n460 I1=n459 I2=det_reg[2]
XU496 AOI12HS $PINS O=n466 A1=n460 B1=n462 B2=n461
XU497 INV1S $PINS O=n463 I=trace_sq_reg[7]
XU498 NR2 $PINS O=n465 I1=det_reg[3] I2=n463
XU499 ND2S $PINS O=n464 I1=n463 I2=det_reg[3]
XU500 OAI12HS $PINS O=n470 A1=n464 B1=n466 B2=n465
XU501 INV1S $PINS O=n467 I=trace_sq_reg[8]
XU502 OR2 $PINS O=n469 I1=det_reg[4] I2=n467
XU503 AN2 $PINS O=n468 I1=n467 I2=det_reg[4]
XU504 AOI12HS $PINS O=n474 A1=n468 B1=n470 B2=n469
XU505 INV1S $PINS O=n471 I=trace_sq_reg[9]
XU506 NR2 $PINS O=n473 I1=det_reg[5] I2=n471
XU507 ND2S $PINS O=n472 I1=n471 I2=det_reg[5]
XU508 OAI12HS $PINS O=n478 A1=n472 B1=n474 B2=n473
XU509 INV1S $PINS O=n475 I=trace_sq_reg[10]
XU510 OR2 $PINS O=n477 I1=det_reg[6] I2=n475
XU511 AN2 $PINS O=n476 I1=n475 I2=det_reg[6]
XU512 AOI12HS $PINS O=n483 A1=n476 B1=n478 B2=n477
XU513 INV1S $PINS O=n479 I=trace_sq_reg[11]
XU514 INV1S $PINS O=n480 I=det_reg[7]
XU515 NR2 $PINS O=n482 I1=n479 I2=n480
XU516 ND2S $PINS O=n481 I1=n480 I2=n479
XU517 OAI12HS $PINS O=n488 A1=n481 B1=n483 B2=n482
XU518 INV1S $PINS O=n484 I=trace_sq_reg[12]
XU519 XNR2HS $PINS O=n485 I1=det_reg[8] I2=det_reg[7]
XU520 OR2 $PINS O=n487 I1=n484 I2=n485
XU521 AN2 $PINS O=n486 I1=n485 I2=n484
XU522 AOI12HS $PINS O=n493 A1=n486 B1=n488 B2=n487
XU523 OR2 $PINS O=n489 I1=det_reg[8] I2=det_reg[7]
XU524 INV1S $PINS O=n494 I=trace_sq_reg[13]
XU525 NR2 $PINS O=n492 I1=n489 I2=n490
XU526 ND2S $PINS O=n491 I1=n490 I2=n489
XU527 OAI12HS $PINS O=n499 A1=n491 B1=n493 B2=n492
XU528 HA1 $PINS S=n490 C=n495 A=det_reg[9] B=n494
XU529 INV1S $PINS O=n500 I=trace_sq_reg[14]
XU530 OR2 $PINS O=n498 I1=n495 I2=n496
XU531 AN2 $PINS O=n497 I1=n496 I2=n495
XU532 AOI12HS $PINS O=n505 A1=n497 B1=n499 B2=n498
XU533 HA1 $PINS S=n496 C=n501 A=det_reg[10] B=n500
XU534 INV1S $PINS O=n506 I=trace_sq_reg[15]
XU535 XNR2HS $PINS O=n502 I1=det_reg[11] I2=n506
XU536 NR2 $PINS O=n504 I1=n501 I2=n502
XU537 ND2S $PINS O=n503 I1=n502 I2=n501
XU538 OAI12HS $PINS O=n511 A1=n503 B1=n505 B2=n504
XU539 OR2 $PINS O=n507 I1=det_reg[11] I2=n506
XU540 INV1S $PINS O=n512 I=trace_sq_reg[16]
XU541 OR2 $PINS O=n510 I1=n507 I2=n508
XU542 AN2 $PINS O=n509 I1=n508 I2=n507
XU543 AOI12HS $PINS O=n517 A1=n509 B1=n511 B2=n510
XU544 HA1 $PINS S=n508 C=n513 A=det_reg[12] B=n512
XU545 INV1S $PINS O=n518 I=trace_sq_reg[17]
XU546 XNR2HS $PINS O=n514 I1=det_reg[13] I2=n518
XU547 NR2 $PINS O=n516 I1=n513 I2=n514
XU548 ND2S $PINS O=n515 I1=n514 I2=n513
XU549 OAI12HS $PINS O=n523 A1=n515 B1=n517 B2=n516
XU550 OR2 $PINS O=n519 I1=det_reg[13] I2=n518
XU551 INV1S $PINS O=n524 I=trace_sq_reg[18]
XU552 XNR2HS $PINS O=n520 I1=det_reg[14] I2=n524
XU553 OR2 $PINS O=n522 I1=n519 I2=n520
XU554 AN2 $PINS O=n521 I1=n520 I2=n519
XU555 AOI12HS $PINS O=n529 A1=n521 B1=n523 B2=n522
XU556 OR2 $PINS O=n525 I1=det_reg[14] I2=n524
XU557 INV1S $PINS O=n530 I=trace_sq_reg[19]
XU558 NR2 $PINS O=n528 I1=n525 I2=n526
XU559 ND2S $PINS O=n527 I1=n526 I2=n525
XU560 OAI12HS $PINS O=n535 A1=n527 B1=n529 B2=n528
XU561 HA1 $PINS S=n526 C=n531 A=det_reg[15] B=n530
XU562 INV1S $PINS O=n536 I=trace_sq_reg[20]
XU563 XNR2HS $PINS O=n532 I1=det_reg[16] I2=n536
XU564 OR2 $PINS O=n534 I1=n531 I2=n532
XU565 AN2 $PINS O=n533 I1=n532 I2=n531
XU566 AOI12HS $PINS O=n541 A1=n533 B1=n535 B2=n534
XU567 OR2 $PINS O=n537 I1=det_reg[16] I2=n536
XU568 INV1S $PINS O=n542 I=trace_sq_reg[21]
XU569 XNR2HS $PINS O=n538 I1=det_reg[17] I2=n542
XU570 NR2 $PINS O=n540 I1=n537 I2=n538
XU571 OAI12HS $PINS O=n547 A1=n539 B1=n541 B2=n540
XU572 OR2 $PINS O=n543 I1=det_reg[17] I2=n542
XU573 INV1S $PINS O=n548 I=trace_sq_reg[22]
XU574 XNR2HS $PINS O=n544 I1=det_reg[18] I2=n548
XU575 OR2 $PINS O=n546 I1=n543 I2=n544
XU576 AN2 $PINS O=n545 I1=n544 I2=n543
XU577 AOI12HS $PINS O=n553 A1=n545 B1=n547 B2=n546
XU578 OR2 $PINS O=n549 I1=det_reg[18] I2=n548
XU579 INV1S $PINS O=n554 I=trace_sq_reg[23]
XU580 NR2 $PINS O=n552 I1=n549 I2=n550
XU581 OAI12HS $PINS O=n559 A1=n551 B1=n553 B2=n552
XU582 HA1 $PINS S=n550 C=n555 A=det_reg[19] B=n554
XU583 INV1S $PINS O=n560 I=trace_sq_reg[24]
XU584 OR2 $PINS O=n558 I1=n555 I2=n556
XU585 AN2 $PINS O=n557 I1=n556 I2=n555
XU586 AOI12HS $PINS O=n565 A1=n557 B1=n559 B2=n558
XU587 HA1 $PINS S=n556 C=n561 A=det_reg[20] B=n560
XU588 INV1S $PINS O=n566 I=trace_sq_reg[25]
XU589 XNR2HS $PINS O=n562 I1=det_reg[21] I2=n566
XU590 NR2 $PINS O=n564 I1=n561 I2=n562
XU591 OAI12HS $PINS O=n571 A1=n563 B1=n565 B2=n564
XU592 OR2 $PINS O=n567 I1=det_reg[21] I2=n566
XU593 INV1S $PINS O=n572 I=trace_sq_reg[26]
XU594 XNR2HS $PINS O=n568 I1=det_reg[22] I2=n572
XU595 OR2 $PINS O=n570 I1=n567 I2=n568
XU596 AN2 $PINS O=n569 I1=n568 I2=n567
XU597 AOI12HS $PINS O=n577 A1=n569 B1=n571 B2=n570
XU598 OR2 $PINS O=n573 I1=det_reg[22] I2=n572
XU599 INV1S $PINS O=n578 I=trace_sq_reg[27]
XU600 NR2 $PINS O=n576 I1=n573 I2=n574
XU601 OAI12HS $PINS O=n583 A1=n575 B1=n577 B2=n576
XU602 HA1 $PINS S=n574 C=n579 A=det_reg[23] B=n578
XU603 INV1S $PINS O=n584 I=trace_sq_reg[28]
XU604 XNR2HS $PINS O=n580 I1=det_reg[24] I2=n584
XU605 OR2 $PINS O=n582 I1=n579 I2=n580
XU606 AN2 $PINS O=n581 I1=n580 I2=n579
XU607 AOI12HS $PINS O=n589 A1=n581 B1=n583 B2=n582
XU608 OR2 $PINS O=n585 I1=det_reg[24] I2=n584
XU609 INV1S $PINS O=n590 I=trace_sq_reg[29]
XU610 XNR2HS $PINS O=n586 I1=det_reg[25] I2=n590
XU611 NR2 $PINS O=n588 I1=n585 I2=n586
XU612 OAI12HS $PINS O=n595 A1=n587 B1=n589 B2=n588
XU613 OR2 $PINS O=n591 I1=det_reg[25] I2=n590
XU614 INV1S $PINS O=n596 I=trace_sq_reg[30]
XU615 XNR2HS $PINS O=n592 I1=det_reg[26] I2=n596
XU616 OR2 $PINS O=n594 I1=n591 I2=n592
XU617 AN2 $PINS O=n593 I1=n592 I2=n591
XU618 AOI12HS $PINS O=n601 A1=n593 B1=n595 B2=n594
XU619 OR2 $PINS O=n597 I1=det_reg[26] I2=n596
XU620 INV1S $PINS O=n602 I=trace_sq_reg[31]
XU621 XNR2HS $PINS O=n598 I1=det_reg[27] I2=n602
XU622 NR2 $PINS O=n600 I1=n597 I2=n598
XU623 OAI12HS $PINS O=n607 A1=n599 B1=n601 B2=n600
XU624 OR2 $PINS O=n603 I1=det_reg[27] I2=n602
XU625 INV1S $PINS O=n608 I=trace_sq_reg[32]
XU626 XNR2HS $PINS O=n604 I1=det_reg[28] I2=n608
XU627 OR2 $PINS O=n606 I1=n603 I2=n604
XU628 AN2 $PINS O=n605 I1=n604 I2=n603
XU629 AOI12HS $PINS O=n613 A1=n605 B1=n607 B2=n606
XU630 OR2 $PINS O=n609 I1=det_reg[28] I2=n608
XU631 INV1S $PINS O=n614 I=trace_sq_reg[33]
XU632 XNR2HS $PINS O=n610 I1=det_reg[29] I2=n614
XU633 NR2 $PINS O=n612 I1=n609 I2=n610
XU634 OAI12HS $PINS O=n618 A1=n611 B1=n613 B2=n612
XU635 OR2 $PINS O=n615 I1=det_reg[29] I2=n614
XU636 OR2 $PINS O=n617 I1=det_reg[30] I2=n615
XU637 AN2 $PINS O=n616 I1=n615 I2=det_reg[30]
XU638 AOI12HS $PINS O=n620 A1=n616 B1=n618 B2=n617
XU639 INV1S $PINS O=n619 I=det_reg[31]
XU640 INV1S $PINS O=n621 I=det_reg[32]
XU641 AN2 $PINS O=corner I1=n622 I2=n621
XU642 OAI112HS $PINS O=intadd_60/A[7] A1=n624 B1=n623 C1=n625 C2=FE_OFN670_n701
XU643 NR2 $PINS O=n657 I1=FE_OFN315_FE_DBTN72_n655 I2=FE_OFN669_n700
XU644 NR2 $PINS O=n627 I1=FE_OFN297_FE_DBTN81_n691 I2=FE_OFN669_n700
XU645 OA12 $PINS O=n659 A1=FE_OFN666_n654 B1=n627 B2=FE_OFN1180_FE_DBTN71_n637
XU646 XOR3 $PINS O=intadd_60/A[6] I1=n658 I2=n657 I3=n659
XU647 NR2 $PINS O=n663 I1=FE_OFN315_FE_DBTN72_n655 I2=n365
XU648 NR2 $PINS O=n628 I1=FE_OFN1180_FE_DBTN71_n637 I2=FE_DBTN83_n654
XU649 XNR2HS $PINS O=n661 I1=n628 I2=n627
XU650 MAO222 $PINS O=n660 A1=n631 B1=n632 C1=n633
XU651 XOR3 $PINS O=intadd_60/A[5] I1=n663 I2=n661 I3=n660
XU652 INV1S $PINS O=n629 I=n635
XU653 NR2 $PINS O=n630 I1=n637 I2=n629
XU654 XNR3 $PINS O=n667 I1=n633 I2=n632 I3=n631
XU655 NR2 $PINS O=n641 I1=n649 I2=n635
XU656 NR2 $PINS O=n639 I1=FE_OFN297_FE_DBTN81_n691 I2=FE_DBTN83_n654
XU657 NR2 $PINS O=n638 I1=FE_OFN315_FE_DBTN72_n655 I2=FE_DBTN71_n637
XU658 MAO222 $PINS O=n665 A1=n641 B1=n639 C1=n638
XU659 XOR3 $PINS O=intadd_60/A[4] I1=n666 I2=n667 I3=n665
XU660 NR2 $PINS O=n687 I1=n653 I2=FE_DBTN72_n655
XU661 MAO222 $PINS O=n669 A1=n648 B1=n646 C1=n645
XU662 XNR3 $PINS O=n668 I1=n637 I2=n636 I3=n635
XU663 XOR3 $PINS O=n672 I1=n639 I2=n638 I3=n641
XU664 XOR3 $PINS O=intadd_60/A[3] I1=n669 I2=n668 I3=n672
XU665 AOI22S $PINS O=n642 A1=n701 A2=n690 B1=n640 B2=n696
XU666 NR2 $PINS O=n674 I1=n642 I2=n641
XU667 INV1S $PINS O=n644 I=n649
XU668 NR2 $PINS O=n651 I1=FE_OFN297_FE_DBTN81_n691 I2=FE_DBTN72_n655
XU670 NR2 $PINS O=n650 I1=FE_DBTN73_n695 I2=FE_DBTN71_n637
XU671 MAO222 $PINS O=n673 A1=n644 B1=n651 C1=n650
XU672 XNR3 $PINS O=n675 I1=n645 I2=n646 I3=n648
XU673 XOR3 $PINS O=intadd_60/A[2] I1=n674 I2=n673 I3=n675
XU674 NR2P $PINS O=n679 I1=n692 I2=n646
XU675 AO12 $PINS O=n647 A1=n655 B1=FE_OFN666_n654 B2=n690
XU676 XOR3 $PINS O=n676 I1=n651 I2=n650 I3=n649
XU677 XOR3 $PINS O=intadd_60/A[1] I1=n679 I2=n677 I3=n676
XU678 NR2 $PINS O=n697 I1=FE_DBTN73_n695 I2=FE_DBTN81_n691
XU679 NR2 $PINS O=n681 I1=n653 I2=FE_DBTN71_n637
XU680 AOI22S $PINS O=n656 A1=FE_OFN1146_n695 A2=n655 B1=FE_OCPN2943_n654
+ B2=n696
XU681 NR2 $PINS O=n682 I1=n656 I2=n679
XU682 XOR3 $PINS O=intadd_60/A[0] I1=n697 I2=n681 I3=n682
XU683 MAO222 $PINS O=intadd_60/B[7] A1=n659 B1=n658 C1=n657
XU684 INV1S $PINS O=n664 I=n660
XU685 INV1S $PINS O=n662 I=n661
XU686 MAO222 $PINS O=intadd_60/B[6] A1=n664 B1=n663 C1=n662
XU687 MAO222 $PINS O=intadd_60/B[5] A1=n667 B1=n666 C1=n665
XU688 INV1S $PINS O=n671 I=n668
XU689 INV1S $PINS O=n670 I=n669
XU690 MAO222 $PINS O=intadd_60/B[4] A1=n672 B1=n671 C1=n670
XU691 MAO222 $PINS O=intadd_60/B[3] A1=n675 B1=n674 C1=n673
XU692 INV1S $PINS O=n680 I=n676
XU693 INV1S $PINS O=n678 I=n677
XU694 MAO222 $PINS O=intadd_60/B[2] A1=n680 B1=n679 C1=n678
XU695 MAO222 $PINS O=intadd_60/B[1] A1=n682 B1=n697 C1=n681
XU696 INV1S $PINS O=n685 I=n689
XU697 NR2 $PINS O=n686 I1=n89 I2=FE_DBTN71_n637
XU698 OA12 $PINS O=intadd_60/B[0] A1=n687 B1=n685 B2=n686
XU699 XOR2HS $PINS O=n688 I1=n687 I2=n686
XU700 XOR2HS $PINS O=n714 I1=n689 I2=n688
XU701 XNR2HS $PINS O=n716 I1=n693 I2=n692
XU702 OAI22S $PINS O=n699 A1=n718 A2=n716 B1=n695 B2=FE_DBTN81_n691
XU703 AOI12HS $PINS O=n698 A1=n717 B1=n716 B2=n718
XU704 NR2 $PINS O=n715 I1=n699 I2=n698
XU705 NR2 $PINS O=intadd_60/CI I1=n714 I2=n715
XU706 NR2 $PINS O=n702 I1=FE_OFN670_n701 I2=FE_OFN669_n700
XU707 XOR2HS $PINS O=N17 I1=n702 I2=intadd_60/n1
XU708 INV1S $PINS O=n703 I=s1_P2[10]
XU709 OR2 $PINS O=n712 I1=n703 I2=n713
XU710 NR2 $PINS O=n708 I1=n704 I2=n712
XU711 XNR2HS $PINS O=FE_PHN3290_trace_sq_33 I1=s1_P2[15] I2=n706
XU712 INV1S $PINS O=n705 I=FE_PHN3209_s1_P2_13
XU713 INV1S $PINS O=n710 I=n708
XU714 NR2 $PINS O=n707 I1=n705 I2=n710
XU715 OA12 $PINS O=trace_sq[32] A1=n706 B1=s1_P2[14] B2=n707
XU716 XOR2HS $PINS O=trace_sq[31] I1=FE_PHN3209_s1_P2_13 I2=n708
XU717 INV1S $PINS O=n709 I=s1_P2[11]
XU718 NR2 $PINS O=n711 I1=n709 I2=n712
XU719 OA12 $PINS O=trace_sq[30] A1=n710 B1=FE_PHN3213_s1_P2_12 B2=n711
XU720 XNR2HS $PINS O=trace_sq[29] I1=FE_PHN3126_s1_P2_11 I2=n712
XU721 XNR2HS $PINS O=trace_sq[28] I1=FE_PHN3302_s1_P2_10 I2=n713
XU722 XOR2HS $PINS O=trace_sq[19] I1=s1_P1[9] I2=intadd_61/n1
XU723 XOR2HS $PINS O=trace_sq[10] I1=s1_P0[10] I2=s1_P1[0]
XU724 AOI12HS $PINS O=N7 A1=intadd_60/CI B1=n715 B2=n714
XU725 XNR3 $PINS O=N6 I1=n718 I2=n717 I3=n716
XR_28 QDFFRSBN $PINS Q=DP_OP_18J1_127_8258/n162 D=FE_PHN3080_n725 CK=clk_clone3
+ RB=n750 SB=FE_OFN16_i_reset_n_i
Xdet_reg_reg[24] QDFFRBS $PINS Q=det_reg[24] D=FE_PHN2957_s1_det_24
+ CK=clk_clone1 RB=FE_OFN21_i_reset_n_i
Xs1_P0_reg[9] QDFFRBS $PINS Q=trace_sq[9] D=N10 CK=clk_clone4
+ RB=FE_OFN121_i_reset_n_i
Xs1_P2_reg[5] QDFFRBS $PINS Q=s1_P2[5] D=N41 CK=clk_clone2
+ RB=FE_OFN23_i_reset_n_i
Xs1_P1_reg[6] QDFFRBS $PINS Q=s1_P1[6] D=N25 CK=clk_clone2
+ RB=FE_OFN43_i_reset_n_i
Xs1_det_reg[23] QDFFRBS $PINS Q=FE_PHN3104_s1_det_23 D=det[23] CK=clk_clone1
+ RB=FE_OFN86_i_reset_n_i
Xs1_det_reg[8] QDFFRBS $PINS Q=s1_det[8] D=det[8] CK=clk_clone4
+ RB=FE_OFN122_i_reset_n_i
Xtrace_sq_reg_reg[26] QDFFRBS $PINS Q=trace_sq_reg[26] D=trace_sq[26]
+ CK=clk_clone2 RB=FE_OFN50_i_reset_n_i
Xtrace_sq_reg_reg[11] QDFFRBS $PINS Q=trace_sq_reg[11] D=FE_PHN3242_trace_sq_11
+ CK=clk_clone4 RB=FE_OFN77_i_reset_n_i
Xdet_reg_reg[23] QDFFRBS $PINS Q=det_reg[23] D=s1_det[23] CK=clk_clone1
+ RB=FE_OFN49_i_reset_n_i
Xdet_reg_reg[8] QDFFRBS $PINS Q=det_reg[8] D=FE_PHN3085_s1_det_8 CK=clk_clone4
+ RB=FE_OFN122_i_reset_n_i
XU13 ND2 $PINS O=n70 I1=n84 I2=n60
XU14 ND2 $PINS O=n122 I1=n164 I2=n66
XU18 ND2S $PINS O=n148 I1=n134 I2=n95
XU27 ND2S $PINS O=n713 I1=intadd_62/n1 I2=s1_P2[9]
XU29 TIE1 $PINS O=n750
.ENDS

.SUBCKT LK clk rst_n a[7] a[6] a[5] a[4] a[3] a[2] a[1] a[0] b[7] b[6] b[5]
+ b[4] b[3] b[2] b[1] b[0] valid Vout[11] Vout[10] Vout[9] Vout[8] Vout[7]
+ Vout[6] Vout[5] Vout[4] Vout[3] Vout[2] Vout[1] Vout[0]
XFE_PHC3305_a_reg_6 BUF1CK $PINS O=FE_PHN3305_a_reg_6 I=a_reg[6]
XFE_PHC3304_a_reg_7 BUF1CK $PINS O=FE_PHN3283_a_reg_7 I=FE_PHN3304_a_reg_7
XFE_PHC3303_n3606 BUF1CK $PINS O=FE_PHN3303_n3606 I=n3606
XFE_PHC3300_img1_1_2 BUF1S $PINS O=FE_PHN3300_img1_1_2 I=img1[1][2]
XFE_PHC3298_n1186 BUF1CK $PINS O=FE_PHN3298_n1186 I=n1186
XFE_PHC3297_n3607 BUF1CK $PINS O=FE_PHN3297_n3607 I=n3607
XFE_PHC3296_n1029 BUF6CK $PINS O=FE_PHN3296_n1029 I=n1029
XFE_PHC3295_n1140 BUF1CK $PINS O=n1140 I=FE_PHN3295_n1140
XFE_PHC3293_n1076 DELA $PINS O=n1076 I=FE_PHN3293_n1076
XFE_PHC3292_N591 BUF4 $PINS O=FE_PHN3292_N591 I=N591
XFE_PHC3291_N592 DELA $PINS O=N592 I=FE_PHN3291_N592
XFE_PHC3289_col_reg_0 BUF1CK $PINS O=col_reg[0] I=FE_PHN3289_col_reg_0
XFE_PHC3288_Iy2_20 BUF1CK $PINS O=Iy2[20] I=FE_PHN3288_Iy2_20
XFE_PHC3287_Iy2_21 BUF1CK $PINS O=Iy2[21] I=FE_PHN3287_Iy2_21
XFE_PHC3286_IyIt_9 BUF1CK $PINS O=IyIt[9] I=FE_PHN3286_IyIt_9
XFE_PHC3285_a_reg_6 BUF1S $PINS O=FE_PHN3285_a_reg_6 I=FE_PHN3305_a_reg_6
XFE_PHC3284_a_reg_5 BUF1S $PINS O=FE_PHN3284_a_reg_5 I=a_reg[5]
XFE_PHC3283_a_reg_7 BUF1S $PINS O=a_reg[7] I=FE_PHN3283_a_reg_7
XFE_PHC3282_Ix2_7 BUF1CK $PINS O=FE_PHN3282_Ix2_7 I=Ix2[7]
XFE_PHC3280_IxIy_IyIt_27 BUF1CK $PINS O=FE_PHN3280_IxIy_IyIt_27 I=IxIy_IyIt[27]
XFE_PHC3279_mul_pos_buffer_3 BUF1CK $PINS O=FE_PHN3279_mul_pos_buffer_3
+ I=mul_pos_buffer[3]
XFE_PHC3276_IxIy_IyIt_29 BUF1CK $PINS O=FE_PHN3276_IxIy_IyIt_29 I=IxIy_IyIt[29]
XFE_PHC3275_IxIy_IyIt_30 BUF1CK $PINS O=FE_PHN3275_IxIy_IyIt_30 I=IxIy_IyIt[30]
XFE_PHC3274_Ix2_16 BUF1CK $PINS O=FE_PHN3274_Ix2_16 I=Ix2[16]
XFE_PHC3273_Uy_29 BUF1CK $PINS O=FE_PHN3273_Uy_29 I=Uy[29]
XFE_PHC3272_IyIt_7 BUF1CK $PINS O=FE_PHN3272_IyIt_7 I=IyIt[7]
XFE_PHC3271_IxIt_17 BUF1CK $PINS O=FE_PHN3271_IxIt_17 I=IxIt[17]
XFE_PHC3270_n2898 BUF1CK $PINS O=FE_PHN3270_n2898 I=n2898
XFE_PHC3268_Iy2_3 BUF4CK $PINS O=FE_PHN3268_Iy2_3 I=Iy2[3]
XFE_PHC3267_Ix2_8 BUF1CK $PINS O=FE_PHN3267_Ix2_8 I=Ix2[8]
XFE_PHC3266_Uy_30 BUF1CK $PINS O=FE_PHN3266_Uy_30 I=Uy[30]
XFE_PHC3265_Uy_26 BUF1CK $PINS O=FE_PHN3265_Uy_26 I=Uy[26]
XFE_PHC3263_n1350 BUF1CK $PINS O=FE_PHN3263_n1350 I=n1350
XFE_PHC3262_Iy2_0 BUF1CK $PINS O=FE_PHN3262_Iy2_0 I=Iy2[0]
XFE_PHC3261_Ux_20 BUF1CK $PINS O=Ux[20] I=FE_PHN3261_Ux_20
XFE_PHC3260_Iy2_10 BUF1CK $PINS O=FE_PHN3260_Iy2_10 I=Iy2[10]
XFE_PHC3257_Ux_24 BUF1CK $PINS O=FE_PHN3257_Ux_24 I=Ux[24]
XFE_PHC3256_Ux_26 BUF1CK $PINS O=FE_PHN3256_Ux_26 I=Ux[26]
XFE_PHC3255_Iy2_9 BUF1CK $PINS O=FE_PHN3255_Iy2_9 I=Iy2[9]
XFE_PHC3254_n3856 BUF1CK $PINS O=FE_PHN3254_n3856 I=n3856
XFE_PHC3253_Ix2_18 BUF2CK $PINS O=FE_PHN3253_Ix2_18 I=Ix2[18]
XFE_PHC3252_IxIy_20 BUF1CK $PINS O=FE_PHN3252_IxIy_20 I=IxIy[20]
XFE_PHC3251_Ix2_5 BUF1CK $PINS O=FE_PHN3251_Ix2_5 I=Ix2[5]
XFE_PHC3249_Iy2_11 BUF2CK $PINS O=FE_PHN3249_Iy2_11 I=Iy2[11]
XFE_PHC3248_Ix2_6 BUF1CK $PINS O=FE_PHN3248_Ix2_6 I=Ix2[6]
XFE_PHC3247_IxIy_21 BUF1CK $PINS O=FE_PHN3247_IxIy_21 I=IxIy[21]
XFE_PHC3246_Iy2_7 BUF1CK $PINS O=FE_PHN3246_Iy2_7 I=Iy2[7]
XFE_PHC3245_n1308 BUF1CK $PINS O=FE_PHN3245_n1308 I=n1308
XFE_PHC3244_Iy2_8 BUF1CK $PINS O=FE_PHN3244_Iy2_8 I=Iy2[8]
XFE_PHC3243_Iy2_6 BUF1CK $PINS O=FE_PHN3243_Iy2_6 I=Iy2[6]
XFE_PHC3239_Iy2_12 BUF1CK $PINS O=FE_PHN3239_Iy2_12 I=Iy2[12]
XFE_PHC3237_img1_1_2 BUF12CK $PINS O=img1[1][2] I=FE_PHN3237_img1_1_2
XFE_PHC3236_n1347 BUF1CK $PINS O=FE_PHN3236_n1347 I=n1347
XFE_PHC3233_n1332 BUF1CK $PINS O=FE_PHN3233_n1332 I=n1332
XFE_PHC3231_It_3_4 BUF2CK $PINS O=It[3][4] I=FE_PHN3231_It_3_4
XFE_PHC3230_Iy2_15 BUF2CK $PINS O=FE_PHN3230_Iy2_15 I=Iy2[15]
XFE_PHC3229_n2901 BUF1CK $PINS O=FE_PHN3229_n2901 I=n2901
XFE_PHC3228_Iy2_5 BUF1CK $PINS O=FE_PHN3228_Iy2_5 I=Iy2[5]
XFE_PHC3227_It_0_0 BUF1CK $PINS O=FE_PHN3227_It_0_0 I=It[0][0]
XFE_PHC3225_Iy2_14 BUF1CK $PINS O=FE_PHN3225_Iy2_14 I=Iy2[14]
XFE_PHC3224_Ix_3_7 BUF4CK $PINS O=Ix[3][7] I=FE_PHN3224_Ix_3_7
XFE_PHC3221_It_1_6 BUF1CK $PINS O=It[1][6] I=FE_PHN3221_It_1_6
XFE_PHC3220_Iy2_19 BUF1CK $PINS O=FE_PHN3220_Iy2_19 I=Iy2[19]
XFE_PHC3219_col_reg_3 BUF1CK $PINS O=FE_PHN3219_col_reg_3 I=col_reg[3]
XFE_PHC3218_mul_pos_buffer_0 BUF1CK $PINS O=FE_PHN3218_mul_pos_buffer_0
+ I=mul_pos_buffer[0]
XFE_PHC3215_It_1_7 BUF1CK $PINS O=It[1][7] I=FE_PHN3215_It_1_7
XFE_PHC3214_row_reg_0 BUF1CK $PINS O=FE_PHN3214_row_reg_0 I=row_reg[0]
XFE_PHC3212_It_1_0 BUF1CK $PINS O=FE_PHN3212_It_1_0 I=It[1][0]
XFE_PHC3211_Ix_1_3 BUF1CK $PINS O=FE_PHN3211_Ix_1_3 I=Ix[1][3]
XFE_PHC3210_Ix_3_8 BUF1CK $PINS O=FE_PHN3210_Ix_3_8 I=Ix[3][8]
XFE_PHC3208_Ix_1_4 BUF1CK $PINS O=FE_PHN3208_Ix_1_4 I=Ix[1][4]
XFE_PHC3207_It_1_8 BUF1CK $PINS O=It[1][8] I=FE_PHN3207_It_1_8
XFE_PHC3206_Ix_2_6 BUF1CK $PINS O=Ix[2][6] I=FE_PHN3206_Ix_2_6
XFE_PHC3205_start_valid BUF4 $PINS O=FE_PHN3205_start_valid I=start_valid
XFE_PHC3204_Ix_1_7 BUF1CK $PINS O=FE_PHN3204_Ix_1_7 I=Ix[1][7]
XFE_PHC3203_Uy_0 DELA $PINS O=FE_PHN3203_Uy_0 I=Uy[0]
XFE_PHC3201_It_2_1 BUF1CK $PINS O=It[2][1] I=FE_PHN3201_It_2_1
XFE_PHC3199_Ix_1_8 BUF1CK $PINS O=Ix[1][8] I=FE_PHN3199_Ix_1_8
XFE_PHC3198_Ix_4_5 BUF1CK $PINS O=Ix[4][5] I=FE_PHN3198_Ix_4_5
XFE_PHC3197_Ix_2_5 BUF1CK $PINS O=Ix[2][5] I=FE_PHN3197_Ix_2_5
XFE_PHC3196_It_1_5 BUF1CK $PINS O=It[1][5] I=FE_PHN3196_It_1_5
XFE_PHC3195_IxIt_22 BUF1CK $PINS O=FE_PHN3195_IxIt_22 I=IxIt[22]
XFE_PHC3194_It_3_2 BUF1CK $PINS O=FE_PHN3194_It_3_2 I=It[3][2]
XFE_PHC3193_Ix_3_6 BUF1CK $PINS O=FE_PHN3193_Ix_3_6 I=Ix[3][6]
XFE_PHC3192_It_3_5 BUF1CK $PINS O=It[3][5] I=FE_PHN3192_It_3_5
XFE_PHC3191_Ix_2_4 BUF1CK $PINS O=FE_PHN3191_Ix_2_4 I=Ix[2][4]
XFE_PHC3190_It_1_1 BUF1CK $PINS O=FE_PHN3190_It_1_1 I=It[1][1]
XFE_PHC3189_mul_pos_buffer_4 BUF1CK $PINS O=FE_PHN3189_mul_pos_buffer_4
+ I=mul_pos_buffer[4]
XFE_PHC3188_It_3_3 BUF1CK $PINS O=It[3][3] I=FE_PHN3188_It_3_3
XFE_PHC3187_Ix_2_7 BUF1CK $PINS O=FE_PHN3187_Ix_2_7 I=Ix[2][7]
XFE_PHC3185_Ix_4_2 BUF1CK $PINS O=FE_PHN3185_Ix_4_2 I=Ix[4][2]
XFE_PHC3184_Ix_1_2 BUF1CK $PINS O=FE_PHN3184_Ix_1_2 I=Ix[1][2]
XFE_PHC3183_Ux_0 BUF3 $PINS O=FE_PHN3183_Ux_0 I=Ux[0]
XFE_PHC3182_Ix_1_6 BUF1CK $PINS O=FE_PHN3182_Ix_1_6 I=Ix[1][6]
XFE_PHC3181_a_reg_0 DELA $PINS O=FE_PHN3181_a_reg_0 I=a_reg[0]
XFE_PHC3180_It_3_1 BUF1CK $PINS O=It[3][1] I=FE_PHN3180_It_3_1
XFE_PHC3179_It_2_7 BUF1CK $PINS O=FE_PHN3179_It_2_7 I=It[2][7]
XFE_PHC3178_Ix_4_6 BUF1CK $PINS O=FE_PHN3178_Ix_4_6 I=Ix[4][6]
XFE_PHC3177_It_3_0 BUF1CK $PINS O=FE_PHN3177_It_3_0 I=It[3][0]
XFE_PHC3176_Ix_1_1 BUF1CK $PINS O=Ix[1][1] I=FE_PHN3176_Ix_1_1
XFE_PHC3175_Ix_4_8 BUF1CK $PINS O=FE_PHN3175_Ix_4_8 I=Ix[4][8]
XFE_PHC3174_It_2_2 BUF1CK $PINS O=It[2][2] I=FE_PHN3174_It_2_2
XFE_PHC3173_It_2_4 BUF1CK $PINS O=It[2][4] I=FE_PHN3173_It_2_4
XFE_PHC3172_It_2_3 BUF1CK $PINS O=It[2][3] I=FE_PHN3172_It_2_3
XFE_PHC3171_Ix_2_3 BUF1CK $PINS O=Ix[2][3] I=FE_PHN3171_Ix_2_3
XFE_PHC3170_Ix_4_3 BUF1CK $PINS O=Ix[4][3] I=FE_PHN3170_Ix_4_3
XFE_PHC3169_It_3_7 BUF1CK $PINS O=It[3][7] I=FE_PHN3169_It_3_7
XFE_PHC3167_It_2_6 BUF1CK $PINS O=It[2][6] I=FE_PHN3167_It_2_6
XFE_PHC3166_It_2_5 BUF1CK $PINS O=It[2][5] I=FE_PHN3166_It_2_5
XFE_PHC3165_Ix_2_0 BUF1CK $PINS O=FE_PHN3165_Ix_2_0 I=Ix[2][0]
XFE_PHC3164_Ix_3_5 BUF1CK $PINS O=FE_PHN3164_Ix_3_5 I=Ix[3][5]
XFE_PHC3163_Ix_4_1 BUF1CK $PINS O=Ix[4][1] I=FE_PHN3163_Ix_4_1
XFE_PHC3162_It_3_6 BUF1CK $PINS O=It[3][6] I=FE_PHN3162_It_3_6
XFE_PHC3161_It_1_4 BUF1CK $PINS O=It[1][4] I=FE_PHN3161_It_1_4
XFE_PHC3160_It_1_3 BUF1CK $PINS O=FE_PHN3160_It_1_3 I=It[1][3]
XFE_PHC3159_Ix_2_2 BUF1CK $PINS O=FE_PHN3159_Ix_2_2 I=Ix[2][2]
XFE_PHC3158_Ix_3_3 BUF1CK $PINS O=FE_PHN3158_Ix_3_3 I=Ix[3][3]
XFE_PHC3156_Iy2_22 BUF1CK $PINS O=FE_PHN3156_Iy2_22 I=Iy2[22]
XFE_PHC3155_It_3_8 BUF1CK $PINS O=FE_PHN3155_It_3_8 I=It[3][8]
XFE_PHC3154_Ix_2_8 BUF1CK $PINS O=Ix[2][8] I=FE_PHN3154_Ix_2_8
XFE_PHC3153_Ix_4_0 BUF1CK $PINS O=FE_PHN3153_Ix_4_0 I=Ix[4][0]
XFE_PHC3152_Ix_4_7 BUF1CK $PINS O=Ix[4][7] I=FE_PHN3152_Ix_4_7
XFE_PHC3151_Ix_1_0 BUF1CK $PINS O=FE_PHN3151_Ix_1_0 I=Ix[1][0]
XFE_PHC3150_Ix_4_4 BUF1CK $PINS O=Ix[4][4] I=FE_PHN3150_Ix_4_4
XFE_PHC3149_Ix_3_2 BUF1CK $PINS O=Ix[3][2] I=FE_PHN3149_Ix_3_2
XFE_PHC3148_It_2_8 BUF1CK $PINS O=FE_PHN3148_It_2_8 I=It[2][8]
XFE_PHC3147_Ix_3_4 BUF1CK $PINS O=Ix[3][4] I=FE_PHN3147_Ix_3_4
XFE_PHC3145_It_2_0 BUF1CK $PINS O=It[2][0] I=FE_PHN3145_It_2_0
XFE_PHC3144_It_1_2 BUF1CK $PINS O=It[1][2] I=FE_PHN3144_It_1_2
XFE_PHC3143_Ix_3_0 BUF1CK $PINS O=Ix[3][0] I=FE_PHN3143_Ix_3_0
XFE_PHC3142_img1_12_1 DELB $PINS O=FE_PHN3142_img1_12_1 I=img1[12][1]
XFE_PHC3141_img1_12_3 DELB $PINS O=FE_PHN3141_img1_12_3 I=img1[12][3]
XFE_PHC3140_Ix_3_1 BUF1CK $PINS O=FE_PHN3140_Ix_3_1 I=Ix[3][1]
XFE_PHC3138_img1_12_4 DELB $PINS O=FE_PHN3138_img1_12_4 I=img1[12][4]
XFE_PHC3137_img1_12_0 DELB $PINS O=FE_PHN3137_img1_12_0 I=img1[12][0]
XFE_PHC3136_Ix_2_1 BUF1CK $PINS O=FE_PHN3136_Ix_2_1 I=Ix[2][1]
XFE_PHC3134_img1_12_5 DELB $PINS O=FE_PHN3134_img1_12_5 I=img1[12][5]
XFE_PHC3132_img1_12_2 DELB $PINS O=FE_PHN3132_img1_12_2 I=img1[12][2]
XFE_PHC3131_img1_12_7 DELB $PINS O=FE_PHN3131_img1_12_7 I=img1[12][7]
XFE_PHC3127_img1_12_6 DELB $PINS O=FE_PHN3127_img1_12_6 I=img1[12][6]
XFE_PHC3120_img1_5_7 DELB $PINS O=FE_PHN3120_img1_5_7 I=img1[5][7]
XFE_PHC3115_img1_1_3 DELB $PINS O=FE_PHN3115_img1_1_3 I=img1[1][3]
XFE_PHC3113_img1_2_5 DELB $PINS O=img1[2][5] I=FE_PHN3113_img1_2_5
XFE_PHC3110_img1_2_4 DELB $PINS O=img1[2][4] I=FE_PHN3110_img1_2_4
XFE_PHC3106_img1_2_0 DELB $PINS O=img1[2][0] I=FE_PHN3106_img1_2_0
XFE_PHC3100_img1_8_6 DELB $PINS O=FE_PHN3100_img1_8_6 I=img1[8][6]
XFE_PHC3099_img1_13_0 DELB $PINS O=img1[13][0] I=FE_PHN3099_img1_13_0
XFE_PHC3091_img1_4_0 DELB $PINS O=img1[4][0] I=FE_PHN3091_img1_4_0
XFE_PHC3088_img1_2_3 DELB $PINS O=FE_PHN3088_img1_2_3 I=img1[2][3]
XFE_PHC3087_img1_9_4 DELB $PINS O=FE_PHN3087_img1_9_4 I=img1[9][4]
XFE_PHC3082_img1_8_7 DELB $PINS O=img1[8][7] I=FE_PHN3082_img1_8_7
XFE_PHC3081_img1_9_0 DELB $PINS O=FE_PHN3081_img1_9_0 I=img1[9][0]
XFE_PHC3076_img1_4_6 DELB $PINS O=FE_PHN3076_img1_4_6 I=img1[4][6]
XFE_PHC3075_img1_8_5 DELB $PINS O=img1[8][5] I=FE_PHN3075_img1_8_5
XFE_PHC3074_img1_5_4 DELB $PINS O=img1[5][4] I=FE_PHN3074_img1_5_4
XFE_PHC3070_img1_3_1 DELB $PINS O=img1[3][1] I=FE_PHN3070_img1_3_1
XFE_PHC3067_img1_4_3 DELB $PINS O=img1[4][3] I=FE_PHN3067_img1_4_3
XFE_PHC3066_img1_1_5 DELB $PINS O=FE_PHN3066_img1_1_5 I=img1[1][5]
XFE_PHC3064_img1_6_7 DELB $PINS O=FE_PHN3064_img1_6_7 I=img1[6][7]
XFE_PHC3063_img1_11_1 DELB $PINS O=FE_PHN3063_img1_11_1 I=img1[11][1]
XFE_PHC3062_img1_10_0 DELB $PINS O=img1[10][0] I=FE_PHN3062_img1_10_0
XFE_PHC3061_img1_5_2 DELB $PINS O=FE_PHN3061_img1_5_2 I=img1[5][2]
XFE_PHC3058_img1_3_4 DELB $PINS O=FE_PHN3058_img1_3_4 I=img1[3][4]
XFE_PHC3057_img1_10_6 DELB $PINS O=img1[10][6] I=FE_PHN3057_img1_10_6
XFE_PHC3056_img1_7_0 DELB $PINS O=FE_PHN3056_img1_7_0 I=img1[7][0]
XFE_PHC3055_img1_5_3 DELB $PINS O=FE_PHN3055_img1_5_3 I=img1[5][3]
XFE_PHC3053_img1_13_2 DELB $PINS O=FE_PHN3053_img1_13_2 I=img1[13][2]
XFE_PHC3052_img1_10_3 DELB $PINS O=FE_PHN3052_img1_10_3 I=img1[10][3]
XFE_PHC3051_img1_9_3 DELB $PINS O=img1[9][3] I=FE_PHN3051_img1_9_3
XFE_PHC3050_img1_7_1 DELB $PINS O=img1[7][1] I=FE_PHN3050_img1_7_1
XFE_PHC3049_img1_11_3 DELB $PINS O=FE_PHN3049_img1_11_3 I=img1[11][3]
XFE_PHC3048_img1_2_7 DELB $PINS O=FE_PHN3048_img1_2_7 I=img1[2][7]
XFE_PHC3047_img1_11_7 DELB $PINS O=img1[11][7] I=FE_PHN3047_img1_11_7
XFE_PHC3046_img1_11_5 DELB $PINS O=FE_PHN3046_img1_11_5 I=img1[11][5]
XFE_PHC3045_img1_1_1 DELB $PINS O=img1[1][1] I=FE_PHN3045_img1_1_1
XFE_PHC3044_img1_10_2 DELB $PINS O=FE_PHN3044_img1_10_2 I=img1[10][2]
XFE_PHC3043_img1_8_3 DELB $PINS O=FE_PHN3043_img1_8_3 I=img1[8][3]
XFE_PHC3041_img1_13_4 DELB $PINS O=FE_PHN3041_img1_13_4 I=img1[13][4]
XFE_PHC3040_img1_4_5 DELB $PINS O=img1[4][5] I=FE_PHN3040_img1_4_5
XFE_PHC3039_img1_6_6 DELB $PINS O=img1[6][6] I=FE_PHN3039_img1_6_6
XFE_PHC3038_img1_8_2 DELB $PINS O=FE_PHN3038_img1_8_2 I=img1[8][2]
XFE_PHC3037_img1_1_7 DELB $PINS O=FE_PHN3037_img1_1_7 I=img1[1][7]
XFE_PHC3036_img1_5_1 DELB $PINS O=img1[5][1] I=FE_PHN3036_img1_5_1
XFE_PHC3035_img1_7_2 DELB $PINS O=img1[7][2] I=FE_PHN3035_img1_7_2
XFE_PHC3034_img1_1_4 DELB $PINS O=FE_PHN3034_img1_1_4 I=img1[1][4]
XFE_PHC3033_img1_5_0 DELB $PINS O=FE_PHN3033_img1_5_0 I=img1[5][0]
XFE_PHC3032_img1_9_2 DELB $PINS O=FE_PHN3032_img1_9_2 I=img1[9][2]
XFE_PHC3031_img1_6_4 DELB $PINS O=img1[6][4] I=FE_PHN3031_img1_6_4
XFE_PHC3029_img1_4_2 DELB $PINS O=img1[4][2] I=FE_PHN3029_img1_4_2
XFE_PHC3028_img1_8_1 DELB $PINS O=FE_PHN3028_img1_8_1 I=img1[8][1]
XFE_PHC3025_img1_10_4 DELB $PINS O=FE_PHN3025_img1_10_4 I=img1[10][4]
XFE_PHC3023_img1_6_3 DELB $PINS O=img1[6][3] I=FE_PHN3023_img1_6_3
XFE_PHC3022_img1_5_6 DELB $PINS O=FE_PHN3022_img1_5_6 I=img1[5][6]
XFE_PHC3021_img1_10_1 DELB $PINS O=FE_PHN3021_img1_10_1 I=img1[10][1]
XFE_PHC3020_img1_2_2 DELB $PINS O=FE_PHN3020_img1_2_2 I=img1[2][2]
XFE_PHC3019_img1_4_1 DELB $PINS O=FE_PHN3019_img1_4_1 I=img1[4][1]
XFE_PHC3018_img1_5_5 DELB $PINS O=FE_PHN3018_img1_5_5 I=img1[5][5]
XFE_PHC3017_img1_7_4 DELB $PINS O=img1[7][4] I=FE_PHN3017_img1_7_4
XFE_PHC3016_img1_7_3 DELB $PINS O=img1[7][3] I=FE_PHN3016_img1_7_3
XFE_PHC3015_img1_11_2 DELB $PINS O=FE_PHN3015_img1_11_2 I=img1[11][2]
XFE_PHC3013_img1_3_0 DELB $PINS O=FE_PHN3013_img1_3_0 I=img1[3][0]
XFE_PHC3012_img1_10_5 DELB $PINS O=img1[10][5] I=FE_PHN3012_img1_10_5
XFE_PHC3010_img1_1_6 DELB $PINS O=FE_PHN3010_img1_1_6 I=img1[1][6]
XFE_PHC3007_img1_6_0 DELB $PINS O=img1[6][0] I=FE_PHN3007_img1_6_0
XFE_PHC3003_img1_13_7 DELB $PINS O=FE_PHN3003_img1_13_7 I=img1[13][7]
XFE_PHC3002_img1_13_6 DELB $PINS O=FE_PHN3002_img1_13_6 I=img1[13][6]
XFE_PHC3001_img1_3_7 DELB $PINS O=FE_PHN3001_img1_3_7 I=img1[3][7]
XFE_PHC2998_img1_2_6 DELB $PINS O=img1[2][6] I=FE_PHN2998_img1_2_6
XFE_PHC2997_img1_4_7 DELB $PINS O=FE_PHN2997_img1_4_7 I=img1[4][7]
XFE_PHC2996_img1_2_1 DELB $PINS O=img1[2][1] I=FE_PHN2996_img1_2_1
XFE_PHC2994_img1_11_4 DELB $PINS O=FE_PHN2994_img1_11_4 I=img1[11][4]
XFE_PHC2993_img1_8_4 DELB $PINS O=FE_PHN2993_img1_8_4 I=img1[8][4]
XFE_PHC2992_img1_6_1 DELB $PINS O=img1[6][1] I=FE_PHN2992_img1_6_1
XFE_PHC2991_img1_3_2 DELB $PINS O=FE_PHN2991_img1_3_2 I=img1[3][2]
XFE_PHC2990_img1_9_1 DELB $PINS O=FE_PHN2990_img1_9_1 I=img1[9][1]
XFE_PHC2989_img1_6_2 DELB $PINS O=FE_PHN2989_img1_6_2 I=img1[6][2]
XFE_PHC2986_img1_8_0 DELB $PINS O=FE_PHN2986_img1_8_0 I=img1[8][0]
XFE_PHC2985_img1_4_4 DELB $PINS O=FE_PHN2985_img1_4_4 I=img1[4][4]
XFE_PHC2981_img1_7_5 DELB $PINS O=FE_PHN2981_img1_7_5 I=img1[7][5]
XFE_PHC2980_img1_13_5 DELB $PINS O=FE_PHN2980_img1_13_5 I=img1[13][5]
XFE_PHC2979_img1_3_6 DELB $PINS O=FE_PHN2979_img1_3_6 I=img1[3][6]
XFE_PHC2978_img1_11_0 DELB $PINS O=FE_PHN2978_img1_11_0 I=img1[11][0]
XFE_PHC2977_img1_3_3 DELB $PINS O=FE_PHN2977_img1_3_3 I=img1[3][3]
XFE_PHC2974_img1_6_5 DELB $PINS O=FE_PHN2974_img1_6_5 I=img1[6][5]
XFE_PHC2973_img1_9_5 DELB $PINS O=FE_PHN2973_img1_9_5 I=img1[9][5]
XFE_PHC2972_img1_3_5 DELB $PINS O=img1[3][5] I=FE_PHN2972_img1_3_5
XFE_PHC2970_img1_9_6 DELB $PINS O=FE_PHN2970_img1_9_6 I=img1[9][6]
XFE_PHC2969_img1_7_6 DELB $PINS O=FE_PHN2969_img1_7_6 I=img1[7][6]
XFE_PHC2968_img1_9_7 DELB $PINS O=FE_PHN2968_img1_9_7 I=img1[9][7]
XFE_PHC2967_img1_13_3 DELB $PINS O=FE_PHN2967_img1_13_3 I=img1[13][3]
XFE_PHC2966_img1_10_7 DELB $PINS O=img1[10][7] I=FE_PHN2966_img1_10_7
XFE_PHC2963_img1_13_1 DELB $PINS O=FE_PHN2963_img1_13_1 I=img1[13][1]
XFE_PHC2954_img1_11_6 DELB $PINS O=FE_PHN2954_img1_11_6 I=img1[11][6]
XFE_PHC2952_img1_1_0 DELB $PINS O=img1[1][0] I=FE_PHN2952_img1_1_0
XFE_PHC2947_img1_7_7 DELB $PINS O=FE_PHN2947_img1_7_7 I=img1[7][7]
XFE_RC_40_1 XOR2HS $PINS O=FE_OFN821_n4336 I1=a_reg[0] I2=img1[12][0]
XFE_RC_39_1 MOAI1S $PINS O=n2616 A1=FE_OFN2730_FE_DBTN8_n1705 A2=IxIy[15]
+ B1=FE_OFN4248_FE_OFN758_n1715 B2=intadd_35/A[1]
XFE_RC_38_1 MOAI1S $PINS O=intadd_4/B[0] A1=n4266 A2=IyIt[6] B1=n4266
+ B2=IyIt[6]
XFE_RC_37_0 MOAI1 $PINS O=n4240 A1=n4238 A2=FE_PHN3247_IxIy_21 B1=n4238
+ B2=FE_OFN579_IxIy_21
XFE_RC_36_0 AOI12H $PINS O=n3392 A1=n2193 B1=n3394 B2=n3657
XFE_RC_35_0 OR2 $PINS O=FE_RN_22_1 I1=n2647 I2=FE_OFN927_n2619
XFE_RC_34_1 ND3P $PINS O=n2891 I1=n2590 I2=FE_RN_22_1 I3=n2589
XFE_RC_32_1 ND2S $PINS O=FE_RN_21_0 I1=n4086 I2=intadd_25/SUM[5]
XFE_RC_31_1 OAI12HS $PINS O=n4090 A1=FE_RN_21_0 B1=n4087 B2=intadd_15/n1
XFE_OCPC16_FE_OFN478_n1710 INV1S $PINS O=FE_OFN2729_n1710 I=FE_OFN478_n1710
XFE_OCPC15_FE_OFN478_n1710 INV2 $PINS O=FE_OFN686_FE_DBTN16_n1710
+ I=FE_OFN478_n1710
XFE_OCPC14_FE_OFN478_n1710 BUF4CK $PINS O=FE_OFN687_FE_DBTN16_n1710
+ I=FE_OFN478_n1710
XFE_OCPC13_FE_OFN478_n1710 BUF2 $PINS O=FE_OFN691_FE_DBTN16_n1710
+ I=FE_OFN478_n1710
XFE_RC_30_0 MOAI1S $PINS O=intadd_5/B[0] A1=n4264 A2=IyIt[5] B1=n4264
+ B2=IyIt[5]
XFE_RC_29_0 NR2P $PINS O=FE_RN_20_0 I1=n4162 I2=n3614
XFE_RC_28_0 OR3B2 $PINS O=n2906 I1=FE_RN_20_0 B1=n2905 B2=n2904
XFE_OCPC12_intadd_14_SUM_5 BUF1 $PINS O=FE_OCPN5_intadd_14_SUM_5
+ I=intadd_14/SUM[5]
XFE_RC_12_1 AOI12H $PINS O=n3659 A1=n3651 B1=n3653 B2=n3652
XFE_OCPC9_n3611 BUF2 $PINS O=FE_OCPN2_n3611 I=n3611
XFE_OCPC8_n1709 INV2 $PINS O=FE_OCPN1_n1709 I=FE_OFN699_FE_DBTN7_n1709
XFE_OCPC7_n1709 INV2 $PINS O=FE_OCPN0_n1709 I=FE_OFN699_FE_DBTN7_n1709
XFE_OCPC6_n1709 INV2 $PINS O=FE_OFN464_n1709 I=FE_OFN697_FE_DBTN7_n1709
XFE_OCPC5_n1709 INV1S $PINS O=FE_OFN696_FE_DBTN7_n1709
+ I=FE_OFN697_FE_DBTN7_n1709
XFE_OCPC4_n1709 INV2 $PINS O=FE_OFN699_FE_DBTN7_n1709 I=FE_OFN471_n1709
XFE_OCPC3_n1709 INV2 $PINS O=FE_OFN697_FE_DBTN7_n1709 I=FE_OFN471_n1709
XFE_OCPC1_n1709 INV2 $PINS O=FE_OFN471_n1709 I=n1709
XFE_OCPC0_n1709 BUF1 $PINS O=FE_OCPN4373_n1709 I=n1709
XCTS_ccl_a_INV_clk_G0_L5_20 INV12CK $PINS O=CTS_135 I=CTS_136
XCTS_ccl_a_INV_clk_G0_L5_19 INV12CK $PINS O=CTS_134 I=CTS_136
XCTS_ccl_a_INV_clk_G0_L4_8 INV6CK $PINS O=CTS_136 I=CTS_137
XCTS_ccl_a_INV_clk_G0_L5_18 INV12CK $PINS O=CTS_132 I=CTS_133
XCTS_ccl_a_INV_clk_G0_L5_17 INV12CK $PINS O=CTS_131 I=CTS_133
XCTS_ccl_a_INV_clk_G0_L4_7 INV6CK $PINS O=CTS_133 I=CTS_137
XCTS_ccl_a_INV_clk_G0_L5_16 INV12CK $PINS O=CTS_129 I=CTS_130
XCTS_ccl_a_INV_clk_G0_L5_15 INV12CK $PINS O=CTS_128 I=CTS_130
XCTS_ccl_a_INV_clk_G0_L5_14 INV12CK $PINS O=CTS_127 I=CTS_130
XCTS_ccl_a_INV_clk_G0_L4_6 INV8CK $PINS O=CTS_130 I=CTS_137
XCTS_ccl_a_INV_clk_G0_L3_4 INV12CK $PINS O=CTS_137 I=CTS_138
XCTS_ccl_a_INV_clk_G0_L5_13 INV12CK $PINS O=CTS_124 I=CTS_125
XCTS_ccl_a_INV_clk_G0_L5_12 INV12CK $PINS O=CTS_123 I=CTS_125
XCTS_ccl_a_INV_clk_G0_L5_11 INV12CK $PINS O=CTS_122 I=CTS_125
XCTS_ccl_a_INV_clk_G0_L4_5 INV12CK $PINS O=CTS_125 I=CTS_126
XCTS_ccl_a_INV_clk_G0_L5_10 INV12CK $PINS O=CTS_120 I=CTS_121
XCTS_ccl_a_INV_clk_G0_L5_9 INV12CK $PINS O=CTS_119 I=CTS_121
XCTS_ccl_a_INV_clk_G0_L5_8 INV12CK $PINS O=CTS_118 I=CTS_121
XCTS_ccl_a_INV_clk_G0_L4_4 INV12CK $PINS O=CTS_121 I=CTS_126
XCTS_ccl_a_INV_clk_G0_L3_3 INV12CK $PINS O=CTS_126 I=CTS_138
XCTS_ccl_a_INV_clk_G0_L5_7 INV12CK $PINS O=CTS_115 I=CTS_116
XCTS_ccl_a_INV_clk_G0_L5_6 INV12CK $PINS O=CTS_114 I=CTS_116
XCTS_ccl_a_INV_clk_G0_L4_3 INV6CK $PINS O=CTS_116 I=CTS_117
XCTS_ccl_a_INV_clk_G0_L3_2 INV6CK $PINS O=CTS_117 I=CTS_138
XCTS_ccl_a_INV_clk_G0_L5_5 INV12CK $PINS O=CTS_111 I=CTS_112
XCTS_ccl_a_INV_clk_G0_L5_4 INV12CK $PINS O=CTS_110 I=CTS_112
XCTS_ccl_a_INV_clk_G0_L5_3 INV12CK $PINS O=CTS_109 I=CTS_112
XCTS_ccl_a_INV_clk_G0_L4_2 INV12CK $PINS O=CTS_112 I=CTS_113
XCTS_ccl_a_INV_clk_G0_L5_2 INV12CK $PINS O=CTS_107 I=CTS_108
XCTS_ccl_a_INV_clk_G0_L5_1 INV12CK $PINS O=CTS_106 I=CTS_108
XCTS_ccl_a_INV_clk_G0_L4_1 INV8CK $PINS O=CTS_108 I=CTS_113
XCTS_ccl_a_INV_clk_G0_L3_1 INV12CK $PINS O=CTS_113 I=CTS_138
XCTS_ccl_a_INV_clk_G0_L2_1 INV12CK $PINS O=CTS_138 I=clk
XFE_OCPC2942_intadd_14_SUM_0 BUF6 $PINS O=FE_OCPN2942_intadd_14_SUM_0
+ I=intadd_14/SUM[0]
XFE_OCPC2940_n2278 BUF1S $PINS O=FE_OCPN2940_n2278 I=n2278
XFE_RC_109_0 MOAI1 $PINS O=n4097 A1=n4096 A2=n4095 B1=n4096 B2=n4095
XFE_RC_78_0 ND2 $PINS O=FE_RN_37_0 I1=n2842 I2=FE_OFN1665_IyIt_17
XFE_RC_77_0 OAI12H $PINS O=n1694 A1=FE_RN_37_0 B1=intadd_34/n1 B2=IyIt[18]
XFE_RC_76_0 ND2 $PINS O=FE_RN_36_0 I1=n4308 I2=intadd_23/SUM[5]
XFE_RC_75_0 OAI12HS $PINS O=n4312 A1=FE_RN_36_0 B1=n4309 B2=intadd_2/n1
XFE_RC_74_0 MOAI1 $PINS O=n4205 A1=n3065 A2=n3064 B1=n3063 B2=intadd_13/n1
XFE_RC_71_0 XNR2HS $PINS O=n4113 I1=img1[0][0] I2=a_reg[0]
XFE_RC_70_0 INV1S $PINS O=FE_RN_22_0 I=intadd_10/B[3]
XFE_RC_69_0 INV1S $PINS O=FE_RN_23_0 I=intadd_10/n5
XFE_RC_68_0 ND2S $PINS O=FE_RN_24_0 I1=FE_RN_31_0 I2=intadd_9/SUM[2]
XFE_RC_67_0 OAI12HS $PINS O=intadd_10/n4 A1=FE_RN_24_0 B1=FE_RN_23_0
+ B2=FE_RN_22_0
XFE_RC_64_0 OAI22S $PINS O=FE_RN_27_0 A1=FE_RN_22_0 A2=intadd_10/n5
+ B1=FE_RN_23_0 B2=intadd_10/B[3]
XFE_RC_63_0 OR2B1S $PINS O=FE_RN_28_0 I1=intadd_9/SUM[2] B1=FE_RN_27_0
XFE_RC_60_0 ND2S $PINS O=FE_RN_31_0 I1=FE_RN_23_0 I2=FE_RN_22_0
XFE_RC_59_0 ND2 $PINS O=FE_RN_32_0 I1=intadd_10/n5 I2=intadd_10/B[3]
XFE_RC_58_0 ND2S $PINS O=FE_RN_33_0 I1=FE_RN_32_0 I2=FE_RN_31_0
XFE_RC_57_0 ND2 $PINS O=FE_RN_34_0 I1=FE_RN_33_0 I2=intadd_9/SUM[2]
XFE_RC_56_0 ND2S $PINS O=intadd_10/SUM[3] I1=FE_RN_34_0 I2=FE_RN_28_0
XFE_RC_41_0 INV2 $PINS O=Iy2_shift[0] I=FE_RN_11_0
XFE_RC_40_0 AOI12HS $PINS O=FE_RN_11_0 A1=n3604 B1=n3605
+ B2=FE_OFN602_shift_amount_reg_3
XFE_RC_39_0 XOR3 $PINS O=intadd_34/SUM[2] I1=intadd_34/B[2] I2=n1302
+ I3=intadd_34/n2
XFE_RC_38_0 MAO222P $PINS O=intadd_34/n1 A1=intadd_34/B[2] B1=n1302
+ C1=intadd_34/n2
XFE_RC_34_0 INV1S $PINS O=FE_RN_8_0 I=FE_OFN581_IxIy_18
XFE_RC_33_0 INV1CK $PINS O=FE_RN_9_0 I=intadd_35/n1
XFE_RC_32_0 ND2P $PINS O=FE_RN_10_0 I1=FE_RN_9_0 I2=FE_RN_8_0
XFE_RC_31_0 ND2P $PINS O=n2281 I1=FE_RN_7_0 I2=FE_RN_10_0
XFE_RC_23_0 ND2P $PINS O=FE_RN_7_0 I1=n2837 I2=IxIy[17]
XFE_RC_20_0 INV1S $PINS O=FE_RN_3_0 I=intadd_8/n1
XFE_RC_19_0 INV2CK $PINS O=FE_RN_4_0 I=n4225
XFE_RC_18_0 ND2 $PINS O=FE_RN_5_0 I1=FE_RN_4_0 I2=FE_RN_3_0
XFE_RC_17_0 ND2P $PINS O=FE_RN_6_0 I1=n4224 I2=intadd_24/SUM[5]
XFE_RC_16_0 ND2P $PINS O=n4228 I1=FE_RN_6_0 I2=FE_RN_5_0
XFE_RC_12_0 ND3P $PINS O=Iy2_shift[10] I1=n3328 I2=n3329 I3=n3327
XFE_RC_10_0 AOI22H $PINS O=n2754 A1=FE_OFN349_FE_DBTN24_n2351
+ A2=FE_OFN546_Ix2_4 B1=n2751 B2=FE_OFN786_n2278
XFE_RC_9_0 INV1S $PINS O=FE_RN_2_0 I=n4234
XFE_RC_8_0 MXL2HS $PINS OB=n3331 S=n3330 A=n4234 B=FE_RN_2_0
XFE_RC_7_0 ND2 $PINS O=FE_RN_0_0 I1=n3128 I2=n3129
XFE_RC_6_0 INV2 $PINS O=n1650 I=FE_RN_1_0
XFE_RC_5_0 AN2B1S $PINS O=FE_RN_1_0 I1=n3127 B1=FE_RN_0_0
XFE_RC_4_0 ND3P $PINS O=Ix2_shift[2] I1=n3156 I2=n3155 I3=n3154
XFE_OFC2934_Iy2_shift_9 BUF1 $PINS O=FE_OFN4369_n I=FE_OFN1306_Iy2_shift_9
XFE_OFC2744_FE_DBTN16_n1710 BUF2CK $PINS O=FE_OFN2744_FE_DBTN16_n1710
+ I=FE_OFN2732_FE_DBTN16_n1710
XFE_OFC2930_n3751 BUF1 $PINS O=FE_OFN4365_n I=FE_OFN510_n3751
XFE_OFC2742_FE_DBTN17_n1715 BUF1CK $PINS O=FE_OFN2742_FE_DBTN17_n1715
+ I=FE_OFN2727_FE_DBTN17_n1715
XFE_OFC2924_FE_DBTN7_n1709 INV2 $PINS O=FE_OFN4359_n I=FE_OFN4357_n
XFE_OFC2923_FE_DBTN7_n1709 INV3 $PINS O=FE_OFN4358_n I=FE_OFN4357_n
XFE_OFC2922_FE_DBTN7_n1709 INV3 $PINS O=FE_OFN4357_n
+ I=FE_OFN2740_FE_DBTN7_n1709
XFE_OFC2921_IxIy_shift_3 INV3 $PINS O=FE_OFN4356_IxIy_shift_3
+ I=FE_OFN4354_IxIy_shift_3
XFE_OFC2919_IxIy_shift_3 INV2 $PINS O=FE_OFN4354_IxIy_shift_3 I=IxIy_shift[3]
XFE_OFC2916_Ix2_shift_8 BUF1 $PINS O=FE_OFN4351_Ix2_shift_8 I=Ix2_shift[8]
XFE_OFC2914_Iy2_shift_8 BUF1 $PINS O=FE_OFN4349_n I=FE_OFN1310_Iy2_shift_8
XFE_OFC2740_FE_DBTN7_n1709 BUF1 $PINS O=FE_OFN2740_FE_DBTN7_n1709
+ I=FE_OFN700_FE_DBTN7_n1709
XFE_OFC2912_FE_DBTN2_n2466 BUF1 $PINS O=FE_OFN4347_n
+ I=FE_OFN1040_FE_DBTN2_n2466
XFE_OFC2910_FE_DBTN2_n2466 BUF3 $PINS O=FE_OFN4345_n
+ I=FE_OFN1039_FE_DBTN2_n2466
XFE_OFC2909_FE_DBTN2_n2466 BUF1 $PINS O=FE_OFN4344_n
+ I=FE_OFN1041_FE_DBTN2_n2466
XFE_OFC2738_FE_DBTN7_n1709 BUF1CK $PINS O=FE_OFN2738_FE_DBTN7_n1709
+ I=FE_OCPN4373_n1709
XFE_OFC2737_FE_DBTN16_n1710 BUF1CK $PINS O=FE_OFN2737_FE_DBTN16_n1710
+ I=FE_OFN689_FE_DBTN16_n1710
XFE_OFC2736_n1709 BUF1CK $PINS O=FE_OFN2736_n1709 I=FE_OFN467_n1709
XFE_OFC2734_FE_DBTN7_n1709 BUF2 $PINS O=FE_OFN2734_FE_DBTN7_n1709
+ I=FE_OFN464_n1709
XFE_OFC2889_FE_DBTN2_n2466 BUF1 $PINS O=FE_OFN4324_n
+ I=FE_OFN1038_FE_DBTN2_n2466
XFE_OFC2885_n BUF1 $PINS O=FE_OFN4320_n I=FE_OFN4114_n
XFE_OFC2733_n3751 BUF2 $PINS O=FE_OFN2733_n3751 I=FE_OFN510_n3751
XFE_OFC2884_FE_DBTN2_n2466 BUF1 $PINS O=FE_OFN4319_FE_DBTN2_n2466
+ I=FE_DBTN2_n2466
XFE_OFC2732_FE_DBTN16_n1710 BUF2CK $PINS O=FE_OFN2732_FE_DBTN16_n1710
+ I=FE_OFN686_FE_DBTN16_n1710
XFE_OFC2882_FE_DBTN7_n1709 BUF1 $PINS O=FE_OFN4317_n I=FE_OFN696_FE_DBTN7_n1709
XFE_OFC2878_n1710 BUF1 $PINS O=FE_OFN4313_n I=FE_OFN481_n1710
XFE_OFC2875_n1715 BUF1 $PINS O=FE_OFN4310_n I=FE_OFN760_n1715
XFE_OFC2873_FE_DBTN2_n2466 BUF1 $PINS O=FE_OFN4308_n
+ I=FE_OFN1043_FE_DBTN2_n2466
XFE_OFC2731_n3867 BUF1CK $PINS O=FE_OFN2731_n3867 I=n3867
XFE_OFC2730_FE_DBTN8_n1705 BUF3CK $PINS O=FE_OFN2730_FE_DBTN8_n1705
+ I=FE_OFN909_FE_DBTN8_n1705
XFE_OFC2842_IxIt_18 BUF1 $PINS O=FE_OFN4277_IxIt_18 I=IxIt[18]
XFE_OFC2841_n3869 BUF1CK $PINS O=FE_OFN4276_n3869 I=n3869
XFE_OFC2839_It_4__7 BUF1 $PINS O=FE_OFN4274_It_4__7 I=It[4][7]
XFE_OFC2728_FE_DBTN16_n1710 BUF1CK $PINS O=FE_OFN2728_FE_DBTN16_n1710
+ I=FE_OFN693_FE_DBTN16_n1710
XFE_OFC2727_FE_DBTN17_n1715 BUF1 $PINS O=FE_OFN2727_FE_DBTN17_n1715
+ I=FE_OFN895_FE_DBTN17_n1715
XFE_OFC2833_n4234 BUF1 $PINS O=FE_OFN4268_n4234 I=n4234
XFE_OFC2831_FE_OFN1030_FE_DBTN41_n4489 BUF1 $PINS
+ O=FE_OFN4266_FE_OFN1030_FE_DBTN41_n4489 I=FE_OFN1030_FE_DBTN41_n4489
XFE_OFC2827_n1709 BUF1 $PINS O=FE_OFN4262_n1709 I=n1709
XFE_OFC2818_FE_DBTN8_n1705 BUF1 $PINS O=FE_OFN4253_FE_DBTN8_n1705
+ I=FE_DBTN8_n1705
XFE_OFC2813_FE_OFN758_n1715 BUF2 $PINS O=FE_OFN4248_FE_OFN758_n1715
+ I=FE_OFN758_n1715
XFE_OFC2811_FE_OFN1554_n3259 BUF1 $PINS O=FE_OFN4246_FE_OFN1554_n3259
+ I=FE_OFN4245_FE_OFN1554_n3259
XFE_OFC2810_FE_OFN1554_n3259 BUF4CK $PINS O=FE_OFN4245_FE_OFN1554_n3259
+ I=FE_OFN1554_n3259
XFE_OFC2809_n2466 INV2 $PINS O=FE_OFN4244_n2466 I=FE_OFN4241_n2466
XFE_OFC2808_n2466 INV1S $PINS O=FE_OFN4243_n2466 I=FE_OFN4241_n2466
XFE_OFC2807_n2466 INV2 $PINS O=FE_OFN4242_n2466 I=FE_OFN4241_n2466
XFE_OFC2806_n2466 INV2CK $PINS O=FE_OFN4241_n2466 I=n2466
XFE_OFC2805_intadd_21_SUM_3 BUF1 $PINS O=FE_OFN4240_intadd_21_SUM_3
+ I=intadd_21/SUM[3]
XFE_OFC2804_intadd_21_SUM_3 BUF1 $PINS O=FE_OFN4239_intadd_21_SUM_3
+ I=intadd_21/SUM[3]
XFE_OFC2799_FE_OFN899_FE_DBTN17_n1715 INV1S $PINS
+ O=FE_OFN4234_FE_OFN899_FE_DBTN17_n1715 I=FE_OFN4232_FE_OFN899_FE_DBTN17_n1715
XFE_OFC2798_FE_OFN899_FE_DBTN17_n1715 BUF1 $PINS
+ O=FE_OFN4233_FE_OFN899_FE_DBTN17_n1715 I=FE_OFN899_FE_DBTN17_n1715
XFE_OFC2797_FE_OFN899_FE_DBTN17_n1715 INV1S $PINS
+ O=FE_OFN4232_FE_OFN899_FE_DBTN17_n1715 I=FE_OFN899_FE_DBTN17_n1715
XFE_OFC2781_FE_OFN508_n3751 BUF1 $PINS O=FE_OFN4216_FE_OFN508_n3751
+ I=FE_OFN508_n3751
XFE_OFC2780_FE_OFN508_n3751 BUF1 $PINS O=FE_OFN4215_FE_OFN508_n3751
+ I=FE_OFN508_n3751
XFE_OFC2779_FE_OFN778_n2278 BUF1 $PINS O=FE_OFN4214_FE_OFN778_n2278
+ I=FE_OFN778_n2278
XFE_OFC2778_FE_OFN778_n2278 BUF4CK $PINS O=FE_OFN4213_FE_OFN778_n2278
+ I=FE_OFN778_n2278
XFE_OFC2774_FE_OFN928_n2902 INV3 $PINS O=FE_OFN4209_FE_OFN928_n2902
+ I=FE_OFN4207_FE_OFN928_n2902
XFE_OFC2772_FE_OFN928_n2902 INV2 $PINS O=FE_OFN4207_FE_OFN928_n2902
+ I=FE_OFN4205_FE_OFN928_n2902
XFE_OFC2770_FE_OFN928_n2902 BUF2 $PINS O=FE_OFN4205_FE_OFN928_n2902
+ I=FE_OFN928_n2902
XFE_OFC2763_FE_OFN479_n1710 BUF1 $PINS O=FE_OFN4198_FE_OFN479_n1710
+ I=FE_OFN4197_FE_OFN479_n1710
XFE_OFC2762_FE_OFN479_n1710 BUF1 $PINS O=FE_OFN4197_FE_OFN479_n1710
+ I=FE_OFN479_n1710
XFE_OFC2761_FE_OFN910_FE_DBTN8_n1705 BUF1 $PINS
+ O=FE_OFN4196_FE_OFN910_FE_DBTN8_n1705 I=FE_OFN4195_FE_OFN910_FE_DBTN8_n1705
XFE_OFC2760_FE_OFN910_FE_DBTN8_n1705 INV2 $PINS
+ O=FE_OFN4195_FE_OFN910_FE_DBTN8_n1705 I=FE_OFN4194_FE_OFN910_FE_DBTN8_n1705
XFE_OFC2759_FE_OFN910_FE_DBTN8_n1705 INV1S $PINS
+ O=FE_OFN4194_FE_OFN910_FE_DBTN8_n1705 I=FE_OFN910_FE_DBTN8_n1705
XFE_OFC2755_FE_OFN1124_IxIy_shift_7 INV1S $PINS
+ O=FE_OFN4190_FE_OFN1124_IxIy_shift_7 I=FE_OFN4189_FE_OFN1124_IxIy_shift_7
XFE_OFC2754_FE_OFN1124_IxIy_shift_7 INV1S $PINS
+ O=FE_OFN4189_FE_OFN1124_IxIy_shift_7 I=FE_OFN1124_IxIy_shift_7
XFE_OFC2753_FE_OFN906_FE_DBTN8_n1705 INV2 $PINS
+ O=FE_OFN4188_FE_OFN906_FE_DBTN8_n1705 I=FE_OFN4185_FE_OFN906_FE_DBTN8_n1705
XFE_OFC2752_FE_OFN906_FE_DBTN8_n1705 INV1S $PINS
+ O=FE_OFN4187_FE_OFN906_FE_DBTN8_n1705 I=FE_OFN4185_FE_OFN906_FE_DBTN8_n1705
XFE_OFC2751_FE_OFN906_FE_DBTN8_n1705 INV2 $PINS
+ O=FE_OFN4186_FE_OFN906_FE_DBTN8_n1705 I=FE_OFN4185_FE_OFN906_FE_DBTN8_n1705
XFE_OFC2750_FE_OFN906_FE_DBTN8_n1705 INV2 $PINS
+ O=FE_OFN4185_FE_OFN906_FE_DBTN8_n1705 I=FE_OFN906_FE_DBTN8_n1705
XFE_OFC2747_FE_OFN1323_IxIy_shift_10 INV2 $PINS
+ O=FE_OFN4182_FE_OFN1323_IxIy_shift_10 I=FE_OFN4181_FE_OFN1323_IxIy_shift_10
XFE_OFC2746_FE_OFN1323_IxIy_shift_10 INV2 $PINS
+ O=FE_OFN4181_FE_OFN1323_IxIy_shift_10 I=FE_OFN1323_IxIy_shift_10
XFE_OFC2743_FE_OFN1263_Ix2_shift_9 BUF1 $PINS
+ O=FE_OFN4178_FE_OFN1263_Ix2_shift_9 I=FE_OFN1263_Ix2_shift_9
XFE_OFC2740_FE_OFN1263_Ix2_shift_9 BUF1 $PINS
+ O=FE_OFN4175_FE_OFN1263_Ix2_shift_9 I=FE_OFN1263_Ix2_shift_9
XFE_OFC2731_FE_OFN1078_Ix2_shift_15 BUF1 $PINS
+ O=FE_OFN4165_FE_OFN1078_Ix2_shift_15 I=FE_OFN4164_FE_OFN1078_Ix2_shift_15
XFE_OFC2729_FE_OFN1078_Ix2_shift_15 BUF1 $PINS
+ O=FE_OFN4164_FE_OFN1078_Ix2_shift_15 I=FE_OFN1078_Ix2_shift_15
XFE_OFC2723_intadd_14_SUM_5 BUF3CK $PINS O=FE_OFN4158_intadd_14_SUM_5
+ I=FE_OFN397_intadd_14_SUM_5
XFE_OFC2722_intadd_14_SUM_5 BUF3 $PINS O=FE_OFN397_intadd_14_SUM_5
+ I=FE_OFN396_intadd_14_SUM_5
XFE_OFC2720_intadd_14_SUM_5 BUF3 $PINS O=FE_OFN396_intadd_14_SUM_5
+ I=intadd_14/SUM[5]
XFE_OFC2719_intadd_21_SUM_1 BUF2 $PINS O=FE_OFN441_intadd_21_SUM_1
+ I=FE_OFN442_intadd_21_SUM_1
XFE_OFC2718_intadd_21_SUM_1 BUF1 $PINS O=FE_OFN442_intadd_21_SUM_1
+ I=intadd_21/SUM[1]
XFE_OFC2717_Iy2_shift_2 INV2 $PINS O=FE_OFN1318_Iy2_shift_2
+ I=FE_OFN1320_Iy2_shift_2
XFE_OFC2716_Iy2_shift_2 INV3CK $PINS O=FE_OFN1320_Iy2_shift_2 I=Iy2_shift[2]
XFE_OFC2715_a_reg_0 BUF1 $PINS O=FE_OFN4157_a_reg_0 I=FE_OFN530_a_reg_0
XFE_OFC2714_a_reg_0 INV2 $PINS O=FE_OFN530_a_reg_0 I=a_reg[0]
XFE_OFC2708_n4486 INV2 $PINS O=FE_DBTN42_n4486 I=n4486
XFE_OFC2707_intadd_14_SUM_4 BUF1 $PINS O=FE_OFN1692_intadd_14_SUM_4
+ I=FE_OFN399_intadd_14_SUM_4
XFE_OFC2706_intadd_14_SUM_4 INV2 $PINS O=FE_OFN399_intadd_14_SUM_4
+ I=FE_OFN1689_intadd_14_SUM_4
XFE_OFC2705_intadd_14_SUM_4 INV2 $PINS O=FE_OFN1689_intadd_14_SUM_4
+ I=intadd_14/SUM[4]
XFE_OFC2704_intadd_14_SUM_1 BUF1 $PINS O=FE_OFN415_intadd_14_SUM_1
+ I=FE_OFN413_intadd_14_SUM_1
XFE_OFC2703_intadd_14_SUM_1 BUF1 $PINS O=FE_OFN4139_intadd_14_SUM_1
+ I=FE_OFN416_intadd_14_SUM_1
XFE_OFC2702_intadd_14_SUM_1 INV2 $PINS O=FE_OFN413_intadd_14_SUM_1
+ I=FE_OFN416_intadd_14_SUM_1
XFE_OFC2701_intadd_14_SUM_1 INV2 $PINS O=FE_OFN416_intadd_14_SUM_1
+ I=intadd_14/SUM[1]
XFE_OFC2700_n4337 INV1S $PINS O=FE_OFN4153_n4337 I=FE_OFN519_n4337
XFE_OFC2696_n4337 INV1S $PINS O=FE_OFN520_n4337 I=FE_OFN519_n4337
XFE_OFC2695_n4337 INV2 $PINS O=FE_OFN519_n4337 I=n4337
XFE_OFC2694_intadd_14_SUM_0 BUF1 $PINS O=FE_OFN419_intadd_14_SUM_0
+ I=FE_OFN418_intadd_14_SUM_0
XFE_OFC2693_intadd_14_SUM_0 BUF1 $PINS O=FE_OFN417_intadd_14_SUM_0
+ I=FE_OFN420_intadd_14_SUM_0
XFE_OFC2692_intadd_14_SUM_0 BUF1 $PINS O=FE_OFN418_intadd_14_SUM_0
+ I=FE_OCPN2942_intadd_14_SUM_0
XFE_OFC2691_intadd_14_SUM_0 BUF2 $PINS O=FE_OFN420_intadd_14_SUM_0
+ I=FE_OCPN2942_intadd_14_SUM_0
XFE_OFC2690_Ix2_shift_1 INV2 $PINS O=FE_OFN830_Ix2_shift_1
+ I=FE_OFN828_Ix2_shift_1
XFE_OFC2689_Ix2_shift_1 INV3CK $PINS O=FE_OFN828_Ix2_shift_1 I=Ix2_shift[1]
XFE_OFC2688_n1710 BUF1 $PINS O=FE_DBTN16_n1710 I=FE_OFN475_n1710
XFE_OFC2684_n4113 BUF1 $PINS O=FE_OFN1750_n4113 I=FE_OFN951_n4268
XFE_OFC2683_n4113 BUF1 $PINS O=FE_OFN1747_n4113 I=FE_OFN949_n4268
XFE_OFC2682_n4113 INV2 $PINS O=FE_OFN951_n4268 I=FE_OFN948_n4268
XFE_OFC2681_n4113 INV1S $PINS O=FE_OFN949_n4268 I=FE_OFN948_n4268
XFE_OFC2680_n4113 INV2 $PINS O=FE_OFN950_n4268 I=FE_OFN948_n4268
XFE_OFC2679_n4113 INV2 $PINS O=FE_OFN948_n4268 I=FE_OFN812_n4113
XFE_OFC2678_n4113 INV1S $PINS O=FE_OFN1751_n4113 I=FE_OFN812_n4113
XFE_OFC2676_n1709 BUF1 $PINS O=FE_OFN4149_n I=FE_OCPN1_n1709
XFE_OFC2675_n1709 BUF1CK $PINS O=FE_OFN468_n1709 I=FE_OCPN0_n1709
XFE_OFC2664_n1705 BUF1 $PINS O=FE_OFN908_FE_DBTN8_n1705 I=FE_OFN751_n1705
XFE_OFC2663_n1705 BUF1 $PINS O=FE_DBTN8_n1705 I=FE_OFN905_FE_DBTN8_n1705
XFE_OFC2662_n1705 BUF2 $PINS O=FE_OFN911_FE_DBTN8_n1705
+ I=FE_OFN905_FE_DBTN8_n1705
XFE_OFC2661_n1705 INV1S $PINS O=FE_OFN751_n1705 I=FE_OFN905_FE_DBTN8_n1705
XFE_OFC2660_n1705 INV3 $PINS O=FE_OFN905_FE_DBTN8_n1705 I=FE_OFN756_n1705
XFE_OFC2659_n1705 INV2 $PINS O=FE_OFN756_n1705 I=n1705
XFE_OFC2653_n2278 INV2 $PINS O=FE_OFN4143_n2278 I=FE_OFN786_n2278
XFE_OFC2651_n2278 INV1S $PINS O=FE_OFN4141_n2278 I=FE_OFN785_n2278
XFE_OFC2650_n2278 INV2 $PINS O=FE_OFN786_n2278 I=FE_OFN785_n2278
XFE_OFC2645_n2278 BUF1 $PINS O=FE_OFN778_n2278 I=n2278
XFE_OFC2644_n2278 INV1S $PINS O=FE_OFN785_n2278 I=n2278
XFE_OFC2643_Iy2_shift_10 INV1S $PINS O=FE_OFN1299_Iy2_shift_10
+ I=FE_OFN1301_Iy2_shift_10
XFE_OFC2641_Iy2_shift_10 INV1S $PINS O=FE_OFN1301_Iy2_shift_10 I=Iy2_shift[10]
XFE_OFC2639_intadd_14_SUM_1 BUF1 $PINS O=FE_OFN1636_intadd_14_SUM_1 I=n4109
XFE_OFC2636_intadd_14_SUM_1 INV1S $PINS O=n4109 I=FE_OFN416_intadd_14_SUM_1
XFE_OFC2635_intadd_14_SUM_1 INV1S $PINS O=FE_OFN414_intadd_14_SUM_1
+ I=FE_OFN416_intadd_14_SUM_1
XFE_OFC2631_n4336 BUF2 $PINS O=FE_OFN4138_n4336 I=FE_OFN4136_n4336
XFE_OFC2630_n4336 BUF1 $PINS O=FE_OFN4137_n4336 I=FE_OFN4133_n4336
XFE_OFC2629_n4336 INV3 $PINS O=FE_OFN4136_n4336 I=FE_OFN4133_n4336
XFE_OFC2627_n4336 INV1S $PINS O=FE_OFN4134_n4336 I=FE_OFN821_n4336
XFE_OFC2626_n4336 INV3 $PINS O=FE_OFN4133_n4336 I=FE_OFN821_n4336
XFE_OFC2616_IxIt_shift_1 INV2 $PINS O=FE_OFN862_IxIt_shift_1
+ I=FE_OFN859_IxIt_shift_1
XFE_OFC2612_IxIt_shift_1 INV2 $PINS O=FE_OFN859_IxIt_shift_1 I=IxIt_shift[1]
XFE_OFC2608_Iy2_shift_0 BUF1 $PINS O=FE_OFN843_Iy2_shift_0 I=Iy2_shift[0]
XFE_OFC2605_IyIt_shift_11 INV1S $PINS O=FE_OFN4126_IyIt_shift_11
+ I=FE_OFN1371_IyIt_shift_11
XFE_OFC2604_IyIt_shift_11 INV2 $PINS O=FE_OFN1371_IyIt_shift_11
+ I=IyIt_shift[11]
XFE_OFC2603_Iy2_shift_9 BUF1 $PINS O=FE_OFN1552_Iy2_shift_9 I=FE_OFN4369_n
XFE_OFC2596_n3869 INV1S $PINS O=FE_OFN1618_n3869 I=FE_OFN802_n3869
XFE_OFC2595_n3869 INV2 $PINS O=FE_OFN802_n3869 I=n3869
XFE_OFC2593_Ix2_shift_3 BUF2 $PINS O=FE_OFN1608_Ix2_shift_3
+ I=FE_DBTN25_Ix2_shift_3
XFE_OFC2592_Ix2_shift_3 BUF1 $PINS O=FE_OFN1288_Ix2_shift_3
+ I=FE_OFN1502_FE_DBTN25_Ix2_shift_3
XFE_OFC2591_Ix2_shift_3 INV2 $PINS O=FE_DBTN25_Ix2_shift_3 I=Ix2_shift[3]
XFE_OFC2589_Ix2_shift_3 INV1S $PINS O=FE_OFN1502_FE_DBTN25_Ix2_shift_3
+ I=Ix2_shift[3]
XFE_OFC2586_IyIt_shift_8 INV1S $PINS O=FE_OFN1378_IyIt_shift_8
+ I=FE_OFN1568_IyIt_shift_8
XFE_OFC2585_IyIt_shift_8 INV2 $PINS O=FE_OFN1568_IyIt_shift_8 I=IyIt_shift[8]
XFE_OFC2582_intadd_14_SUM_2 BUF1 $PINS O=FE_OFN4121_intadd_14_SUM_2
+ I=FE_OFN412_intadd_14_SUM_2
XFE_OFC2581_intadd_14_SUM_2 INV1S $PINS O=FE_OFN4120_intadd_14_SUM_2
+ I=FE_OFN412_intadd_14_SUM_2
XFE_OFC2580_intadd_14_SUM_2 INV2 $PINS O=FE_OFN412_intadd_14_SUM_2
+ I=FE_OFN411_intadd_14_SUM_2
XFE_OFC2579_intadd_14_SUM_2 INV1S $PINS O=n4134 I=FE_OFN411_intadd_14_SUM_2
XFE_OFC2578_intadd_14_SUM_2 INV1S $PINS O=FE_OFN410_intadd_14_SUM_2
+ I=FE_OFN411_intadd_14_SUM_2
XFE_OFC2577_intadd_14_SUM_2 INV1S $PINS O=FE_OFN409_intadd_14_SUM_2
+ I=FE_OFN411_intadd_14_SUM_2
XFE_OFC2576_intadd_14_SUM_2 BUF1 $PINS O=FE_OFN407_intadd_14_SUM_2
+ I=FE_OFN408_intadd_14_SUM_2
XFE_OFC2575_intadd_14_SUM_2 INV2 $PINS O=FE_OFN411_intadd_14_SUM_2
+ I=intadd_14/SUM[2]
XFE_OFC2574_intadd_14_SUM_2 BUF1 $PINS O=FE_OFN408_intadd_14_SUM_2
+ I=intadd_14/SUM[2]
XFE_OFC2573_shift_amount_reg_0 INV2 $PINS O=n2350 I=shift_amount_reg[0]
XFE_OFC2572_IxIy_8 BUF1 $PINS O=FE_OFN584_IxIy_8 I=IxIy[8]
XFE_OFC2571_shift_amount_reg_1 INV2 $PINS O=FE_DBTN40_shift_amount_reg_1
+ I=shift_amount_reg[1]
XFE_OFC2570_n4483 BUF1 $PINS O=FE_OFN352_FE_DBTN23_n4483
+ I=FE_OFN1639_FE_DBTN23_n4483
XFE_OFC2569_n4483 INV1S $PINS O=FE_DBTN23_n4483 I=n4483
XFE_OFC2568_n4483 INV1S $PINS O=FE_OFN1639_FE_DBTN23_n4483 I=n4483
XFE_OFC2567_n1710 INV1S $PINS O=FE_OFN4119_n I=FE_OFN691_FE_DBTN16_n1710
XFE_OFC2566_n1710 INV2 $PINS O=FE_OFN693_FE_DBTN16_n1710
+ I=FE_OFN691_FE_DBTN16_n1710
XFE_OFC2565_n1710 BUF1 $PINS O=FE_OFN692_FE_DBTN16_n1710
+ I=FE_OFN688_FE_DBTN16_n1710
XFE_OFC2562_n1710 BUF1CK $PINS O=FE_OFN689_FE_DBTN16_n1710
+ I=FE_OFN687_FE_DBTN16_n1710
XFE_OFC2561_n1710 INV2 $PINS O=FE_OFN688_FE_DBTN16_n1710 I=FE_OFN478_n1710
XFE_OFC2558_n1710 BUF1 $PINS O=FE_OFN481_n1710 I=FE_OFN479_n1710
XFE_OFC2556_n1710 INV1S $PINS O=FE_OFN479_n1710 I=FE_OFN473_n1710
XFE_OFC2555_n1710 INV4 $PINS O=FE_OFN478_n1710 I=FE_OFN473_n1710
XFE_OFC2553_n1710 INV1S $PINS O=FE_OFN475_n1710 I=FE_OFN473_n1710
XFE_OFC2548_Iy2_shift_1 BUF2 $PINS O=FE_OFN837_Iy2_shift_1 I=Iy2_shift[1]
XFE_OFC2544_n1705 BUF1 $PINS O=FE_OFN4114_n
+ I=FE_OFN4186_FE_OFN906_FE_DBTN8_n1705
XFE_OFC2541_n1705 INV2 $PINS O=FE_OFN906_FE_DBTN8_n1705
+ I=FE_OFN911_FE_DBTN8_n1705
XFE_OFC2539_n1705 INV2 $PINS O=FE_OFN907_FE_DBTN8_n1705
+ I=FE_OFN911_FE_DBTN8_n1705
XFE_OFC2535_n3867 INV1S $PINS O=FE_OFN513_n3867 I=FE_OFN1628_n3867
XFE_OFC2534_n3867 INV2 $PINS O=FE_OFN1628_n3867 I=n3867
XFE_OFC2524_n1709 BUF1 $PINS O=FE_OFN470_n1709 I=FE_OFN466_n1709
XFE_OFC2523_n1709 INV1S $PINS O=FE_DBTN7_n1709 I=FE_OFN465_n1709
XFE_OFC2522_n1709 INV2 $PINS O=FE_OFN469_n1709 I=FE_OFN465_n1709
XFE_OFC2520_n1709 INV1S $PINS O=FE_OFN466_n1709 I=FE_OCPN1_n1709
XFE_OFC2519_n1709 INV1S $PINS O=FE_OFN465_n1709 I=FE_OFN2738_FE_DBTN7_n1709
XFE_OFC2516_n1709 BUF1 $PINS O=FE_OFN467_n1709 I=FE_OCPN4373_n1709
XFE_OFC2513_n1715 BUF1 $PINS O=FE_OFN897_FE_DBTN17_n1715 I=FE_OFN758_n1715
XFE_OFC2511_n1715 BUF1 $PINS O=FE_OFN894_FE_DBTN17_n1715 I=FE_OFN763_n1715
XFE_OFC2510_n1715 INV2 $PINS O=FE_OFN895_FE_DBTN17_n1715 I=FE_OFN763_n1715
XFE_OFC2509_n1715 INV1S $PINS O=FE_OFN764_n1715 I=FE_OFN759_n1715
XFE_OFC2508_n1715 INV1S $PINS O=FE_DBTN17_n1715 I=FE_OFN759_n1715
XFE_OFC2507_n1715 BUF1 $PINS O=FE_OFN761_n1715 I=FE_OFN759_n1715
XFE_OFC2506_n1715 BUF1 $PINS O=FE_OFN758_n1715 I=FE_OFN759_n1715
XFE_OFC2505_n1715 BUF1 $PINS O=FE_OFN899_FE_DBTN17_n1715 I=FE_OFN759_n1715
XFE_OFC2504_n1715 INV2 $PINS O=FE_OFN763_n1715 I=FE_OFN759_n1715
XFE_OFC2502_IxIy_shift_5 BUF1 $PINS O=FE_OFN1764_IxIy_shift_5 I=IxIy_shift[5]
XFE_OFC2501_IxIy_shift_4 BUF1 $PINS O=FE_OFN1763_IxIy_shift_4 I=IxIy_shift[4]
XFE_OFC2500_Iy2_15 INV1S $PINS O=FE_OFN1762_Iy2_15 I=n2911
XFE_OFC2499_Iy2_15 INV1S $PINS O=n2911 I=Iy2[15]
XFE_OFC2489_Ix_0__8 INV1S $PINS O=FE_OFN1760_Ix_0__8 I=FE_DBTN54_Ix_0_8
XFE_OFC2488_Ix_0__8 INV1S $PINS O=FE_DBTN54_Ix_0_8 I=Ix[0][8]
XFE_OFC2482_IyIt_shift_7 INV1S $PINS O=FE_DBTN14_IyIt_shift_7
+ I=FE_OFN1140_IyIt_shift_7
XFE_OFC2481_IyIt_shift_7 INV2 $PINS O=FE_OFN1140_IyIt_shift_7
+ I=FE_OFN1139_IyIt_shift_7
XFE_OFC2475_IyIt_shift_7 INV1S $PINS O=FE_OFN1139_IyIt_shift_7 I=IyIt_shift[7]
XFE_OFC2470_n4113 BUF1 $PINS O=FE_OFN1749_n4113 I=FE_OFN950_n4268
XFE_OFC2462_n4113 INV1S $PINS O=FE_OFN814_n4113 I=FE_OFN812_n4113
XFE_OFC2461_n4113 INV1S $PINS O=FE_OFN813_n4113 I=FE_OFN812_n4113
XFE_OFC2460_n4113 INV3 $PINS O=FE_OFN812_n4113 I=n4113
XFE_OFC2459_FE_DBTN13_n4339 BUF1 $PINS O=FE_OFN1746_FE_DBTN13_n4339
+ I=FE_OFN361_FE_DBTN13_n4339
XFE_OFC2458_FE_DBTN13_n4339 BUF1 $PINS O=FE_OFN360_FE_DBTN13_n4339
+ I=FE_DBTN13_n4339
XFE_OFC2457_FE_DBTN13_n4339 BUF1 $PINS O=FE_OFN359_FE_DBTN13_n4339
+ I=FE_DBTN13_n4339
XFE_OFC2456_FE_DBTN13_n4339 BUF1 $PINS O=FE_OFN361_FE_DBTN13_n4339
+ I=FE_DBTN13_n4339
XFE_OFC2440_IxIt_shift_15 BUF1 $PINS O=FE_OFN981_IxIt_shift_15 I=IxIt_shift[15]
XFE_OFC2431_IxIt_shift_6 BUF1 $PINS O=FE_OFN1736_IxIt_shift_6 I=IxIt_shift[6]
XFE_OFC2430_Iy2_22 INV1S $PINS O=FE_OFN1735_Iy2_22 I=FE_OFN561_Iy2_22
XFE_OFC2425_Iy2_22 INV1S $PINS O=FE_OFN561_Iy2_22 I=Iy2[22]
XFE_OFC2415_IxIt_shift_11 INV1S $PINS O=FE_OFN1726_IxIt_shift_11
+ I=FE_OFN1352_IxIt_shift_11
XFE_OFC2411_IxIt_shift_11 INV1S $PINS O=FE_OFN1352_IxIt_shift_11
+ I=IxIt_shift[11]
XFE_OFC2409_Ix2_15 INV1S $PINS O=n2707 I=Ix2[15]
XFE_OFC2402_IxIt_shift_12 INV1S $PINS O=FE_OFN1349_IxIt_shift_12
+ I=IxIt_shift[12]
XFE_OFC2388_IyIt_shift_3 INV1S $PINS O=FE_OFN1385_IyIt_shift_3 I=IyIt_shift[3]
XFE_OFC2377_Iy2_shift_14 BUF1 $PINS O=FE_OFN1181_FE_DBTN27_Iy2_shift_14
+ I=FE_DBTN27_Iy2_shift_14
XFE_OFC2373_Iy2_shift_14 INV1S $PINS O=FE_DBTN27_Iy2_shift_14 I=Iy2_shift[14]
XFE_OFC2372_IxIt_2 INV1S $PINS O=FE_OFN1712_IxIt_2 I=IxIt[2]
XFE_OFC2357_IxIt_shift_13 BUF1 $PINS O=FE_OFN986_IxIt_shift_13 I=IxIt_shift[13]
XFE_OFC2356_n3177 INV1S $PINS O=FE_OFN1708_n3177 I=n3322
XFE_OFC2355_n3177 INV1S $PINS O=n3322 I=n3177
XFE_OFC2354_IxIy_2 INV1S $PINS O=FE_OFN1707_IxIy_2 I=n4162
XFE_OFC2353_IxIy_2 INV1S $PINS O=n4162 I=IxIy[2]
XFE_OFC2350_intadd_14_SUM_5 BUF1 $PINS O=FE_OFN394_intadd_14_SUM_5
+ I=FE_OCPN5_intadd_14_SUM_5
XFE_OFC2349_intadd_14_SUM_5 BUF1 $PINS O=FE_OFN398_intadd_14_SUM_5
+ I=FE_OCPN5_intadd_14_SUM_5
XFE_OFC2346_Ix2_shift_4 INV2 $PINS O=FE_DBTN31_Ix2_shift_4
+ I=FE_OFN1284_Ix2_shift_4
XFE_OFC2344_Ix2_shift_4 INV1S $PINS O=FE_OFN1493_FE_DBTN31_Ix2_shift_4
+ I=FE_OFN1284_Ix2_shift_4
XFE_OFC2342_Ix2_shift_4 BUF2 $PINS O=FE_OFN1284_Ix2_shift_4 I=Ix2_shift[4]
XFE_OFC2340_Iy2_18 INV1S $PINS O=n2888 I=Iy2[18]
XFE_OFC2318_IyIt_shift_1 INV3 $PINS O=FE_OFN872_IyIt_shift_1
+ I=FE_OFN871_IyIt_shift_1
XFE_OFC2313_IyIt_shift_1 INV2 $PINS O=FE_OFN871_IyIt_shift_1 I=IyIt_shift[1]
XFE_OFC2312_intadd_14_SUM_6 BUF1 $PINS O=n4297 I=FE_OFN392_intadd_14_SUM_6
XFE_OFC2311_intadd_14_SUM_6 BUF1 $PINS O=FE_OFN391_intadd_14_SUM_6
+ I=FE_OFN390_intadd_14_SUM_6
XFE_OFC2310_intadd_14_SUM_6 BUF2 $PINS O=FE_OFN392_intadd_14_SUM_6
+ I=intadd_14/SUM[6]
XFE_OFC2309_intadd_14_SUM_6 BUF2 $PINS O=FE_OFN390_intadd_14_SUM_6
+ I=intadd_14/SUM[6]
XFE_OFC2308_intadd_14_SUM_6 INV1S $PINS O=FE_OFN393_intadd_14_SUM_6
+ I=intadd_14/SUM[6]
XFE_OFC2307_Ix2_18 INV1S $PINS O=n2651 I=Ix2[18]
XFE_OFC2306_n2902 INV2 $PINS O=n3614 I=FE_OFN4209_FE_OFN928_n2902
XFE_OFC2304_n2902 BUF2 $PINS O=FE_OFN928_n2902 I=n2902
XFE_OFC2289_FE_DBTN24_n2351 BUF4CK $PINS O=FE_OFN349_FE_DBTN24_n2351
+ I=FE_OFN350_FE_DBTN24_n2351
XFE_OFC2288_FE_DBTN24_n2351 BUF3CK $PINS O=FE_OFN350_FE_DBTN24_n2351
+ I=FE_DBTN24_n2351
XFE_OFC2287_FE_DBTN24_n2351 BUF1 $PINS O=FE_OFN351_FE_DBTN24_n2351
+ I=FE_DBTN24_n2351
XFE_OFC2285_intadd_14_SUM_4 BUF1 $PINS O=FE_OFN1691_intadd_14_SUM_4
+ I=FE_OFN399_intadd_14_SUM_4
XFE_OFC2284_intadd_14_SUM_4 BUF1 $PINS O=FE_OFN1690_intadd_14_SUM_4
+ I=FE_OFN677_FE_DBTN46_intadd_14_SUM_4
XFE_OFC2282_intadd_14_SUM_4 BUF1 $PINS O=FE_OFN677_FE_DBTN46_intadd_14_SUM_4
+ I=FE_OFN1689_intadd_14_SUM_4
XFE_OFC2280_intadd_14_SUM_4 INV1S $PINS O=FE_OFN401_intadd_14_SUM_4
+ I=FE_OFN1689_intadd_14_SUM_4
XFE_OFC2279_intadd_14_SUM_4 INV1S $PINS O=FE_DBTN46_intadd_14_SUM_4
+ I=FE_OFN1689_intadd_14_SUM_4
XFE_OFC2278_intadd_14_SUM_4 INV2 $PINS O=FE_OFN400_intadd_14_SUM_4
+ I=FE_OFN1689_intadd_14_SUM_4
XFE_OFC2263_Ix2_shift_12 BUF1 $PINS O=FE_OFN1505_FE_DBTN20_Ix2_shift_12
+ I=FE_OFN1258_Ix2_shift_12
XFE_OFC2261_Ix2_shift_12 BUF1 $PINS O=FE_OFN1258_Ix2_shift_12
+ I=FE_OFN1503_FE_DBTN20_Ix2_shift_12
XFE_OFC2259_Ix2_shift_12 INV2 $PINS O=FE_OFN1503_FE_DBTN20_Ix2_shift_12
+ I=Ix2_shift[12]
XFE_OFC2233_Ix2_shift_2 INV1S $PINS O=FE_OFN1291_Ix2_shift_2 I=Ix2_shift[2]
XFE_OFC2230_Ix2_shift_14 BUF1 $PINS O=FE_OFN1184_FE_DBTN26_Ix2_shift_14
+ I=FE_DBTN26_Ix2_shift_14
XFE_OFC2228_Ix2_shift_14 INV1S $PINS O=FE_DBTN26_Ix2_shift_14
+ I=FE_OFN1086_Ix2_shift_14
XFE_OFC2225_Ix2_shift_14 BUF1 $PINS O=FE_OFN1086_Ix2_shift_14 I=Ix2_shift[14]
XFE_OFC2216_It_0__8 BUF1 $PINS O=FE_DBTN70_It_0_8 I=FE_OFN317_FE_DBTN70_It_0_8
XFE_OFC2215_It_0__8 INV1S $PINS O=FE_OFN317_FE_DBTN70_It_0_8 I=It[0][8]
XFE_OFC2211_IxIt_5 INV1S $PINS O=FE_OFN1669_IxIt_5 I=n4011
XFE_OFC2210_IxIt_5 INV1S $PINS O=n4011 I=IxIt[5]
XFE_OFC2209_Ix2_12 BUF1 $PINS O=FE_OFN538_Ix2_12 I=Ix2[12]
XFE_OFC2208_Ix2_10 BUF1 $PINS O=FE_OFN540_Ix2_10 I=Ix2[10]
XFE_OFC2201_Ix2_shift_5 BUF1 $PINS O=FE_OFN1282_Ix2_shift_5 I=Ix2_shift[5]
XFE_OFC2195_IyIt_3 BUF1 $PINS O=FE_OFN601_IyIt_3 I=IyIt[3]
XFE_OFC2194_IxIy_9 BUF1 $PINS O=FE_OFN1668_IxIy_9 I=IxIy[9]
XFE_OFC2188_n4316 BUF1 $PINS O=FE_OFN518_n4316 I=n4316
XFE_OFC2187_IyIt_2 INV1S $PINS O=n4256 I=IyIt[2]
XFE_OFC2185_IyIt_17 INV1S $PINS O=FE_OFN1665_IyIt_17 I=FE_OFN594_IyIt_17
XFE_OFC2182_IyIt_17 INV1S $PINS O=n1302 I=FE_OFN594_IyIt_17
XFE_OFC2181_IyIt_17 INV1S $PINS O=FE_OFN594_IyIt_17 I=IyIt[17]
XFE_OFC2180_Ix2_13 BUF1 $PINS O=FE_OFN537_Ix2_13 I=Ix2[13]
XFE_OFC2179_n3611 INV1S $PINS O=FE_OFN1662_n3611 I=FE_OFN1660_n3611
XFE_OFC2178_n3611 BUF2 $PINS O=FE_OFN1661_n3611 I=FE_OFN932_n3611
XFE_OFC2177_n3611 INV1S $PINS O=FE_OFN1660_n3611 I=FE_OFN933_n3611
XFE_OFC2176_n3611 INV1S $PINS O=FE_OFN1659_n3611 I=FE_OFN933_n3611
XFE_OFC2174_n3611 INV1S $PINS O=FE_OFN932_n3611 I=FE_OFN933_n3611
XFE_OFC2173_n3611 INV1S $PINS O=n3600 I=FE_OFN933_n3611
XFE_OFC2172_n3611 INV2 $PINS O=FE_OFN933_n3611 I=FE_OCPN2_n3611
XFE_OFC2166_IxIy_7 BUF1 $PINS O=FE_OFN585_IxIy_7 I=IxIy[7]
XFE_OFC2164_a_reg_1 INV1S $PINS O=FE_OFN1656_a_reg_1 I=intadd_14/B[0]
XFE_OFC2162_a_reg_1 INV3 $PINS O=intadd_14/B[0] I=a_reg[1]
XFE_OFC2161_Iy2_IxIt_0 INV2 $PINS O=n3491 I=Iy2_IxIt[0]
XFE_OFC2151_IxIt_4 BUF1 $PINS O=FE_OFN559_IxIt_4 I=IxIt[4]
XFE_OFC2150_IxIt_4 INV1S $PINS O=n4005 I=IxIt[4]
XFE_OFC2149_IxIy_18 INV1S $PINS O=n2840 I=IxIy[18]
XFE_OFC2148_Iy2_16 INV1S $PINS O=FE_OFN565_Iy2_16 I=Iy2[16]
XFE_OFC2147_Iy2_16 BUF1 $PINS O=n2908 I=Iy2[16]
XFE_OFC2135_IxIy_shift_14 BUF1 $PINS O=FE_OFN971_IxIy_shift_14 I=IxIy_shift[14]
XFE_OFC2132_IxIy_16 INV1S $PINS O=intadd_35/A[1] I=IxIy[16]
XFE_OFC2131_intadd_14_SUM_3 BUF1 $PINS O=FE_OFN1649_intadd_14_SUM_3
+ I=FE_OFN1648_intadd_14_SUM_3
XFE_OFC2130_intadd_14_SUM_3 BUF1 $PINS O=FE_OFN1648_intadd_14_SUM_3
+ I=FE_OFN405_intadd_14_SUM_3
XFE_OFC2129_intadd_14_SUM_3 BUF1 $PINS O=FE_OFN406_intadd_14_SUM_3
+ I=FE_OFN405_intadd_14_SUM_3
XFE_OFC2128_intadd_14_SUM_3 BUF1 $PINS O=FE_OFN405_intadd_14_SUM_3
+ I=FE_OFN404_intadd_14_SUM_3
XFE_OFC2127_intadd_14_SUM_3 INV1S $PINS O=n4120 I=FE_OFN404_intadd_14_SUM_3
XFE_OFC2126_intadd_14_SUM_3 BUF1 $PINS O=FE_OFN404_intadd_14_SUM_3
+ I=intadd_14/SUM[3]
XFE_OFC2125_intadd_14_SUM_3 BUF1 $PINS O=FE_OFN403_intadd_14_SUM_3
+ I=intadd_14/SUM[3]
XFE_OFC2115_IxIy_shift_3 INV2 $PINS O=FE_OFN1346_IxIy_shift_3
+ I=FE_OFN1345_IxIy_shift_3
XFE_OFC2113_IxIy_shift_3 INV2 $PINS O=FE_OFN1345_IxIy_shift_3
+ I=FE_OFN4356_IxIy_shift_3
XFE_OFC2108_IxIy_15 INV1S $PINS O=intadd_35/A[0] I=IxIy[15]
XFE_OFC2106_IyIt_15 INV1S $PINS O=intadd_34/A[0] I=IyIt[15]
XFE_OFC2105_n3751 BUF4CK $PINS O=FE_OFN512_n3751 I=FE_OFN2733_n3751
XFE_OFC2103_n3751 BUF6CK $PINS O=FE_OFN510_n3751 I=FE_OFN508_n3751
XFE_OFC2101_n3751 BUF4CK $PINS O=FE_OFN508_n3751 I=n3751
XFE_OFC2099_IyIt_16 INV1S $PINS O=intadd_34/A[1] I=IyIt[16]
XFE_OFC2094_It_4__8 INV1S $PINS O=FE_DBTN62_It_4_8 I=It[4][8]
XFE_OFC2091_Iy2_shift_15 BUF1 $PINS O=FE_OFN1088_Iy2_shift_15
+ I=FE_OFN1194_FE_DBTN12_Iy2_shift_15
XFE_OFC2087_Iy2_shift_15 INV1S $PINS O=FE_OFN1194_FE_DBTN12_Iy2_shift_15
+ I=Iy2_shift[15]
XFE_OFC2085_IxIy_5 INV1S $PINS O=FE_OFN587_IxIy_5 I=IxIy[5]
XFE_OFC2084_IxIy_5 BUF1 $PINS O=n4180 I=IxIy[5]
XFE_OFC2083_a_reg_4 INV1S $PINS O=FE_OFN1641_a_reg_4 I=intadd_14/B[3]
XFE_OFC2081_a_reg_4 INV2 $PINS O=intadd_14/B[3] I=a_reg[4]
XFE_OFC2080_IxIt_20 BUF1 $PINS O=FE_OFN550_IxIt_20 I=IxIt[20]
XFE_OFC2079_Ix2_16 INV1S $PINS O=n2703 I=Ix2[16]
XFE_OFC2078_Ix2_16 BUF1 $PINS O=FE_OFN535_Ix2_16 I=Ix2[16]
XFE_OFC2076_FE_DBTN23_n4483 INV1S $PINS O=FE_OFN354_FE_DBTN23_n4483 I=n4483
XFE_OFC2072_intadd_21_SUM_3 BUF1 $PINS O=FE_OFN439_intadd_21_SUM_3
+ I=FE_OFN440_intadd_21_SUM_3
XFE_OFC2071_intadd_21_SUM_3 BUF1 $PINS O=FE_OFN440_intadd_21_SUM_3
+ I=FE_OFN437_intadd_21_SUM_3
XFE_OFC2070_intadd_21_SUM_3 BUF1 $PINS O=FE_OFN437_intadd_21_SUM_3
+ I=FE_OFN4240_intadd_21_SUM_3
XFE_OFC2068_IxIt_21 BUF1 $PINS O=FE_OFN549_IxIt_21 I=IxIt[21]
XFE_OFC2061_Ix2_22 BUF1 $PINS O=n1356 I=Ix2[22]
XFE_OFC2060_Ix2_22 INV1S $PINS O=FE_OFN532_Ix2_22 I=Ix2[22]
XFE_OFC2059_IyIt_22 INV1S $PINS O=FE_OFN590_IyIt_22 I=IyIt[22]
XFE_OFC2058_IyIt_22 BUF1 $PINS O=n1404 I=IyIt[22]
XFE_OFC2042_Ix2_9 BUF1 $PINS O=FE_OFN541_Ix2_9 I=Ix2[9]
XFE_OFC2041_a_reg_3 INV1S $PINS O=FE_OFN1632_a_reg_3 I=intadd_14/B[2]
XFE_OFC2039_a_reg_3 INV2 $PINS O=intadd_14/B[2] I=a_reg[3]
XFE_OFC2038_IyIt_4 BUF1 $PINS O=FE_OFN600_IyIt_4 I=IyIt[4]
XFE_OFC2034_intadd_21_SUM_5 INV1S $PINS O=FE_OFN432_intadd_21_SUM_5
+ I=FE_OFN431_intadd_21_SUM_5
XFE_OFC2033_intadd_21_SUM_5 INV1S $PINS O=FE_OFN431_intadd_21_SUM_5
+ I=FE_OFN429_intadd_21_SUM_5
XFE_OFC2032_intadd_21_SUM_5 BUF1 $PINS O=FE_OFN430_intadd_21_SUM_5 I=n3964
XFE_OFC2031_intadd_21_SUM_5 BUF1 $PINS O=FE_OFN429_intadd_21_SUM_5
+ I=intadd_21/SUM[5]
XFE_OFC2030_intadd_21_SUM_5 BUF1 $PINS O=n3964 I=intadd_21/SUM[5]
XFE_OFC2018_IxIy_17 INV1S $PINS O=FE_OFN1629_IxIy_17 I=FE_OFN582_IxIy_17
XFE_OFC2016_IxIy_17 INV1S $PINS O=FE_OFN582_IxIy_17 I=IxIy[17]
XFE_OFC2012_n3867 BUF1 $PINS O=n3864 I=n3867
XFE_OFC2011_Ix2_19 BUF1 $PINS O=FE_OFN534_Ix2_19 I=Ix2[19]
XFE_OFC2003_Ix2_shift_10 BUF1 $PINS O=FE_OFN1259_Ix2_shift_10 I=Ix2_shift[10]
XFE_OFC2002_IyIt_21 BUF1 $PINS O=FE_OFN591_IyIt_21 I=IyIt[21]
XFE_OFC2001_IyIt_18 INV1S $PINS O=n2845 I=IyIt[18]
XFE_OFC2000_IyIt_18 BUF1 $PINS O=FE_OFN593_IyIt_18 I=IyIt[18]
XFE_OFC1995_IxIy_shift_0 BUF1 $PINS O=FE_OFN857_IxIy_shift_0
+ I=FE_OFN858_IxIy_shift_0
XFE_OFC1994_IxIy_shift_0 INV2 $PINS O=FE_OFN856_IxIy_shift_0
+ I=FE_OFN854_IxIy_shift_0
XFE_OFC1993_IxIy_shift_0 INV1S $PINS O=FE_OFN858_IxIy_shift_0
+ I=FE_OFN854_IxIy_shift_0
XFE_OFC1985_IxIy_shift_0 INV2 $PINS O=FE_OFN854_IxIy_shift_0 I=IxIy_shift[0]
XFE_OFC1975_IxIy_shift_12 INV1S $PINS O=FE_OFN974_IxIy_shift_12
+ I=FE_OFN978_IxIy_shift_12
XFE_OFC1967_IxIy_shift_12 INV1S $PINS O=FE_OFN978_IxIy_shift_12
+ I=IxIy_shift[12]
XFE_OFC1956_n1438 INV3 $PINS O=FE_DBTN38_n1438 I=n1438
XFE_OFC1955_IxIy_19 INV1S $PINS O=FE_OFN514_n4234 I=FE_OFN4268_n4234
XFE_OFC1954_IxIy_19 INV1S $PINS O=n4234 I=IxIy[19]
XFE_OFC1953_intadd_14_n1 BUF1 $PINS O=FE_OFN747_n1439 I=FE_OFN421_intadd_14_n1
XFE_OFC1952_intadd_14_n1 BUF1 $PINS O=n1439 I=FE_OFN422_intadd_14_n1
XFE_OFC1951_intadd_14_n1 INV2 $PINS O=FE_OFN421_intadd_14_n1
+ I=FE_OFN422_intadd_14_n1
XFE_OFC1950_intadd_14_n1 INV1S $PINS O=FE_OFN423_intadd_14_n1
+ I=FE_OFN422_intadd_14_n1
XFE_OFC1949_intadd_14_n1 INV2 $PINS O=FE_OFN422_intadd_14_n1 I=intadd_14/n1
XFE_OFC1924_a_reg_2 INV1S $PINS O=FE_OFN1604_a_reg_2 I=intadd_14/B[1]
XFE_OFC1922_a_reg_2 INV3 $PINS O=intadd_14/B[1] I=a_reg[2]
XFE_OFC1917_Ix2_3 BUF1 $PINS O=FE_OFN547_Ix2_3 I=Ix2[3]
XFE_OFC1913_Iy2_4 BUF1 $PINS O=FE_OFN576_Iy2_4 I=Iy2[4]
XFE_OFC1912_Ix2_14 INV1S $PINS O=n2708 I=Ix2[14]
XFE_OFC1911_Ix2_14 BUF1 $PINS O=FE_OFN536_Ix2_14 I=Ix2[14]
XFE_OFC1910_IxIt_3 BUF1 $PINS O=FE_OFN560_IxIt_3 I=IxIt[3]
XFE_OFC1909_IyIt_5 INV1S $PINS O=n4265 I=FE_OFN599_IyIt_5
XFE_OFC1908_IyIt_5 INV1S $PINS O=FE_OFN599_IyIt_5 I=IyIt[5]
XFE_OFC1907_IxIt_9 BUF1 $PINS O=FE_OFN555_IxIt_9 I=IxIt[9]
XFE_OFC1900_n1437 INV2 $PINS O=FE_DBTN39_n1437 I=FE_OFN1197_n1437
XFE_OFC1898_n1437 BUF1 $PINS O=FE_OFN1197_n1437 I=n1437
XFE_OFC1888_Ix2_shift_8 INV2 $PINS O=FE_OFN1270_Ix2_shift_8
+ I=FE_OFN1271_Ix2_shift_8
XFE_OFC1880_Ix2_shift_8 INV2 $PINS O=FE_OFN1271_Ix2_shift_8 I=Ix2_shift[8]
XFE_OFC1872_Ix2_shift_15 INV1S $PINS O=FE_OFN1188_FE_DBTN21_Ix2_shift_15
+ I=FE_OFN4164_FE_OFN1078_Ix2_shift_15
XFE_OFC1869_Ix2_shift_15 INV1S $PINS O=FE_OFN1078_Ix2_shift_15
+ I=FE_OFN1079_Ix2_shift_15
XFE_OFC1863_Ix2_shift_15 INV1S $PINS O=FE_OFN1079_Ix2_shift_15
+ I=FE_OFN1077_Ix2_shift_15
XFE_OFC1862_Ix2_shift_15 BUF1 $PINS O=FE_OFN1077_Ix2_shift_15 I=Ix2_shift[15]
XFE_OFC1853_IxIy_shift_13 INV2 $PINS O=FE_OFN1583_IxIy_shift_13
+ I=FE_OFN1099_IxIy_shift_13
XFE_OFC1846_IxIy_shift_13 BUF1 $PINS O=FE_OFN1099_IxIy_shift_13
+ I=IxIy_shift[13]
XFE_OFC1838_n4484 INV3 $PINS O=FE_OFN1239_n4484 I=FE_OFN1238_n4484
XFE_OFC1837_n4484 BUF2 $PINS O=FE_OFN1238_n4484 I=n4484
XFE_OFC1836_IxIt_18 BUF1 $PINS O=FE_OFN553_IxIt_18 I=FE_OFN4277_IxIt_18
XFE_OFC1831_Ix2_shift_13 BUF1 $PINS O=FE_OFN1580_Ix2_shift_13
+ I=FE_OFN958_Ix2_shift_13
XFE_OFC1828_Ix2_shift_13 BUF1 $PINS O=FE_OFN958_Ix2_shift_13 I=Ix2_shift[13]
XFE_OFC1827_Ix2_shift_13 BUF1 $PINS O=FE_OFN959_Ix2_shift_13 I=Ix2_shift[13]
XFE_OFC1820_IxIy_shift_7 BUF1 $PINS O=FE_OFN1578_IxIy_shift_7
+ I=FE_OFN1121_IxIy_shift_7
XFE_OFC1819_IxIy_shift_7 INV2 $PINS O=FE_OFN1124_IxIy_shift_7
+ I=FE_OFN1121_IxIy_shift_7
XFE_OFC1817_IxIy_shift_7 INV2 $PINS O=FE_OFN1121_IxIy_shift_7 I=IxIy_shift[7]
XFE_OFC1813_IxIy_shift_1 INV2CK $PINS O=FE_OFN851_IxIy_shift_1
+ I=FE_OFN846_IxIy_shift_1
XFE_OFC1812_IxIy_shift_1 BUF1 $PINS O=FE_OFN847_IxIy_shift_1
+ I=FE_OFN844_IxIy_shift_1
XFE_OFC1807_IxIy_shift_1 INV1S $PINS O=FE_OFN846_IxIy_shift_1
+ I=FE_OFN849_IxIy_shift_1
XFE_OFC1805_IxIy_shift_1 INV1S $PINS O=FE_OFN844_IxIy_shift_1
+ I=FE_OFN849_IxIy_shift_1
XFE_OFC1803_IxIy_shift_1 INV2 $PINS O=FE_OFN849_IxIy_shift_1 I=IxIy_shift[1]
XFE_OFC1792_Iy2_shift_13 BUF1 $PINS O=FE_OFN963_Iy2_shift_13 I=Iy2_shift[13]
XFE_OFC1790_n1710 BUF1 $PINS O=FE_OFN1574_n1710 I=FE_OFN688_FE_DBTN16_n1710
XFE_OFC1772_n1710 INV2 $PINS O=FE_OFN473_n1710 I=n1710
XFE_OFC1771_n2466 BUF1 $PINS O=FE_OFN1041_FE_DBTN2_n2466
+ I=FE_OFN1038_FE_DBTN2_n2466
XFE_OFC1770_n2466 BUF1 $PINS O=FE_OFN1040_FE_DBTN2_n2466 I=FE_DBTN2_n2466
XFE_OFC1769_n2466 BUF1 $PINS O=FE_OFN1039_FE_DBTN2_n2466 I=FE_OFN4308_n
XFE_OFC1768_n2466 INV2 $PINS O=FE_OFN1038_FE_DBTN2_n2466 I=FE_OFN4244_n2466
XFE_OFC1767_n2466 INV1S $PINS O=FE_DBTN2_n2466 I=FE_OFN4243_n2466
XFE_OFC1766_n2466 INV2 $PINS O=FE_OFN1043_FE_DBTN2_n2466 I=FE_OFN4242_n2466
XFE_OFC1755_Iy2_shift_11 INV1S $PINS O=FE_OFN1294_Iy2_shift_11
+ I=FE_OFN1292_Iy2_shift_11
XFE_OFC1754_Iy2_shift_11 INV2 $PINS O=FE_OFN1292_Iy2_shift_11 I=Iy2_shift[11]
XFE_OFC1744_n2620 BUF1 $PINS O=FE_OFN1572_n2620 I=FE_OFN1570_n2620
XFE_OFC1741_n2620 INV2 $PINS O=FE_OFN1570_n2620 I=FE_OFN1057_n2620
XFE_OFC1737_n2620 INV1S $PINS O=FE_OFN1057_n2620 I=n2620
XFE_OFC1722_IxIy_shift_8 BUF1 $PINS O=FE_OFN1109_IxIy_shift_8 I=IxIy_shift[8]
XFE_OFC1708_n1715 INV1S $PINS O=FE_OFN760_n1715 I=FE_OFN758_n1715
XFE_OFC1706_n1715 INV2 $PINS O=FE_OFN757_n1715 I=FE_OFN4248_FE_OFN758_n1715
XFE_OFC1705_n1715 INV3 $PINS O=FE_OFN759_n1715 I=n1715
XFE_OFC1704_a_reg_0 INV1S $PINS O=n3934 I=FE_OFN4157_a_reg_0
XFE_OFC1701_n1709 BUF4CK $PINS O=FE_OFN700_FE_DBTN7_n1709
+ I=FE_OFN2734_FE_DBTN7_n1709
XFE_OFC1698_n1709 INV1S $PINS O=FE_OFN472_n1709 I=FE_OFN697_FE_DBTN7_n1709
XFE_OFC1667_Iy2_shift_8 INV1S $PINS O=FE_OFN1310_Iy2_shift_8
+ I=FE_OFN1313_Iy2_shift_8
XFE_OFC1663_Iy2_shift_8 INV1S $PINS O=FE_OFN1313_Iy2_shift_8 I=Iy2_shift[8]
XFE_OFC1654_IxIy_shift_10 INV2 $PINS O=FE_OFN1323_IxIy_shift_10
+ I=FE_OFN1321_IxIy_shift_10
XFE_OFC1650_IxIy_shift_10 INV1S $PINS O=FE_OFN1321_IxIy_shift_10
+ I=IxIy_shift[10]
XFE_OFC1639_IxIt_shift_8 INV2 $PINS O=FE_OFN1361_IxIt_shift_8
+ I=FE_OFN1360_IxIt_shift_8
XFE_OFC1636_IxIt_shift_8 INV1S $PINS O=FE_OFN1360_IxIt_shift_8 I=IxIt_shift[8]
XFE_OFC1625_n3310 BUF1 $PINS O=FE_OFN1557_n3310 I=FE_OFN1065_n3310
XFE_OFC1622_n3310 BUF2 $PINS O=FE_OFN1065_n3310 I=n3310
XFE_OFC1614_Ix2_shift_9 INV2 $PINS O=FE_OFN1263_Ix2_shift_9
+ I=FE_OFN1262_Ix2_shift_9
XFE_OFC1611_Ix2_shift_9 INV1S $PINS O=FE_OFN1262_Ix2_shift_9 I=Ix2_shift[9]
XFE_OFC1607_n3259 BUF1CK $PINS O=FE_OFN1554_n3259 I=FE_OFN1231_n3259
XFE_OFC1604_n3259 INV1S $PINS O=FE_OFN1231_n3259 I=FE_OFN1228_n3259
XFE_OFC1601_n3259 INV1S $PINS O=FE_OFN1230_n3259 I=FE_OFN1228_n3259
XFE_OFC1600_n3259 INV2 $PINS O=FE_OFN1228_n3259 I=n3259
XFE_OFC1590_Iy2_shift_9 INV1S $PINS O=FE_OFN1306_Iy2_shift_9
+ I=FE_OFN1304_Iy2_shift_9
XFE_OFC1589_Iy2_shift_9 INV1S $PINS O=FE_OFN1304_Iy2_shift_9 I=Iy2_shift[9]
XFE_OFC1577_n2891 INV1S $PINS O=FE_OFN1220_n2891 I=FE_OFN1217_n2891
XFE_OFC1573_n2891 INV2 $PINS O=FE_OFN1217_n2891 I=n2891
XFE_OFC1572_n4489 BUF1 $PINS O=FE_OFN955_n4489 I=FE_OFN954_n4489
XFE_OFC1571_n4489 BUF1 $PINS O=FE_OFN954_n4489 I=FE_DBTN41_n4489
XFE_OFC1570_n4489 BUF1 $PINS O=FE_OFN1027_FE_DBTN41_n4489
+ I=FE_OFN1028_FE_DBTN41_n4489
XFE_OFC1569_n4489 BUF1 $PINS O=FE_OFN953_n4489 I=FE_OFN1028_FE_DBTN41_n4489
XFE_OFC1568_n4489 BUF1 $PINS O=FE_OFN952_n4489 I=FE_OFN1028_FE_DBTN41_n4489
XFE_OFC1567_n4489 INV1S $PINS O=FE_DBTN41_n4489 I=FE_OFN1028_FE_DBTN41_n4489
XFE_OFC1566_n4489 BUF1 $PINS O=FE_OFN1030_FE_DBTN41_n4489 I=n4489
XFE_OFC1565_n4489 INV2 $PINS O=FE_OFN1028_FE_DBTN41_n4489 I=n4489
XFE_OFC1563_n1705 BUF2 $PINS O=FE_OFN909_FE_DBTN8_n1705
+ I=FE_OFN907_FE_DBTN8_n1705
XFE_OFC1555_n1705 BUF1 $PINS O=FE_OFN753_n1705 I=FE_OFN749_n1705
XFE_OFC1552_n1705 INV1S $PINS O=FE_OFN750_n1705 I=FE_OFN756_n1705
XFE_OFC1551_n1705 INV1S $PINS O=FE_OFN749_n1705 I=FE_OFN756_n1705
XFE_OFC1550_n1705 INV1S $PINS O=FE_OFN910_FE_DBTN8_n1705 I=FE_OFN756_n1705
XFE_OFC1507_FE_DBTN10_IxIy_shift_4 BUF2 $PINS
+ O=FE_OFN1509_FE_DBTN10_IxIy_shift_4 I=FE_OFN1507_FE_DBTN10_IxIy_shift_4
XFE_OFC1505_FE_DBTN10_IxIy_shift_4 INV2 $PINS
+ O=FE_OFN1507_FE_DBTN10_IxIy_shift_4 I=FE_OFN1506_FE_DBTN10_IxIy_shift_4
XFE_OFC1504_FE_DBTN10_IxIy_shift_4 INV2 $PINS
+ O=FE_OFN1506_FE_DBTN10_IxIy_shift_4 I=FE_DBTN10_IxIy_shift_4
XFE_OFC1494_FE_DBTN30_IxIy_shift_5 INV2 $PINS
+ O=FE_OFN1496_FE_DBTN30_IxIy_shift_5 I=FE_OFN1494_FE_DBTN30_IxIy_shift_5
XFE_OFC1492_FE_DBTN30_IxIy_shift_5 INV1S $PINS
+ O=FE_OFN1494_FE_DBTN30_IxIy_shift_5 I=FE_DBTN30_IxIy_shift_5
XFE_OFC1370_IyIt_shift_11 BUF1 $PINS O=FE_OFN1372_IyIt_shift_11
+ I=FE_OFN4126_IyIt_shift_11
XFE_OFC1367_IxIt_shift_3 BUF1 $PINS O=FE_OFN1369_IxIt_shift_3 I=IxIt_shift[3]
XFE_OFC1365_IxIt_shift_7 BUF1 $PINS O=FE_OFN1367_IxIt_shift_7 I=IxIt_shift[7]
XFE_OFC1364_IxIt_shift_7 BUF1 $PINS O=FE_OFN1366_IxIt_shift_7 I=IxIt_shift[7]
XFE_OFC1354_IxIt_shift_10 BUF1 $PINS O=FE_OFN1356_IxIt_shift_10
+ I=IxIt_shift[10]
XFE_OFC1337_IxIy_shift_4 BUF1 $PINS O=FE_OFN1339_IxIy_shift_4
+ I=FE_OFN1337_IxIy_shift_4
XFE_OFC1335_IxIy_shift_4 BUF1 $PINS O=FE_OFN1337_IxIy_shift_4
+ I=FE_OFN1763_IxIy_shift_4
XFE_OFC1329_IxIy_shift_5 BUF1 $PINS O=FE_OFN1331_IxIy_shift_5
+ I=FE_OFN1328_IxIy_shift_5
XFE_OFC1326_IxIy_shift_5 BUF1 $PINS O=FE_OFN1328_IxIy_shift_5
+ I=FE_OFN1764_IxIy_shift_5
XFE_OFC1314_Iy2_shift_6 BUF1 $PINS O=FE_OFN1316_Iy2_shift_6 I=Iy2_shift[6]
XFE_OFC1278_Ix2_shift_7 INV1S $PINS O=FE_OFN1280_Ix2_shift_7
+ I=FE_OFN1278_Ix2_shift_7
XFE_OFC1277_Ix2_shift_7 INV1S $PINS O=FE_OFN1279_Ix2_shift_7
+ I=FE_OFN1278_Ix2_shift_7
XFE_OFC1276_Ix2_shift_7 INV1S $PINS O=FE_OFN1278_Ix2_shift_7 I=Ix2_shift[7]
XFE_OFC1252_n4488 BUF1 $PINS O=FE_OFN1254_n4488 I=FE_OFN1253_n4488
XFE_OFC1251_n4488 BUF1 $PINS O=FE_OFN1253_n4488 I=n4488
XFE_OFC1246_n4487 BUF1 $PINS O=FE_OFN1248_n4487 I=n4487
XFE_OFC1134_IyIt_shift_9 BUF1 $PINS O=FE_OFN1136_IyIt_shift_9 I=IyIt_shift[9]
XFE_OFC1132_IyIt_shift_12 BUF1 $PINS O=FE_OFN1134_IyIt_shift_12
+ I=FE_OFN1133_IyIt_shift_12
XFE_OFC1131_IyIt_shift_12 BUF1 $PINS O=FE_OFN1133_IyIt_shift_12
+ I=IyIt_shift[12]
XFE_OFC1127_IyIt_shift_13 BUF1 $PINS O=FE_OFN1129_IyIt_shift_13
+ I=FE_OFN1128_IyIt_shift_13
XFE_OFC1126_IyIt_shift_13 BUF1 $PINS O=FE_OFN1128_IyIt_shift_13
+ I=IyIt_shift[13]
XFE_OFC1124_IyIt_shift_15 BUF1 $PINS O=FE_OFN1126_IyIt_shift_15
+ I=IyIt_shift[15]
XFE_OFC1073_n3930 BUF1 $PINS O=FE_OFN1075_n3930 I=n3930
XFE_OFC1053_FE_DBTN0_n4229 BUF1 $PINS O=FE_OFN1055_FE_DBTN0_n4229
+ I=FE_OFN1054_FE_DBTN0_n4229
XFE_OFC1052_FE_DBTN0_n4229 BUF1 $PINS O=FE_OFN1054_FE_DBTN0_n4229
+ I=FE_OFN1052_FE_DBTN0_n4229
XFE_OFC1051_FE_DBTN0_n4229 BUF1 $PINS O=FE_OFN1053_FE_DBTN0_n4229
+ I=FE_OFN1051_FE_DBTN0_n4229
XFE_OFC1050_FE_DBTN0_n4229 BUF1 $PINS O=FE_OFN1052_FE_DBTN0_n4229
+ I=FE_OFN1050_FE_DBTN0_n4229
XFE_OFC1049_FE_DBTN0_n4229 BUF1 $PINS O=FE_OFN1051_FE_DBTN0_n4229
+ I=FE_OFN1049_FE_DBTN0_n4229
XFE_OFC1048_FE_DBTN0_n4229 BUF1 $PINS O=FE_OFN1050_FE_DBTN0_n4229
+ I=FE_DBTN0_n4229
XFE_OFC1047_FE_DBTN0_n4229 BUF1 $PINS O=FE_OFN1049_FE_DBTN0_n4229
+ I=FE_DBTN0_n4229
XFE_OFC1035_FE_DBTN9_n2102 BUF1 $PINS O=FE_OFN1037_FE_DBTN9_n2102
+ I=FE_DBTN9_n2102
XFE_OFC1034_FE_DBTN9_n2102 BUF1 $PINS O=FE_OFN1036_FE_DBTN9_n2102
+ I=FE_DBTN9_n2102
XFE_OFC1033_FE_DBTN11_n4099 BUF1 $PINS O=FE_OFN1035_FE_DBTN11_n4099
+ I=FE_OFN1033_FE_DBTN11_n4099
XFE_OFC1032_FE_DBTN11_n4099 BUF1 $PINS O=FE_OFN1034_FE_DBTN11_n4099
+ I=FE_OFN1033_FE_DBTN11_n4099
XFE_OFC1031_FE_DBTN11_n4099 INV1S $PINS O=FE_OFN1033_FE_DBTN11_n4099
+ I=FE_OFN1031_FE_DBTN11_n4099
XFE_OFC1030_FE_DBTN11_n4099 INV1S $PINS O=FE_OFN1032_FE_DBTN11_n4099
+ I=FE_OFN1031_FE_DBTN11_n4099
XFE_OFC1029_FE_DBTN11_n4099 INV1S $PINS O=FE_OFN1031_FE_DBTN11_n4099
+ I=FE_DBTN11_n4099
XFE_OFC991_IyIt_shift_14 BUF1 $PINS O=FE_OFN993_IyIt_shift_14 I=IyIt_shift[14]
XFE_OFC982_IxIt_shift_14 BUF1 $PINS O=FE_OFN984_IxIt_shift_14 I=IxIt_shift[14]
XFE_OFC945_n4229 BUF1 $PINS O=FE_OFN947_n4229 I=FE_OFN946_n4229
XFE_OFC944_n4229 BUF1 $PINS O=FE_OFN946_n4229 I=FE_OFN945_n4229
XFE_OFC943_n4229 BUF1 $PINS O=FE_OFN945_n4229 I=FE_OFN943_n4229
XFE_OFC942_n4229 BUF1 $PINS O=FE_OFN944_n4229 I=FE_OFN943_n4229
XFE_OFC941_n4229 BUF1 $PINS O=FE_OFN943_n4229 I=n4229
XFE_OFC940_n4099 INV1S $PINS O=FE_OFN942_n4099 I=FE_OFN940_n4099
XFE_OFC939_n4099 INV1S $PINS O=FE_OFN941_n4099 I=FE_OFN940_n4099
XFE_OFC938_n4099 INV1S $PINS O=FE_OFN940_n4099 I=FE_OFN937_n4099
XFE_OFC937_n4099 INV1S $PINS O=FE_OFN939_n4099 I=FE_OFN936_n4099
XFE_OFC936_n4099 INV1S $PINS O=FE_OFN938_n4099 I=FE_OFN936_n4099
XFE_OFC935_n4099 INV1S $PINS O=FE_OFN937_n4099 I=FE_OFN936_n4099
XFE_OFC934_n4099 INV1S $PINS O=FE_OFN936_n4099 I=n4099
XFE_OFC933_n3926 BUF1 $PINS O=FE_OFN935_n3926 I=FE_OFN934_n3926
XFE_OFC932_n3926 BUF1 $PINS O=FE_OFN934_n3926 I=n3926
XFE_OFC928_n2924 BUF1 $PINS O=FE_OFN930_n2924 I=n2924
XFE_OFC925_n2619 BUF2CK $PINS O=FE_OFN927_n2619 I=n2619
XFE_OFC923_n2102 BUF1 $PINS O=FE_OFN925_n2102 I=n2102
XFE_OFC922_n2102 BUF1 $PINS O=FE_OFN924_n2102 I=n2102
XFE_OFC921_n2084 BUF1 $PINS O=FE_OFN923_n2084 I=n2084
XFE_OFC920_FE_DBTN1_n3943 BUF1 $PINS O=FE_OFN922_FE_DBTN1_n3943
+ I=FE_OFN921_FE_DBTN1_n3943
XFE_OFC919_FE_DBTN1_n3943 BUF1 $PINS O=FE_OFN921_FE_DBTN1_n3943
+ I=FE_OFN920_FE_DBTN1_n3943
XFE_OFC918_FE_DBTN1_n3943 BUF1 $PINS O=FE_OFN920_FE_DBTN1_n3943
+ I=FE_OFN916_FE_DBTN1_n3943
XFE_OFC917_FE_DBTN1_n3943 BUF1 $PINS O=FE_OFN919_FE_DBTN1_n3943
+ I=FE_OFN915_FE_DBTN1_n3943
XFE_OFC916_FE_DBTN1_n3943 INV1S $PINS O=FE_OFN918_FE_DBTN1_n3943
+ I=FE_OFN913_FE_DBTN1_n3943
XFE_OFC915_FE_DBTN1_n3943 INV1S $PINS O=FE_OFN917_FE_DBTN1_n3943
+ I=FE_OFN913_FE_DBTN1_n3943
XFE_OFC914_FE_DBTN1_n3943 INV1S $PINS O=FE_OFN916_FE_DBTN1_n3943
+ I=FE_OFN913_FE_DBTN1_n3943
XFE_OFC913_FE_DBTN1_n3943 BUF1 $PINS O=FE_OFN915_FE_DBTN1_n3943
+ I=FE_DBTN1_n3943
XFE_OFC912_FE_DBTN1_n3943 BUF1 $PINS O=FE_OFN914_FE_DBTN1_n3943
+ I=FE_DBTN1_n3943
XFE_OFC911_FE_DBTN1_n3943 INV1S $PINS O=FE_OFN913_FE_DBTN1_n3943
+ I=FE_DBTN1_n3943
XFE_OFC891_FE_DBTN18_n1690 INV1S $PINS O=FE_OFN893_FE_DBTN18_n1690
+ I=FE_OFN891_FE_DBTN18_n1690
XFE_OFC890_FE_DBTN18_n1690 INV1S $PINS O=FE_OFN892_FE_DBTN18_n1690
+ I=FE_OFN891_FE_DBTN18_n1690
XFE_OFC889_FE_DBTN18_n1690 INV1S $PINS O=FE_OFN891_FE_DBTN18_n1690
+ I=FE_DBTN18_n1690
XFE_OFC888_FE_DBTN34_n2158 INV1S $PINS O=FE_OFN890_FE_DBTN34_n2158
+ I=FE_OFN888_FE_DBTN34_n2158
XFE_OFC887_FE_DBTN34_n2158 INV1S $PINS O=FE_OFN889_FE_DBTN34_n2158
+ I=FE_OFN888_FE_DBTN34_n2158
XFE_OFC886_FE_DBTN34_n2158 INV1S $PINS O=FE_OFN888_FE_DBTN34_n2158
+ I=FE_DBTN34_n2158
XFE_OFC864_IxIt_shift_0 BUF1 $PINS O=FE_OFN866_IxIt_shift_0 I=IxIt_shift[0]
XFE_OFC859_IxIt_shift_1 INV1S $PINS O=FE_OFN861_IxIt_shift_1
+ I=FE_OFN859_IxIt_shift_1
XFE_OFC830_Ix2_shift_0 BUF1 $PINS O=FE_OFN832_Ix2_shift_0 I=Ix2_shift[0]
XFE_OFC829_Ix2_shift_0 BUF1 $PINS O=FE_OFN831_Ix2_shift_0 I=Ix2_shift[0]
XFE_OFC824_n4348 BUF1 $PINS O=FE_OFN826_n4348 I=FE_OFN824_n4348
XFE_OFC823_n4348 BUF1 $PINS O=FE_OFN825_n4348 I=FE_OFN824_n4348
XFE_OFC822_n4348 BUF1 $PINS O=FE_OFN824_n4348 I=n4348
XFE_OFC821_n4336 INV1S $PINS O=FE_OFN823_n4336 I=FE_OFN4136_n4336
XFE_OFC818_n4217 BUF1 $PINS O=FE_OFN820_n4217 I=FE_OFN816_n4217
XFE_OFC817_n4217 INV1S $PINS O=FE_OFN819_n4217 I=FE_OFN815_n4217
XFE_OFC816_n4217 INV1S $PINS O=FE_OFN818_n4217 I=FE_OFN815_n4217
XFE_OFC815_n4217 INV1S $PINS O=FE_OFN817_n4217 I=FE_OFN815_n4217
XFE_OFC814_n4217 BUF1 $PINS O=FE_OFN816_n4217 I=n4217
XFE_OFC813_n4217 INV1S $PINS O=FE_OFN815_n4217 I=n4217
XFE_OFC809_n3993 INV1S $PINS O=FE_OFN811_n3993 I=FE_OFN809_n3993
XFE_OFC808_n3993 INV1S $PINS O=FE_OFN810_n3993 I=FE_OFN809_n3993
XFE_OFC807_n3993 INV1S $PINS O=FE_OFN809_n3993 I=n3993
XFE_OFC806_n3943 BUF1 $PINS O=FE_OFN808_n3943 I=FE_OFN807_n3943
XFE_OFC805_n3943 BUF1 $PINS O=FE_OFN807_n3943 I=FE_OFN806_n3943
XFE_OFC804_n3943 BUF1 $PINS O=FE_OFN806_n3943 I=FE_OFN805_n3943
XFE_OFC803_n3943 BUF1 $PINS O=FE_OFN805_n3943 I=n3943
XFE_OFC802_n3943 BUF1 $PINS O=FE_OFN804_n3943 I=n3943
XFE_OFC801_n3871 BUF1 $PINS O=FE_OFN803_n3871 I=n3871
XFE_OFC799_n2447 BUF1 $PINS O=FE_OFN801_n2447 I=FE_OFN799_n2447
XFE_OFC798_n2447 INV1S $PINS O=FE_OFN800_n2447 I=FE_OFN798_n2447
XFE_OFC797_n2447 INV2 $PINS O=FE_OFN799_n2447 I=FE_OFN798_n2447
XFE_OFC796_n2447 INV2 $PINS O=FE_OFN798_n2447 I=FE_OFN796_n2447
XFE_OFC795_n2447 BUF1 $PINS O=FE_OFN797_n2447 I=FE_OFN794_n2447
XFE_OFC794_n2447 INV2 $PINS O=FE_OFN796_n2447 I=FE_OFN793_n2447
XFE_OFC793_n2447 INV1S $PINS O=FE_OFN795_n2447 I=FE_OFN793_n2447
XFE_OFC792_n2447 BUF1 $PINS O=FE_OFN794_n2447 I=FE_OFN792_n2447
XFE_OFC791_n2447 INV1S $PINS O=FE_OFN793_n2447 I=FE_OFN791_n2447
XFE_OFC790_n2447 BUF1 $PINS O=FE_OFN792_n2447 I=n2447
XFE_OFC789_n2447 BUF1 $PINS O=FE_OFN791_n2447 I=n2447
XFE_OFC788_n2278 BUF1 $PINS O=FE_OFN790_n2278 I=FE_OFN788_n2278
XFE_OFC787_n2278 INV1S $PINS O=FE_OFN789_n2278 I=FE_OFN4143_n2278
XFE_OFC786_n2278 INV2 $PINS O=FE_OFN788_n2278 I=FE_OFN4143_n2278
XFE_OFC785_n2278 BUF1 $PINS O=FE_OFN787_n2278 I=FE_OFN4213_FE_OFN778_n2278
XFE_OFC782_n2278 BUF1 $PINS O=FE_OFN784_n2278 I=FE_OFN781_n2278
XFE_OFC779_n2278 INV1S $PINS O=FE_OFN781_n2278 I=FE_OFN777_n2278
XFE_OFC778_n2278 INV1S $PINS O=FE_OFN780_n2278 I=FE_OFN777_n2278
XFE_OFC775_n2278 INV1S $PINS O=FE_OFN777_n2278 I=FE_OFN775_n2278
XFE_OFC773_n2278 BUF1 $PINS O=FE_OFN775_n2278 I=n2278
XFE_OFC772_n2090 BUF1 $PINS O=FE_OFN774_n2090 I=FE_OFN773_n2090
XFE_OFC771_n2090 BUF1 $PINS O=FE_OFN773_n2090 I=FE_OFN772_n2090
XFE_OFC770_n2090 BUF1 $PINS O=FE_OFN772_n2090 I=FE_OFN770_n2090
XFE_OFC769_n2090 BUF1 $PINS O=FE_OFN771_n2090 I=FE_OFN769_n2090
XFE_OFC768_n2090 BUF1 $PINS O=FE_OFN770_n2090 I=FE_OFN768_n2090
XFE_OFC767_n2090 BUF1 $PINS O=FE_OFN769_n2090 I=FE_OFN765_n2090
XFE_OFC766_n2090 BUF1 $PINS O=FE_OFN768_n2090 I=n2090
XFE_OFC765_n2090 BUF1 $PINS O=FE_OFN767_n2090 I=n2090
XFE_OFC764_n2090 BUF1 $PINS O=FE_OFN766_n2090 I=n2090
XFE_OFC763_n2090 BUF1 $PINS O=FE_OFN765_n2090 I=n2090
XFE_OFC746_n1495 BUF1 $PINS O=FE_OFN748_n1495 I=n1495
XFE_OFC744_FE_DBTN3_div_pos_reg_4 BUF1 $PINS O=FE_OFN746_FE_DBTN3_div_pos_reg_4
+ I=FE_DBTN3_div_pos_reg_4
XFE_OFC743_FE_DBTN4_n1819 BUF1 $PINS O=FE_OFN745_FE_DBTN4_n1819
+ I=FE_DBTN4_n1819
XFE_OFC742_FE_DBTN4_n1819 BUF1 $PINS O=FE_OFN744_FE_DBTN4_n1819
+ I=FE_DBTN4_n1819
XFE_OFC741_FE_DBTN5_div_pos_reg_1 BUF1 $PINS O=FE_OFN743_FE_DBTN5_div_pos_reg_1
+ I=FE_OFN742_FE_DBTN5_div_pos_reg_1
XFE_OFC740_FE_DBTN5_div_pos_reg_1 BUF1 $PINS O=FE_OFN742_FE_DBTN5_div_pos_reg_1
+ I=FE_OFN741_FE_DBTN5_div_pos_reg_1
XFE_OFC739_FE_DBTN5_div_pos_reg_1 BUF1 $PINS O=FE_OFN741_FE_DBTN5_div_pos_reg_1
+ I=FE_OFN739_FE_DBTN5_div_pos_reg_1
XFE_OFC738_FE_DBTN5_div_pos_reg_1 INV1S $PINS
+ O=FE_OFN740_FE_DBTN5_div_pos_reg_1 I=FE_OFN738_FE_DBTN5_div_pos_reg_1
XFE_OFC737_FE_DBTN5_div_pos_reg_1 INV1S $PINS
+ O=FE_OFN739_FE_DBTN5_div_pos_reg_1 I=FE_OFN738_FE_DBTN5_div_pos_reg_1
XFE_OFC736_FE_DBTN5_div_pos_reg_1 INV1S $PINS
+ O=FE_OFN738_FE_DBTN5_div_pos_reg_1 I=FE_OFN735_FE_DBTN5_div_pos_reg_1
XFE_OFC733_FE_DBTN5_div_pos_reg_1 BUF1 $PINS O=FE_OFN735_FE_DBTN5_div_pos_reg_1
+ I=FE_OFN734_FE_DBTN5_div_pos_reg_1
XFE_OFC732_FE_DBTN5_div_pos_reg_1 BUF1 $PINS O=FE_OFN734_FE_DBTN5_div_pos_reg_1
+ I=FE_OFN733_FE_DBTN5_div_pos_reg_1
XFE_OFC731_FE_DBTN5_div_pos_reg_1 BUF1 $PINS O=FE_OFN733_FE_DBTN5_div_pos_reg_1
+ I=FE_OFN730_FE_DBTN5_div_pos_reg_1
XFE_OFC729_FE_DBTN5_div_pos_reg_1 BUF1 $PINS O=FE_OFN731_FE_DBTN5_div_pos_reg_1
+ I=FE_OFN728_FE_DBTN5_div_pos_reg_1
XFE_OFC728_FE_DBTN5_div_pos_reg_1 INV1S $PINS
+ O=FE_OFN730_FE_DBTN5_div_pos_reg_1 I=FE_OFN727_FE_DBTN5_div_pos_reg_1
XFE_OFC727_FE_DBTN5_div_pos_reg_1 INV1S $PINS
+ O=FE_OFN729_FE_DBTN5_div_pos_reg_1 I=FE_OFN727_FE_DBTN5_div_pos_reg_1
XFE_OFC726_FE_DBTN5_div_pos_reg_1 BUF1 $PINS O=FE_OFN728_FE_DBTN5_div_pos_reg_1
+ I=FE_OFN725_FE_DBTN5_div_pos_reg_1
XFE_OFC725_FE_DBTN5_div_pos_reg_1 INV1S $PINS
+ O=FE_OFN727_FE_DBTN5_div_pos_reg_1 I=FE_OFN724_FE_DBTN5_div_pos_reg_1
XFE_OFC723_FE_DBTN5_div_pos_reg_1 BUF1 $PINS O=FE_OFN725_FE_DBTN5_div_pos_reg_1
+ I=FE_DBTN5_div_pos_reg_1
XFE_OFC722_FE_DBTN5_div_pos_reg_1 BUF1 $PINS O=FE_OFN724_FE_DBTN5_div_pos_reg_1
+ I=FE_DBTN5_div_pos_reg_1
XFE_OFC721_FE_DBTN6_div_pos_reg_0 BUF1 $PINS O=FE_OFN723_FE_DBTN6_div_pos_reg_0
+ I=FE_OFN722_FE_DBTN6_div_pos_reg_0
XFE_OFC720_FE_DBTN6_div_pos_reg_0 BUF1 $PINS O=FE_OFN722_FE_DBTN6_div_pos_reg_0
+ I=FE_OFN721_FE_DBTN6_div_pos_reg_0
XFE_OFC719_FE_DBTN6_div_pos_reg_0 BUF1 $PINS O=FE_OFN721_FE_DBTN6_div_pos_reg_0
+ I=FE_OFN720_FE_DBTN6_div_pos_reg_0
XFE_OFC718_FE_DBTN6_div_pos_reg_0 BUF1 $PINS O=FE_OFN720_FE_DBTN6_div_pos_reg_0
+ I=FE_OFN718_FE_DBTN6_div_pos_reg_0
XFE_OFC717_FE_DBTN6_div_pos_reg_0 BUF1 $PINS O=FE_OFN719_FE_DBTN6_div_pos_reg_0
+ I=FE_OFN718_FE_DBTN6_div_pos_reg_0
XFE_OFC716_FE_DBTN6_div_pos_reg_0 BUF1 $PINS O=FE_OFN718_FE_DBTN6_div_pos_reg_0
+ I=FE_OFN715_FE_DBTN6_div_pos_reg_0
XFE_OFC713_FE_DBTN6_div_pos_reg_0 BUF1 $PINS O=FE_OFN715_FE_DBTN6_div_pos_reg_0
+ I=FE_OFN713_FE_DBTN6_div_pos_reg_0
XFE_OFC712_FE_DBTN6_div_pos_reg_0 BUF1 $PINS O=FE_OFN714_FE_DBTN6_div_pos_reg_0
+ I=FE_OFN712_FE_DBTN6_div_pos_reg_0
XFE_OFC711_FE_DBTN6_div_pos_reg_0 INV1S $PINS
+ O=FE_OFN713_FE_DBTN6_div_pos_reg_0 I=FE_OFN711_FE_DBTN6_div_pos_reg_0
XFE_OFC710_FE_DBTN6_div_pos_reg_0 BUF1 $PINS O=FE_OFN712_FE_DBTN6_div_pos_reg_0
+ I=FE_OFN710_FE_DBTN6_div_pos_reg_0
XFE_OFC709_FE_DBTN6_div_pos_reg_0 INV1S $PINS
+ O=FE_OFN711_FE_DBTN6_div_pos_reg_0 I=FE_OFN709_FE_DBTN6_div_pos_reg_0
XFE_OFC708_FE_DBTN6_div_pos_reg_0 BUF1 $PINS O=FE_OFN710_FE_DBTN6_div_pos_reg_0
+ I=FE_OFN708_FE_DBTN6_div_pos_reg_0
XFE_OFC707_FE_DBTN6_div_pos_reg_0 BUF1 $PINS O=FE_OFN709_FE_DBTN6_div_pos_reg_0
+ I=FE_OFN646_div_pos_reg_0
XFE_OFC706_FE_DBTN6_div_pos_reg_0 BUF1 $PINS O=FE_OFN708_FE_DBTN6_div_pos_reg_0
+ I=FE_OFN646_div_pos_reg_0
XFE_OFC693_FE_DBTN15_n2359 BUF1 $PINS O=FE_OFN695_FE_DBTN15_n2359
+ I=FE_DBTN15_n2359
XFE_OFC692_FE_DBTN15_n2359 BUF1 $PINS O=FE_OFN694_FE_DBTN15_n2359
+ I=FE_DBTN15_n2359
XFE_OFC683_FE_DBTN32_div_pos_reg_3 INV1S $PINS
+ O=FE_OFN685_FE_DBTN32_div_pos_reg_3 I=FE_OFN683_FE_DBTN32_div_pos_reg_3
XFE_OFC682_FE_DBTN32_div_pos_reg_3 INV1S $PINS
+ O=FE_OFN684_FE_DBTN32_div_pos_reg_3 I=FE_OFN683_FE_DBTN32_div_pos_reg_3
XFE_OFC681_FE_DBTN32_div_pos_reg_3 INV1S $PINS
+ O=FE_OFN683_FE_DBTN32_div_pos_reg_3 I=FE_DBTN32_div_pos_reg_3
XFE_OFC680_FE_DBTN33_shift_amount_reg_3 INV2 $PINS
+ O=FE_OFN682_FE_DBTN33_shift_amount_reg_3
+ I=FE_OFN680_FE_DBTN33_shift_amount_reg_3
XFE_OFC679_FE_DBTN33_shift_amount_reg_3 INV1S $PINS
+ O=FE_OFN681_FE_DBTN33_shift_amount_reg_3
+ I=FE_OFN680_FE_DBTN33_shift_amount_reg_3
XFE_OFC678_FE_DBTN33_shift_amount_reg_3 INV2 $PINS
+ O=FE_OFN680_FE_DBTN33_shift_amount_reg_3 I=FE_DBTN33_shift_amount_reg_3
XFE_OFC677_FE_DBTN37_n4365 BUF1 $PINS O=FE_OFN679_FE_DBTN37_n4365
+ I=FE_DBTN37_n4365
XFE_OFC676_FE_DBTN45_intadd_21_SUM_1 BUF1 $PINS
+ O=FE_OFN678_FE_DBTN45_intadd_21_SUM_1 I=FE_DBTN45_intadd_21_SUM_1
XFE_OFC663_div_pos_reg_0 BUF1 $PINS O=FE_OFN665_div_pos_reg_0
+ I=FE_OFN663_div_pos_reg_0
XFE_OFC662_div_pos_reg_0 BUF1 $PINS O=FE_OFN664_div_pos_reg_0
+ I=FE_OFN663_div_pos_reg_0
XFE_OFC661_div_pos_reg_0 BUF1 $PINS O=FE_OFN663_div_pos_reg_0
+ I=FE_OFN661_div_pos_reg_0
XFE_OFC659_div_pos_reg_0 INV1S $PINS O=FE_OFN661_div_pos_reg_0
+ I=FE_OFN660_div_pos_reg_0
XFE_OFC658_div_pos_reg_0 INV1S $PINS O=FE_OFN660_div_pos_reg_0
+ I=FE_OFN658_div_pos_reg_0
XFE_OFC656_div_pos_reg_0 BUF1 $PINS O=FE_OFN658_div_pos_reg_0
+ I=FE_OFN657_div_pos_reg_0
XFE_OFC655_div_pos_reg_0 BUF1 $PINS O=FE_OFN657_div_pos_reg_0
+ I=FE_OFN655_div_pos_reg_0
XFE_OFC653_div_pos_reg_0 BUF1 $PINS O=FE_OFN655_div_pos_reg_0
+ I=FE_OFN654_div_pos_reg_0
XFE_OFC652_div_pos_reg_0 INV1S $PINS O=FE_OFN654_div_pos_reg_0
+ I=FE_OFN653_div_pos_reg_0
XFE_OFC651_div_pos_reg_0 INV1S $PINS O=FE_OFN653_div_pos_reg_0
+ I=FE_OFN652_div_pos_reg_0
XFE_OFC650_div_pos_reg_0 INV1S $PINS O=FE_OFN652_div_pos_reg_0
+ I=FE_OFN650_div_pos_reg_0
XFE_OFC649_div_pos_reg_0 BUF1 $PINS O=FE_OFN651_div_pos_reg_0
+ I=FE_OFN649_div_pos_reg_0
XFE_OFC648_div_pos_reg_0 INV1S $PINS O=FE_OFN650_div_pos_reg_0
+ I=FE_OFN648_div_pos_reg_0
XFE_OFC647_div_pos_reg_0 BUF1 $PINS O=FE_OFN649_div_pos_reg_0
+ I=FE_OFN647_div_pos_reg_0
XFE_OFC646_div_pos_reg_0 INV1S $PINS O=FE_OFN648_div_pos_reg_0
+ I=FE_OFN646_div_pos_reg_0
XFE_OFC645_div_pos_reg_0 BUF1 $PINS O=FE_OFN647_div_pos_reg_0
+ I=FE_OFN645_div_pos_reg_0
XFE_OFC644_div_pos_reg_0 INV1S $PINS O=FE_OFN646_div_pos_reg_0 I=div_pos_reg[0]
XFE_OFC643_div_pos_reg_0 BUF1 $PINS O=FE_OFN645_div_pos_reg_0 I=div_pos_reg[0]
XFE_OFC642_div_pos_reg_1 BUF1 $PINS O=FE_OFN644_div_pos_reg_1
+ I=FE_OFN642_div_pos_reg_1
XFE_OFC640_div_pos_reg_1 BUF1 $PINS O=FE_OFN642_div_pos_reg_1
+ I=FE_OFN640_div_pos_reg_1
XFE_OFC638_div_pos_reg_1 BUF1 $PINS O=FE_OFN640_div_pos_reg_1
+ I=FE_OFN635_div_pos_reg_1
XFE_OFC637_div_pos_reg_1 BUF1 $PINS O=FE_OFN639_div_pos_reg_1
+ I=FE_OFN635_div_pos_reg_1
XFE_OFC636_div_pos_reg_1 BUF1 $PINS O=FE_OFN638_div_pos_reg_1
+ I=FE_OFN635_div_pos_reg_1
XFE_OFC635_div_pos_reg_1 INV1S $PINS O=FE_OFN637_div_pos_reg_1
+ I=FE_OFN634_div_pos_reg_1
XFE_OFC634_div_pos_reg_1 INV1S $PINS O=FE_OFN636_div_pos_reg_1
+ I=FE_OFN634_div_pos_reg_1
XFE_OFC633_div_pos_reg_1 BUF1 $PINS O=FE_OFN635_div_pos_reg_1
+ I=FE_OFN633_div_pos_reg_1
XFE_OFC632_div_pos_reg_1 INV1S $PINS O=FE_OFN634_div_pos_reg_1
+ I=FE_OFN631_div_pos_reg_1
XFE_OFC631_div_pos_reg_1 BUF1 $PINS O=FE_OFN633_div_pos_reg_1
+ I=FE_OFN630_div_pos_reg_1
XFE_OFC630_div_pos_reg_1 BUF1 $PINS O=FE_OFN632_div_pos_reg_1
+ I=FE_OFN630_div_pos_reg_1
XFE_OFC629_div_pos_reg_1 BUF1 $PINS O=FE_OFN631_div_pos_reg_1
+ I=FE_OFN627_div_pos_reg_1
XFE_OFC628_div_pos_reg_1 BUF1 $PINS O=FE_OFN630_div_pos_reg_1
+ I=FE_OFN626_div_pos_reg_1
XFE_OFC627_div_pos_reg_1 BUF1 $PINS O=FE_OFN629_div_pos_reg_1
+ I=FE_OFN626_div_pos_reg_1
XFE_OFC626_div_pos_reg_1 BUF1 $PINS O=FE_OFN628_div_pos_reg_1
+ I=FE_OFN626_div_pos_reg_1
XFE_OFC625_div_pos_reg_1 BUF1 $PINS O=FE_OFN627_div_pos_reg_1
+ I=FE_OFN625_div_pos_reg_1
XFE_OFC624_div_pos_reg_1 BUF1 $PINS O=FE_OFN626_div_pos_reg_1 I=div_pos_reg[1]
XFE_OFC623_div_pos_reg_1 BUF1 $PINS O=FE_OFN625_div_pos_reg_1 I=div_pos_reg[1]
XFE_OFC622_div_pos_reg_2 INV1S $PINS O=FE_OFN624_div_pos_reg_2
+ I=FE_OFN622_div_pos_reg_2
XFE_OFC621_div_pos_reg_2 INV1S $PINS O=FE_OFN623_div_pos_reg_2
+ I=FE_OFN622_div_pos_reg_2
XFE_OFC620_div_pos_reg_2 INV1S $PINS O=FE_OFN622_div_pos_reg_2
+ I=FE_OFN620_div_pos_reg_2
XFE_OFC619_div_pos_reg_2 BUF1 $PINS O=FE_OFN621_div_pos_reg_2
+ I=FE_OFN620_div_pos_reg_2
XFE_OFC618_div_pos_reg_2 BUF1 $PINS O=FE_OFN620_div_pos_reg_2
+ I=FE_OFN617_div_pos_reg_2
XFE_OFC617_div_pos_reg_2 BUF1 $PINS O=FE_OFN619_div_pos_reg_2
+ I=FE_OFN617_div_pos_reg_2
XFE_OFC616_div_pos_reg_2 BUF1 $PINS O=FE_OFN618_div_pos_reg_2
+ I=FE_OFN615_div_pos_reg_2
XFE_OFC615_div_pos_reg_2 BUF1 $PINS O=FE_OFN617_div_pos_reg_2
+ I=FE_OFN614_div_pos_reg_2
XFE_OFC614_div_pos_reg_2 BUF1 $PINS O=FE_OFN616_div_pos_reg_2
+ I=FE_OFN614_div_pos_reg_2
XFE_OFC613_div_pos_reg_2 BUF1 $PINS O=FE_OFN615_div_pos_reg_2
+ I=FE_OFN612_div_pos_reg_2
XFE_OFC612_div_pos_reg_2 BUF1 $PINS O=FE_OFN614_div_pos_reg_2
+ I=FE_OFN611_div_pos_reg_2
XFE_OFC610_div_pos_reg_2 BUF1 $PINS O=FE_OFN612_div_pos_reg_2
+ I=FE_OFN609_div_pos_reg_2
XFE_OFC609_div_pos_reg_2 BUF1 $PINS O=FE_OFN611_div_pos_reg_2 I=div_pos_reg[2]
XFE_OFC608_div_pos_reg_2 BUF1 $PINS O=FE_OFN610_div_pos_reg_2 I=div_pos_reg[2]
XFE_OFC607_div_pos_reg_2 BUF1 $PINS O=FE_OFN609_div_pos_reg_2 I=div_pos_reg[2]
XFE_OFC606_div_pos_reg_3 BUF1 $PINS O=FE_OFN608_div_pos_reg_3 I=div_pos_reg[3]
XFE_OFC605_div_pos_reg_4 BUF1 $PINS O=FE_OFN607_div_pos_reg_4 I=div_pos_reg[4]
XFE_OFC604_shift_amount_reg_2 BUF1 $PINS O=FE_OFN606_shift_amount_reg_2
+ I=FE_OFN605_shift_amount_reg_2
XFE_OFC603_shift_amount_reg_2 BUF3 $PINS O=FE_OFN605_shift_amount_reg_2
+ I=shift_amount_reg[2]
XFE_OFC602_shift_amount_reg_3 BUF1 $PINS O=FE_OFN604_shift_amount_reg_3
+ I=FE_OFN603_shift_amount_reg_3
XFE_OFC601_shift_amount_reg_3 BUF4 $PINS O=FE_OFN603_shift_amount_reg_3
+ I=shift_amount_reg[3]
XFE_OFC600_shift_amount_reg_3 BUF1 $PINS O=FE_OFN602_shift_amount_reg_3
+ I=shift_amount_reg[3]
XFE_OFC596_IyIt_6 BUF1 $PINS O=FE_OFN598_IyIt_6 I=IyIt[6]
XFE_OFC595_IyIt_7 BUF1 $PINS O=FE_OFN597_IyIt_7 I=IyIt[7]
XFE_OFC594_IyIt_8 BUF1 $PINS O=FE_OFN596_IyIt_8 I=IyIt[8]
XFE_OFC593_IyIt_9 BUF1 $PINS O=FE_OFN595_IyIt_9 I=IyIt[9]
XFE_OFC590_IyIt_20 BUF1 $PINS O=FE_OFN592_IyIt_20 I=IyIt[20]
XFE_OFC587_IxIy_3 BUF1 $PINS O=FE_OFN589_IxIy_3 I=IxIy[3]
XFE_OFC586_IxIy_4 BUF1 $PINS O=FE_OFN588_IxIy_4 I=IxIy[4]
XFE_OFC584_IxIy_6 BUF1 $PINS O=FE_OFN586_IxIy_6 I=IxIy[6]
XFE_OFC579_IxIy_18 BUF1 $PINS O=FE_OFN581_IxIy_18 I=IxIy[18]
XFE_OFC578_IxIy_20 BUF1 $PINS O=FE_OFN580_IxIy_20 I=IxIy[20]
XFE_OFC577_IxIy_21 BUF1 $PINS O=FE_OFN579_IxIy_21 I=IxIy[21]
XFE_OFC576_IxIy_22 BUF1 $PINS O=FE_OFN578_IxIy_22 I=IxIy[22]
XFE_OFC575_Iy2_3 BUF1 $PINS O=FE_OFN577_Iy2_3 I=Iy2[3]
XFE_OFC573_Iy2_5 BUF1 $PINS O=FE_OFN575_Iy2_5 I=Iy2[5]
XFE_OFC572_Iy2_6 BUF1 $PINS O=FE_OFN574_Iy2_6 I=Iy2[6]
XFE_OFC571_Iy2_7 BUF1 $PINS O=FE_OFN573_Iy2_7 I=Iy2[7]
XFE_OFC570_Iy2_8 BUF1 $PINS O=FE_OFN572_Iy2_8 I=Iy2[8]
XFE_OFC569_Iy2_9 BUF1 $PINS O=FE_OFN571_Iy2_9 I=Iy2[9]
XFE_OFC568_Iy2_10 BUF1 $PINS O=FE_OFN570_Iy2_10 I=Iy2[10]
XFE_OFC567_Iy2_11 BUF1 $PINS O=FE_OFN569_Iy2_11 I=Iy2[11]
XFE_OFC566_Iy2_12 BUF1 $PINS O=FE_OFN568_Iy2_12 I=Iy2[12]
XFE_OFC565_Iy2_13 BUF1 $PINS O=FE_OFN567_Iy2_13 I=Iy2[13]
XFE_OFC564_Iy2_14 BUF1 $PINS O=FE_OFN566_Iy2_14 I=Iy2[14]
XFE_OFC562_Iy2_19 BUF1 $PINS O=FE_OFN564_Iy2_19 I=Iy2[19]
XFE_OFC561_Iy2_20 BUF1 $PINS O=FE_OFN563_Iy2_20 I=Iy2[20]
XFE_OFC560_Iy2_21 BUF1 $PINS O=FE_OFN562_Iy2_21 I=Iy2[21]
XFE_OFC556_IxIt_6 BUF1 $PINS O=FE_OFN558_IxIt_6 I=IxIt[6]
XFE_OFC555_IxIt_7 BUF1 $PINS O=FE_OFN557_IxIt_7 I=IxIt[7]
XFE_OFC554_IxIt_8 BUF1 $PINS O=FE_OFN556_IxIt_8 I=IxIt[8]
XFE_OFC552_IxIt_17 BUF1 $PINS O=FE_OFN554_IxIt_17 I=IxIt[17]
XFE_OFC549_IxIt_19 BUF1 $PINS O=FE_OFN551_IxIt_19 I=IxIt[19]
XFE_OFC546_IxIt_22 BUF1 $PINS O=FE_OFN548_IxIt_22 I=IxIt[22]
XFE_OFC544_Ix2_4 BUF1 $PINS O=FE_OFN546_Ix2_4 I=Ix2[4]
XFE_OFC543_Ix2_5 BUF1 $PINS O=FE_OFN545_Ix2_5 I=Ix2[5]
XFE_OFC542_Ix2_6 BUF1 $PINS O=FE_OFN544_Ix2_6 I=Ix2[6]
XFE_OFC541_Ix2_7 BUF1 $PINS O=FE_OFN543_Ix2_7 I=Ix2[7]
XFE_OFC540_Ix2_8 BUF1 $PINS O=FE_OFN542_Ix2_8 I=Ix2[8]
XFE_OFC537_Ix2_11 BUF1 $PINS O=FE_OFN539_Ix2_11 I=Ix2[11]
XFE_OFC531_Ix2_21 BUF1 $PINS O=FE_OFN533_Ix2_21 I=Ix2[21]
XFE_OFC527_n4365 BUF1 $PINS O=FE_OFN529_n4365 I=FE_OFN527_n4365
XFE_OFC526_n4365 BUF1 $PINS O=FE_OFN528_n4365 I=FE_OFN527_n4365
XFE_OFC525_n4365 INV1S $PINS O=FE_OFN527_n4365 I=FE_OFN526_n4365
XFE_OFC524_n4365 INV1S $PINS O=FE_OFN526_n4365 I=FE_OFN524_n4365
XFE_OFC523_n4365 BUF1 $PINS O=FE_OFN525_n4365 I=FE_OFN524_n4365
XFE_OFC522_n4365 BUF1 $PINS O=FE_OFN524_n4365 I=n4365
XFE_OFC519_n4337 INV2 $PINS O=FE_OFN521_n4337 I=FE_OFN519_n4337
XFE_OFC515_n4245 INV1S $PINS O=FE_OFN517_n4245 I=FE_OFN515_n4245
XFE_OFC514_n4245 INV1S $PINS O=FE_OFN516_n4245 I=FE_OFN515_n4245
XFE_OFC513_n4245 INV1S $PINS O=FE_OFN515_n4245 I=n4245
XFE_OFC504_n2949 BUF1 $PINS O=FE_OFN506_n2949 I=FE_OFN501_n2949
XFE_OFC503_n2949 BUF1 $PINS O=FE_OFN505_n2949 I=FE_OFN501_n2949
XFE_OFC499_n2949 INV1S $PINS O=FE_OFN501_n2949 I=FE_OFN500_n2949
XFE_OFC498_n2949 INV1S $PINS O=FE_OFN500_n2949 I=FE_OFN499_n2949
XFE_OFC497_n2949 BUF1 $PINS O=FE_OFN499_n2949 I=FE_OFN496_n2949
XFE_OFC496_n2949 BUF1 $PINS O=FE_OFN498_n2949 I=FE_OFN496_n2949
XFE_OFC495_n2949 BUF1 $PINS O=FE_OFN497_n2949 I=FE_OFN495_n2949
XFE_OFC494_n2949 BUF1 $PINS O=FE_OFN496_n2949 I=FE_OFN493_n2949
XFE_OFC493_n2949 BUF1 $PINS O=FE_OFN495_n2949 I=FE_OFN493_n2949
XFE_OFC492_n2949 BUF1 $PINS O=FE_OFN494_n2949 I=FE_OFN493_n2949
XFE_OFC491_n2949 BUF1 $PINS O=FE_OFN493_n2949 I=FE_OFN491_n2949
XFE_OFC490_n2949 BUF1 $PINS O=FE_OFN492_n2949 I=FE_OFN491_n2949
XFE_OFC489_n2949 BUF1 $PINS O=FE_OFN491_n2949 I=n2949
XFE_OFC488_n2359 BUF1 $PINS O=FE_OFN490_n2359 I=n2359
XFE_OFC487_n2357 BUF1 $PINS O=FE_OFN489_n2357 I=FE_OFN487_n2357
XFE_OFC486_n2357 BUF1 $PINS O=FE_OFN488_n2357 I=FE_OFN486_n2357
XFE_OFC485_n2357 INV1S $PINS O=FE_OFN487_n2357 I=FE_OFN485_n2357
XFE_OFC484_n2357 INV1S $PINS O=FE_OFN486_n2357 I=FE_OFN485_n2357
XFE_OFC483_n2357 INV1S $PINS O=FE_OFN485_n2357 I=n2357
XFE_OFC482_n2356 BUF1 $PINS O=FE_OFN484_n2356 I=FE_OFN482_n2356
XFE_OFC481_n2356 BUF1 $PINS O=FE_OFN483_n2356 I=n2356
XFE_OFC480_n2356 BUF1 $PINS O=FE_OFN482_n2356 I=n2356
XFE_OFC461_n1703 BUF1 $PINS O=FE_OFN463_n1703 I=FE_OFN461_n1703
XFE_OFC460_n1703 BUF1 $PINS O=FE_OFN462_n1703 I=FE_OFN460_n1703
XFE_OFC459_n1703 BUF1 $PINS O=FE_OFN461_n1703 I=FE_OFN459_n1703
XFE_OFC458_n1703 BUF1 $PINS O=FE_OFN460_n1703 I=FE_OFN459_n1703
XFE_OFC457_n1703 INV1S $PINS O=FE_OFN459_n1703 I=FE_OFN457_n1703
XFE_OFC456_n1703 INV1S $PINS O=FE_OFN458_n1703 I=FE_OFN457_n1703
XFE_OFC455_n1703 INV1S $PINS O=FE_OFN457_n1703 I=n1703
XFE_OFC454_n1703 BUF1 $PINS O=FE_OFN456_n1703 I=n1703
XFE_OFC452_n1693 BUF1 $PINS O=FE_OFN454_n1693 I=FE_OFN452_n1693
XFE_OFC451_n1693 BUF1 $PINS O=FE_OFN453_n1693 I=FE_OFN452_n1693
XFE_OFC450_n1693 BUF1 $PINS O=FE_OFN452_n1693 I=FE_OFN450_n1693
XFE_OFC449_n1693 BUF1 $PINS O=FE_OFN451_n1693 I=FE_OFN449_n1693
XFE_OFC448_n1693 BUF1 $PINS O=FE_OFN450_n1693 I=FE_OFN448_n1693
XFE_OFC447_n1693 BUF1 $PINS O=FE_OFN449_n1693 I=FE_OFN447_n1693
XFE_OFC446_n1693 INV1S $PINS O=FE_OFN448_n1693 I=FE_OFN446_n1693
XFE_OFC445_n1693 INV1S $PINS O=FE_OFN447_n1693 I=FE_OFN446_n1693
XFE_OFC444_n1693 INV1S $PINS O=FE_OFN446_n1693 I=FE_OFN445_n1693
XFE_OFC443_n1693 BUF1 $PINS O=FE_OFN445_n1693 I=n1693
XFE_OFC442_intadd_21_n1 BUF1 $PINS O=FE_OFN444_intadd_21_n1
+ I=FE_OFN443_intadd_21_n1
XFE_OFC441_intadd_21_n1 BUF1 $PINS O=FE_OFN443_intadd_21_n1 I=intadd_21/n1
XFE_OFC434_intadd_21_SUM_4 BUF1 $PINS O=FE_OFN436_intadd_21_SUM_4
+ I=FE_OFN434_intadd_21_SUM_4
XFE_OFC433_intadd_21_SUM_4 INV1S $PINS O=FE_OFN435_intadd_21_SUM_4
+ I=FE_OFN433_intadd_21_SUM_4
XFE_OFC432_intadd_21_SUM_4 INV2 $PINS O=FE_OFN434_intadd_21_SUM_4
+ I=FE_OFN433_intadd_21_SUM_4
XFE_OFC431_intadd_21_SUM_4 INV1S $PINS O=FE_OFN433_intadd_21_SUM_4
+ I=intadd_21/SUM[4]
XFE_OFC426_intadd_21_SUM_6 INV1S $PINS O=FE_OFN428_intadd_21_SUM_6
+ I=FE_OFN424_intadd_21_SUM_6
XFE_OFC424_intadd_21_SUM_6 INV1S $PINS O=FE_OFN426_intadd_21_SUM_6
+ I=FE_OFN424_intadd_21_SUM_6
XFE_OFC423_intadd_21_SUM_6 INV2 $PINS O=FE_OFN425_intadd_21_SUM_6
+ I=FE_OFN424_intadd_21_SUM_6
XFE_OFC422_intadd_21_SUM_6 INV1S $PINS O=FE_OFN424_intadd_21_SUM_6
+ I=intadd_21/SUM[6]
XFE_OFC387_Ix_0__7 BUF1 $PINS O=FE_OFN389_Ix_0__7 I=Ix[0][7]
XFE_OFC385_It_0__7 BUF1 $PINS O=FE_OFN387_It_0__7 I=It[0][7]
XFE_OFC356_FE_DBTN19_n2355 BUF1 $PINS O=FE_OFN358_FE_DBTN19_n2355
+ I=FE_OFN356_FE_DBTN19_n2355
XFE_OFC355_FE_DBTN19_n2355 BUF1 $PINS O=FE_OFN357_FE_DBTN19_n2355
+ I=FE_DBTN19_n2355
XFE_OFC354_FE_DBTN19_n2355 BUF1 $PINS O=FE_OFN356_FE_DBTN19_n2355
+ I=FE_DBTN19_n2355
XFE_OFC346_FE_DBTN35_n1689 INV1S $PINS O=FE_OFN348_FE_DBTN35_n1689
+ I=FE_OFN346_FE_DBTN35_n1689
XFE_OFC345_FE_DBTN35_n1689 INV1S $PINS O=FE_OFN347_FE_DBTN35_n1689
+ I=FE_OFN346_FE_DBTN35_n1689
XFE_OFC344_FE_DBTN35_n1689 INV1S $PINS O=FE_OFN346_FE_DBTN35_n1689
+ I=FE_OFN345_FE_DBTN35_n1689
XFE_OFC343_FE_DBTN35_n1689 BUF1 $PINS O=FE_OFN345_FE_DBTN35_n1689
+ I=FE_DBTN35_n1689
XFE_OFC342_FE_DBTN35_n1689 BUF1 $PINS O=FE_OFN344_FE_DBTN35_n1689
+ I=FE_DBTN35_n1689
XFE_OFC341_FE_DBTN40_shift_amount_reg_1 BUF1 $PINS
+ O=FE_OFN343_FE_DBTN40_shift_amount_reg_1 I=FE_DBTN40_shift_amount_reg_1
XFE_OFC340_FE_DBTN47_Ix_0_0 BUF1 $PINS O=FE_OFN342_FE_DBTN47_Ix_0_0
+ I=FE_DBTN47_Ix_0_0
XFE_OFC339_FE_DBTN48_Ix_0_1 BUF1 $PINS O=FE_OFN341_FE_DBTN48_Ix_0_1
+ I=FE_DBTN48_Ix_0_1
XFE_OFC338_FE_DBTN49_Ix_0_2 BUF1 $PINS O=FE_OFN340_FE_DBTN49_Ix_0_2
+ I=FE_DBTN49_Ix_0_2
XFE_OFC337_FE_DBTN50_Ix_0_3 BUF1 $PINS O=FE_OFN339_FE_DBTN50_Ix_0_3
+ I=FE_DBTN50_Ix_0_3
XFE_OFC336_FE_DBTN51_Ix_0_4 BUF1 $PINS O=FE_OFN338_FE_DBTN51_Ix_0_4
+ I=FE_DBTN51_Ix_0_4
XFE_OFC335_FE_DBTN52_Ix_0_5 BUF1 $PINS O=FE_OFN337_FE_DBTN52_Ix_0_5
+ I=FE_DBTN52_Ix_0_5
XFE_OFC334_FE_DBTN53_Ix_0_6 BUF1 $PINS O=FE_OFN336_FE_DBTN53_Ix_0_6
+ I=FE_DBTN53_Ix_0_6
XFE_OFC333_FE_DBTN54_Ix_0_8 BUF1 $PINS O=FE_OFN335_FE_DBTN54_Ix_0_8
+ I=FE_DBTN54_Ix_0_8
XFE_OFC332_FE_DBTN55_It_4_0 BUF1 $PINS O=FE_OFN334_FE_DBTN55_It_4_0
+ I=FE_DBTN55_It_4_0
XFE_OFC331_FE_DBTN56_It_4_1 BUF1 $PINS O=FE_OFN333_FE_DBTN56_It_4_1
+ I=FE_DBTN56_It_4_1
XFE_OFC330_FE_DBTN57_It_4_2 BUF1 $PINS O=FE_OFN332_FE_DBTN57_It_4_2
+ I=FE_DBTN57_It_4_2
XFE_OFC329_FE_DBTN58_It_4_3 BUF1 $PINS O=FE_OFN331_FE_DBTN58_It_4_3
+ I=FE_DBTN58_It_4_3
XFE_OFC328_FE_DBTN59_It_4_4 BUF1 $PINS O=FE_OFN330_FE_DBTN59_It_4_4
+ I=FE_DBTN59_It_4_4
XFE_OFC327_FE_DBTN60_It_4_5 BUF1 $PINS O=FE_OFN329_FE_DBTN60_It_4_5
+ I=FE_DBTN60_It_4_5
XFE_OFC326_FE_DBTN61_It_4_6 INV1S $PINS O=FE_OFN328_FE_DBTN61_It_4_6
+ I=FE_OFN326_FE_DBTN61_It_4_6
XFE_OFC325_FE_DBTN61_It_4_6 INV1S $PINS O=FE_OFN327_FE_DBTN61_It_4_6
+ I=FE_OFN326_FE_DBTN61_It_4_6
XFE_OFC324_FE_DBTN61_It_4_6 INV1S $PINS O=FE_OFN326_FE_DBTN61_It_4_6
+ I=FE_DBTN61_It_4_6
XFE_OFC323_FE_DBTN62_It_4_8 BUF1 $PINS O=FE_OFN325_FE_DBTN62_It_4_8
+ I=FE_DBTN62_It_4_8
XFE_OFC322_FE_DBTN63_It_0_0 BUF1 $PINS O=FE_OFN324_FE_DBTN63_It_0_0
+ I=FE_DBTN63_It_0_0
XFE_OFC321_FE_DBTN64_It_0_1 BUF1 $PINS O=FE_OFN323_FE_DBTN64_It_0_1
+ I=FE_DBTN64_It_0_1
XFE_OFC320_FE_DBTN65_It_0_2 BUF1 $PINS O=FE_OFN322_FE_DBTN65_It_0_2
+ I=FE_DBTN65_It_0_2
XFE_OFC319_FE_DBTN66_It_0_3 BUF1 $PINS O=FE_OFN321_FE_DBTN66_It_0_3
+ I=FE_DBTN66_It_0_3
XFE_OFC318_FE_DBTN67_It_0_4 BUF1 $PINS O=FE_OFN320_FE_DBTN67_It_0_4
+ I=FE_DBTN67_It_0_4
XFE_OFC317_FE_DBTN68_It_0_5 BUF1 $PINS O=FE_OFN319_FE_DBTN68_It_0_5
+ I=FE_DBTN68_It_0_5
XFE_OFC316_FE_DBTN69_It_0_6 BUF1 $PINS O=FE_OFN318_FE_DBTN69_It_0_6
+ I=FE_DBTN69_It_0_6
XFE_OFC266_i_reset_n_i INV1S $PINS O=FE_OFN268_i_reset_n_i
+ I=FE_OFN263_i_reset_n_i
XFE_OFC265_i_reset_n_i INV1S $PINS O=FE_OFN267_i_reset_n_i
+ I=FE_OFN263_i_reset_n_i
XFE_OFC263_i_reset_n_i BUF1 $PINS O=FE_OFN265_i_reset_n_i
+ I=FE_OFN256_i_reset_n_i
XFE_OFC262_i_reset_n_i BUF1 $PINS O=FE_OFN264_i_reset_n_i
+ I=FE_OFN254_i_reset_n_i
XFE_OFC261_i_reset_n_i INV1S $PINS O=FE_OFN263_i_reset_n_i
+ I=FE_OFN241_i_reset_n_i
XFE_OFC259_i_reset_n_i BUF1 $PINS O=FE_OFN261_i_reset_n_i
+ I=FE_OFN228_i_reset_n_i
XFE_OFC256_i_reset_n_i BUF1 $PINS O=FE_OFN258_i_reset_n_i
+ I=FE_OFN224_i_reset_n_i
XFE_OFC255_i_reset_n_i BUF1 $PINS O=FE_OFN257_i_reset_n_i
+ I=FE_OFN224_i_reset_n_i
XFE_OFC254_i_reset_n_i BUF1 $PINS O=FE_OFN256_i_reset_n_i
+ I=FE_OFN220_i_reset_n_i
XFE_OFC253_i_reset_n_i BUF1 $PINS O=FE_OFN255_i_reset_n_i
+ I=FE_OFN220_i_reset_n_i
XFE_OFC252_i_reset_n_i BUF1 $PINS O=FE_OFN254_i_reset_n_i
+ I=FE_OFN219_i_reset_n_i
XFE_OFC251_i_reset_n_i BUF1 $PINS O=FE_OFN253_i_reset_n_i
+ I=FE_OFN218_i_reset_n_i
XFE_OFC250_i_reset_n_i BUF1 $PINS O=FE_OFN252_i_reset_n_i
+ I=FE_OFN216_i_reset_n_i
XFE_OFC243_i_reset_n_i BUF1 $PINS O=FE_OFN245_i_reset_n_i
+ I=FE_OFN211_i_reset_n_i
XFE_OFC241_i_reset_n_i BUF1 $PINS O=FE_OFN243_i_reset_n_i
+ I=FE_OFN210_i_reset_n_i
XFE_OFC240_i_reset_n_i BUF1 $PINS O=FE_OFN242_i_reset_n_i
+ I=FE_OFN210_i_reset_n_i
XFE_OFC239_i_reset_n_i BUF1 $PINS O=FE_OFN241_i_reset_n_i
+ I=FE_OFN210_i_reset_n_i
XFE_OFC238_i_reset_n_i BUF1 $PINS O=FE_OFN240_i_reset_n_i
+ I=FE_OFN206_i_reset_n_i
XFE_OFC237_i_reset_n_i BUF1 $PINS O=FE_OFN239_i_reset_n_i
+ I=FE_OFN206_i_reset_n_i
XFE_OFC236_i_reset_n_i BUF1 $PINS O=FE_OFN238_i_reset_n_i
+ I=FE_OFN206_i_reset_n_i
XFE_OFC235_i_reset_n_i BUF1 $PINS O=FE_OFN237_i_reset_n_i
+ I=FE_OFN204_i_reset_n_i
XFE_OFC234_i_reset_n_i BUF1 $PINS O=FE_OFN236_i_reset_n_i
+ I=FE_OFN204_i_reset_n_i
XFE_OFC233_i_reset_n_i BUF1 $PINS O=FE_OFN235_i_reset_n_i
+ I=FE_OFN204_i_reset_n_i
XFE_OFC232_i_reset_n_i BUF1 $PINS O=FE_OFN234_i_reset_n_i
+ I=FE_OFN202_i_reset_n_i
XFE_OFC229_i_reset_n_i BUF1 $PINS O=FE_OFN231_i_reset_n_i
+ I=FE_OFN198_i_reset_n_i
XFE_OFC226_i_reset_n_i INV1S $PINS O=FE_OFN228_i_reset_n_i
+ I=FE_OFN190_i_reset_n_i
XFE_OFC225_i_reset_n_i BUF1 $PINS O=FE_OFN227_i_reset_n_i
+ I=FE_OFN187_i_reset_n_i
XFE_OFC224_i_reset_n_i BUF1 $PINS O=FE_OFN226_i_reset_n_i
+ I=FE_OFN187_i_reset_n_i
XFE_OFC223_i_reset_n_i BUF1 $PINS O=FE_OFN225_i_reset_n_i
+ I=FE_OFN186_i_reset_n_i
XFE_OFC222_i_reset_n_i BUF1 $PINS O=FE_OFN224_i_reset_n_i
+ I=FE_OFN181_i_reset_n_i
XFE_OFC218_i_reset_n_i BUF1 $PINS O=FE_OFN220_i_reset_n_i
+ I=FE_OFN175_i_reset_n_i
XFE_OFC217_i_reset_n_i BUF1 $PINS O=FE_OFN219_i_reset_n_i
+ I=FE_OFN175_i_reset_n_i
XFE_OFC216_i_reset_n_i BUF1 $PINS O=FE_OFN218_i_reset_n_i
+ I=FE_OFN175_i_reset_n_i
XFE_OFC215_i_reset_n_i BUF1 $PINS O=FE_OFN217_i_reset_n_i
+ I=FE_OFN174_i_reset_n_i
XFE_OFC214_i_reset_n_i BUF1 $PINS O=FE_OFN216_i_reset_n_i
+ I=FE_OFN170_i_reset_n_i
XFE_OFC210_i_reset_n_i BUF1 $PINS O=FE_OFN212_i_reset_n_i
+ I=FE_OFN166_i_reset_n_i
XFE_OFC209_i_reset_n_i BUF1 $PINS O=FE_OFN211_i_reset_n_i
+ I=FE_OFN165_i_reset_n_i
XFE_OFC208_i_reset_n_i BUF1 $PINS O=FE_OFN210_i_reset_n_i
+ I=FE_OFN163_i_reset_n_i
XFE_OFC207_i_reset_n_i BUF1 $PINS O=FE_OFN209_i_reset_n_i
+ I=FE_OFN160_i_reset_n_i
XFE_OFC206_i_reset_n_i BUF1 $PINS O=FE_OFN208_i_reset_n_i
+ I=FE_OFN159_i_reset_n_i
XFE_OFC205_i_reset_n_i BUF1 $PINS O=FE_OFN207_i_reset_n_i
+ I=FE_OFN158_i_reset_n_i
XFE_OFC204_i_reset_n_i BUF1 $PINS O=FE_OFN206_i_reset_n_i
+ I=FE_OFN157_i_reset_n_i
XFE_OFC203_i_reset_n_i BUF1 $PINS O=FE_OFN205_i_reset_n_i
+ I=FE_OFN157_i_reset_n_i
XFE_OFC202_i_reset_n_i BUF1 $PINS O=FE_OFN204_i_reset_n_i
+ I=FE_OFN156_i_reset_n_i
XFE_OFC201_i_reset_n_i BUF1 $PINS O=FE_OFN203_i_reset_n_i
+ I=FE_OFN156_i_reset_n_i
XFE_OFC200_i_reset_n_i BUF1 $PINS O=FE_OFN202_i_reset_n_i
+ I=FE_OFN155_i_reset_n_i
XFE_OFC197_i_reset_n_i BUF1 $PINS O=FE_OFN199_i_reset_n_i
+ I=FE_OFN154_i_reset_n_i
XFE_OFC196_i_reset_n_i BUF1 $PINS O=FE_OFN198_i_reset_n_i
+ I=FE_OFN152_i_reset_n_i
XFE_OFC195_i_reset_n_i BUF1 $PINS O=FE_OFN197_i_reset_n_i
+ I=FE_OFN152_i_reset_n_i
XFE_OFC194_i_reset_n_i BUF1 $PINS O=FE_OFN196_i_reset_n_i
+ I=FE_OFN151_i_reset_n_i
XFE_OFC193_i_reset_n_i BUF1 $PINS O=FE_OFN195_i_reset_n_i
+ I=FE_OFN150_i_reset_n_i
XFE_OFC192_i_reset_n_i BUF1 $PINS O=FE_OFN194_i_reset_n_i
+ I=FE_OFN147_i_reset_n_i
XFE_OFC190_i_reset_n_i BUF1 $PINS O=FE_OFN192_i_reset_n_i
+ I=FE_OFN143_i_reset_n_i
XFE_OFC189_i_reset_n_i BUF1 $PINS O=FE_OFN191_i_reset_n_i
+ I=FE_OFN143_i_reset_n_i
XFE_OFC188_i_reset_n_i INV1S $PINS O=FE_OFN190_i_reset_n_i
+ I=FE_OFN142_i_reset_n_i
XFE_OFC185_i_reset_n_i BUF1 $PINS O=FE_OFN187_i_reset_n_i
+ I=FE_OFN141_i_reset_n_i
XFE_OFC184_i_reset_n_i BUF1 $PINS O=FE_OFN186_i_reset_n_i
+ I=FE_OFN140_i_reset_n_i
XFE_OFC181_i_reset_n_i BUF1 $PINS O=FE_OFN183_i_reset_n_i
+ I=FE_OFN136_i_reset_n_i
XFE_OFC180_i_reset_n_i BUF1 $PINS O=FE_OFN182_i_reset_n_i
+ I=FE_OFN136_i_reset_n_i
XFE_OFC179_i_reset_n_i BUF1 $PINS O=FE_OFN181_i_reset_n_i
+ I=FE_OFN135_i_reset_n_i
XFE_OFC173_i_reset_n_i BUF1 $PINS O=FE_OFN175_i_reset_n_i
+ I=FE_OFN127_i_reset_n_i
XFE_OFC172_i_reset_n_i BUF1 $PINS O=FE_OFN174_i_reset_n_i
+ I=FE_OFN125_i_reset_n_i
XFE_OFC168_i_reset_n_i BUF1 $PINS O=FE_OFN170_i_reset_n_i
+ I=FE_OFN120_i_reset_n_i
XFE_OFC167_i_reset_n_i BUF1 $PINS O=FE_OFN169_i_reset_n_i
+ I=FE_OFN117_i_reset_n_i
XFE_OFC166_i_reset_n_i BUF1 $PINS O=FE_OFN168_i_reset_n_i
+ I=FE_OFN117_i_reset_n_i
XFE_OFC164_i_reset_n_i BUF1 $PINS O=FE_OFN166_i_reset_n_i
+ I=FE_OFN116_i_reset_n_i
XFE_OFC163_i_reset_n_i BUF1 $PINS O=FE_OFN165_i_reset_n_i
+ I=FE_OFN115_i_reset_n_i
XFE_OFC161_i_reset_n_i BUF1 $PINS O=FE_OFN163_i_reset_n_i
+ I=FE_OFN113_i_reset_n_i
XFE_OFC159_i_reset_n_i BUF1 $PINS O=FE_OFN161_i_reset_n_i
+ I=FE_OFN112_i_reset_n_i
XFE_OFC158_i_reset_n_i BUF1 $PINS O=FE_OFN160_i_reset_n_i
+ I=FE_OFN111_i_reset_n_i
XFE_OFC157_i_reset_n_i BUF1 $PINS O=FE_OFN159_i_reset_n_i
+ I=FE_OFN111_i_reset_n_i
XFE_OFC156_i_reset_n_i BUF1 $PINS O=FE_OFN158_i_reset_n_i
+ I=FE_OFN110_i_reset_n_i
XFE_OFC155_i_reset_n_i BUF1 $PINS O=FE_OFN157_i_reset_n_i
+ I=FE_OFN107_i_reset_n_i
XFE_OFC154_i_reset_n_i BUF1 $PINS O=FE_OFN156_i_reset_n_i
+ I=FE_OFN106_i_reset_n_i
XFE_OFC153_i_reset_n_i BUF1 $PINS O=FE_OFN155_i_reset_n_i
+ I=FE_OFN106_i_reset_n_i
XFE_OFC152_i_reset_n_i BUF1 $PINS O=FE_OFN154_i_reset_n_i
+ I=FE_OFN104_i_reset_n_i
XFE_OFC151_i_reset_n_i BUF1 $PINS O=FE_OFN153_i_reset_n_i
+ I=FE_OFN104_i_reset_n_i
XFE_OFC150_i_reset_n_i BUF1 $PINS O=FE_OFN152_i_reset_n_i
+ I=FE_OFN101_i_reset_n_i
XFE_OFC149_i_reset_n_i BUF1 $PINS O=FE_OFN151_i_reset_n_i
+ I=FE_OFN99_i_reset_n_i
XFE_OFC148_i_reset_n_i BUF1 $PINS O=FE_OFN150_i_reset_n_i
+ I=FE_OFN99_i_reset_n_i
XFE_OFC145_i_reset_n_i BUF1 $PINS O=FE_OFN147_i_reset_n_i
+ I=FE_OFN97_i_reset_n_i
XFE_OFC144_i_reset_n_i BUF1 $PINS O=FE_OFN146_i_reset_n_i
+ I=FE_OFN97_i_reset_n_i
XFE_OFC141_i_reset_n_i BUF1 $PINS O=FE_OFN143_i_reset_n_i
+ I=FE_OFN95_i_reset_n_i
XFE_OFC140_i_reset_n_i BUF1 $PINS O=FE_OFN142_i_reset_n_i
+ I=FE_OFN94_i_reset_n_i
XFE_OFC139_i_reset_n_i BUF1 $PINS O=FE_OFN141_i_reset_n_i
+ I=FE_OFN92_i_reset_n_i
XFE_OFC138_i_reset_n_i BUF1 $PINS O=FE_OFN140_i_reset_n_i
+ I=FE_OFN92_i_reset_n_i
XFE_OFC137_i_reset_n_i BUF1 $PINS O=FE_OFN139_i_reset_n_i
+ I=FE_OFN91_i_reset_n_i
XFE_OFC136_i_reset_n_i BUF1 $PINS O=FE_OFN138_i_reset_n_i
+ I=FE_OFN91_i_reset_n_i
XFE_OFC135_i_reset_n_i BUF1 $PINS O=FE_OFN137_i_reset_n_i
+ I=FE_OFN90_i_reset_n_i
XFE_OFC134_i_reset_n_i BUF1 $PINS O=FE_OFN136_i_reset_n_i
+ I=FE_OFN90_i_reset_n_i
XFE_OFC133_i_reset_n_i BUF1 $PINS O=FE_OFN135_i_reset_n_i
+ I=FE_OFN88_i_reset_n_i
XFE_OFC126_i_reset_n_i BUF1 $PINS O=FE_OFN128_i_reset_n_i
+ I=FE_OFN81_i_reset_n_i
XFE_OFC125_i_reset_n_i BUF1 $PINS O=FE_OFN127_i_reset_n_i
+ I=FE_OFN79_i_reset_n_i
XFE_OFC124_i_reset_n_i BUF1 $PINS O=FE_OFN126_i_reset_n_i
+ I=FE_OFN79_i_reset_n_i
XFE_OFC123_i_reset_n_i BUF1 $PINS O=FE_OFN125_i_reset_n_i
+ I=FE_OFN79_i_reset_n_i
XFE_OFC122_i_reset_n_i BUF1 $PINS O=FE_OFN124_i_reset_n_i
+ I=FE_OFN79_i_reset_n_i
XFE_OFC118_i_reset_n_i BUF1 $PINS O=FE_OFN120_i_reset_n_i
+ I=FE_OFN76_i_reset_n_i
XFE_OFC116_i_reset_n_i BUF1 $PINS O=FE_OFN118_i_reset_n_i
+ I=FE_OFN75_i_reset_n_i
XFE_OFC115_i_reset_n_i BUF1 $PINS O=FE_OFN117_i_reset_n_i
+ I=FE_OFN74_i_reset_n_i
XFE_OFC114_i_reset_n_i BUF1 $PINS O=FE_OFN116_i_reset_n_i
+ I=FE_OFN74_i_reset_n_i
XFE_OFC113_i_reset_n_i BUF1 $PINS O=FE_OFN115_i_reset_n_i
+ I=FE_OFN73_i_reset_n_i
XFE_OFC111_i_reset_n_i BUF1 $PINS O=FE_OFN113_i_reset_n_i
+ I=FE_OFN72_i_reset_n_i
XFE_OFC110_i_reset_n_i BUF1 $PINS O=FE_OFN112_i_reset_n_i
+ I=FE_OFN72_i_reset_n_i
XFE_OFC109_i_reset_n_i BUF1 $PINS O=FE_OFN111_i_reset_n_i
+ I=FE_OFN70_i_reset_n_i
XFE_OFC108_i_reset_n_i BUF1 $PINS O=FE_OFN110_i_reset_n_i
+ I=FE_OFN70_i_reset_n_i
XFE_OFC107_i_reset_n_i BUF1 $PINS O=FE_OFN109_i_reset_n_i
+ I=FE_OFN70_i_reset_n_i
XFE_OFC106_i_reset_n_i BUF1 $PINS O=FE_OFN108_i_reset_n_i
+ I=FE_OFN69_i_reset_n_i
XFE_OFC105_i_reset_n_i BUF1 $PINS O=FE_OFN107_i_reset_n_i
+ I=FE_OFN68_i_reset_n_i
XFE_OFC104_i_reset_n_i BUF1 $PINS O=FE_OFN106_i_reset_n_i
+ I=FE_OFN65_i_reset_n_i
XFE_OFC103_i_reset_n_i BUF1 $PINS O=FE_OFN105_i_reset_n_i
+ I=FE_OFN65_i_reset_n_i
XFE_OFC102_i_reset_n_i BUF1 $PINS O=FE_OFN104_i_reset_n_i
+ I=FE_OFN63_i_reset_n_i
XFE_OFC101_i_reset_n_i BUF1 $PINS O=FE_OFN103_i_reset_n_i
+ I=FE_OFN63_i_reset_n_i
XFE_OFC100_i_reset_n_i BUF1 $PINS O=FE_OFN102_i_reset_n_i
+ I=FE_OFN63_i_reset_n_i
XFE_OFC99_i_reset_n_i BUF1 $PINS O=FE_OFN101_i_reset_n_i I=FE_OFN61_i_reset_n_i
XFE_OFC98_i_reset_n_i BUF1 $PINS O=FE_OFN100_i_reset_n_i I=FE_OFN61_i_reset_n_i
XFE_OFC97_i_reset_n_i BUF1 $PINS O=FE_OFN99_i_reset_n_i I=FE_OFN60_i_reset_n_i
XFE_OFC95_i_reset_n_i BUF1 $PINS O=FE_OFN97_i_reset_n_i I=FE_OFN58_i_reset_n_i
XFE_OFC93_i_reset_n_i BUF1 $PINS O=FE_OFN95_i_reset_n_i I=FE_OFN57_i_reset_n_i
XFE_OFC92_i_reset_n_i BUF1 $PINS O=FE_OFN94_i_reset_n_i I=FE_OFN57_i_reset_n_i
XFE_OFC91_i_reset_n_i BUF1 $PINS O=FE_OFN93_i_reset_n_i I=FE_OFN57_i_reset_n_i
XFE_OFC90_i_reset_n_i BUF1 $PINS O=FE_OFN92_i_reset_n_i I=FE_OFN56_i_reset_n_i
XFE_OFC89_i_reset_n_i BUF1 $PINS O=FE_OFN91_i_reset_n_i I=FE_OFN54_i_reset_n_i
XFE_OFC88_i_reset_n_i BUF1 $PINS O=FE_OFN90_i_reset_n_i I=FE_OFN54_i_reset_n_i
XFE_OFC87_i_reset_n_i BUF1 $PINS O=FE_OFN89_i_reset_n_i I=FE_OFN54_i_reset_n_i
XFE_OFC86_i_reset_n_i BUF1 $PINS O=FE_OFN88_i_reset_n_i I=FE_OFN53_i_reset_n_i
XFE_OFC80_i_reset_n_i BUF1 $PINS O=FE_OFN81_i_reset_n_i I=FE_OFN47_i_reset_n_i
XFE_OFC78_i_reset_n_i BUF1 $PINS O=FE_OFN79_i_reset_n_i I=FE_OFN45_i_reset_n_i
XFE_OFC75_i_reset_n_i BUF1 $PINS O=FE_OFN76_i_reset_n_i I=FE_OFN41_i_reset_n_i
XFE_OFC74_i_reset_n_i BUF1 $PINS O=FE_OFN75_i_reset_n_i I=FE_OFN40_i_reset_n_i
XFE_OFC73_i_reset_n_i BUF1 $PINS O=FE_OFN74_i_reset_n_i I=FE_OFN39_i_reset_n_i
XFE_OFC72_i_reset_n_i BUF1 $PINS O=FE_OFN73_i_reset_n_i I=FE_OFN15_i_reset_n_i
XFE_OFC71_i_reset_n_i BUF1 $PINS O=FE_OFN72_i_reset_n_i I=FE_OFN37_i_reset_n_i
XFE_OFC70_i_reset_n_i BUF1 $PINS O=FE_OFN71_i_reset_n_i I=FE_OFN37_i_reset_n_i
XFE_OFC69_i_reset_n_i BUF1 $PINS O=FE_OFN70_i_reset_n_i I=FE_OFN35_i_reset_n_i
XFE_OFC68_i_reset_n_i BUF1 $PINS O=FE_OFN69_i_reset_n_i I=FE_OFN35_i_reset_n_i
XFE_OFC67_i_reset_n_i BUF1 $PINS O=FE_OFN68_i_reset_n_i I=FE_OFN34_i_reset_n_i
XFE_OFC66_i_reset_n_i BUF1 $PINS O=FE_OFN67_i_reset_n_i I=FE_OFN34_i_reset_n_i
XFE_OFC65_i_reset_n_i BUF1 $PINS O=FE_OFN66_i_reset_n_i I=FE_OFN34_i_reset_n_i
XFE_OFC64_i_reset_n_i BUF1 $PINS O=FE_OFN65_i_reset_n_i I=FE_OFN32_i_reset_n_i
XFE_OFC63_i_reset_n_i BUF1 $PINS O=FE_OFN64_i_reset_n_i I=FE_OFN32_i_reset_n_i
XFE_OFC62_i_reset_n_i BUF1 $PINS O=FE_OFN63_i_reset_n_i I=FE_OFN31_i_reset_n_i
XFE_OFC61_i_reset_n_i BUF1 $PINS O=FE_OFN62_i_reset_n_i I=FE_OFN31_i_reset_n_i
XFE_OFC60_i_reset_n_i BUF1 $PINS O=FE_OFN61_i_reset_n_i I=FE_OFN30_i_reset_n_i
XFE_OFC59_i_reset_n_i BUF1 $PINS O=FE_OFN60_i_reset_n_i I=FE_OFN29_i_reset_n_i
XFE_OFC57_i_reset_n_i BUF1 $PINS O=FE_OFN58_i_reset_n_i I=FE_OFN28_i_reset_n_i
XFE_OFC56_i_reset_n_i BUF1 $PINS O=FE_OFN57_i_reset_n_i I=FE_OFN27_i_reset_n_i
XFE_OFC55_i_reset_n_i BUF1 $PINS O=FE_OFN56_i_reset_n_i I=FE_OFN26_i_reset_n_i
XFE_OFC53_i_reset_n_i BUF1 $PINS O=FE_OFN54_i_reset_n_i I=FE_OFN25_i_reset_n_i
XFE_OFC52_i_reset_n_i BUF1 $PINS O=FE_OFN53_i_reset_n_i I=FE_OFN24_i_reset_n_i
XFE_OFC46_i_reset_n_i BUF1 $PINS O=FE_OFN47_i_reset_n_i I=FE_OFN19_i_reset_n_i
XFE_OFC45_i_reset_n_i BUF1 $PINS O=FE_OFN46_i_reset_n_i I=FE_OFN19_i_reset_n_i
XFE_OFC44_i_reset_n_i BUF1 $PINS O=FE_OFN45_i_reset_n_i I=FE_OFN18_i_reset_n_i
XFE_OFC43_i_reset_n_i BUF1 $PINS O=FE_OFN44_i_reset_n_i I=FE_OFN18_i_reset_n_i
XFE_OFC40_i_reset_n_i BUF1 $PINS O=FE_OFN41_i_reset_n_i I=FE_OFN16_i_reset_n_i
XFE_OFC39_i_reset_n_i BUF1 $PINS O=FE_OFN40_i_reset_n_i I=FE_OFN16_i_reset_n_i
XFE_OFC38_i_reset_n_i BUF1 $PINS O=FE_OFN39_i_reset_n_i I=FE_OFN15_i_reset_n_i
XFE_OFC36_i_reset_n_i BUF1 $PINS O=FE_OFN37_i_reset_n_i I=FE_OFN14_i_reset_n_i
XFE_OFC35_i_reset_n_i BUF1 $PINS O=FE_OFN36_i_reset_n_i I=FE_OFN14_i_reset_n_i
XFE_OFC34_i_reset_n_i BUF1 $PINS O=FE_OFN35_i_reset_n_i I=FE_OFN13_i_reset_n_i
XFE_OFC33_i_reset_n_i BUF1 $PINS O=FE_OFN34_i_reset_n_i I=FE_OFN12_i_reset_n_i
XFE_OFC32_i_reset_n_i BUF1 $PINS O=FE_OFN33_i_reset_n_i I=FE_OFN12_i_reset_n_i
XFE_OFC31_i_reset_n_i BUF1 $PINS O=FE_OFN32_i_reset_n_i I=FE_OFN11_i_reset_n_i
XFE_OFC30_i_reset_n_i BUF1 $PINS O=FE_OFN31_i_reset_n_i I=FE_OFN10_i_reset_n_i
XFE_OFC29_i_reset_n_i BUF1 $PINS O=FE_OFN30_i_reset_n_i I=FE_OFN10_i_reset_n_i
XFE_OFC28_i_reset_n_i BUF1 $PINS O=FE_OFN29_i_reset_n_i I=FE_OFN9_i_reset_n_i
XFE_OFC27_i_reset_n_i BUF1 $PINS O=FE_OFN28_i_reset_n_i I=FE_OFN9_i_reset_n_i
XFE_OFC26_i_reset_n_i INV1S $PINS O=FE_OFN27_i_reset_n_i I=FE_OFN8_i_reset_n_i
XFE_OFC25_i_reset_n_i INV1S $PINS O=FE_OFN26_i_reset_n_i I=FE_OFN8_i_reset_n_i
XFE_OFC24_i_reset_n_i INV1S $PINS O=FE_OFN25_i_reset_n_i I=FE_OFN8_i_reset_n_i
XFE_OFC23_i_reset_n_i INV1S $PINS O=FE_OFN24_i_reset_n_i I=FE_OFN8_i_reset_n_i
XFE_OFC21_i_reset_n_i BUF1 $PINS O=FE_OFN22_i_reset_n_i I=FE_OFN7_i_reset_n_i
XFE_OFC18_i_reset_n_i INV1S $PINS O=FE_OFN19_i_reset_n_i I=FE_OFN4_i_reset_n_i
XFE_OFC17_i_reset_n_i INV1S $PINS O=FE_OFN18_i_reset_n_i I=FE_OFN4_i_reset_n_i
XFE_OFC15_i_reset_n_i INV1S $PINS O=FE_OFN16_i_reset_n_i I=FE_OFN4_i_reset_n_i
XFE_OFC14_i_reset_n_i INV1S $PINS O=FE_OFN15_i_reset_n_i I=FE_OFN4_i_reset_n_i
XFE_OFC13_i_reset_n_i INV1S $PINS O=FE_OFN14_i_reset_n_i I=FE_OFN2_i_reset_n_i
XFE_OFC12_i_reset_n_i INV1S $PINS O=FE_OFN13_i_reset_n_i I=FE_OFN2_i_reset_n_i
XFE_OFC11_i_reset_n_i INV1S $PINS O=FE_OFN12_i_reset_n_i I=FE_OFN2_i_reset_n_i
XFE_OFC10_i_reset_n_i INV1S $PINS O=FE_OFN11_i_reset_n_i I=FE_OFN2_i_reset_n_i
XFE_OFC9_i_reset_n_i INV1S $PINS O=FE_OFN10_i_reset_n_i I=FE_OFN2_i_reset_n_i
XFE_OFC8_i_reset_n_i BUF1 $PINS O=FE_OFN9_i_reset_n_i I=FE_OFN1_i_reset_n_i
XFE_OFC7_i_reset_n_i INV1S $PINS O=FE_OFN8_i_reset_n_i I=FE_OFN1_i_reset_n_i
XFE_OFC6_i_reset_n_i INV1S $PINS O=FE_OFN7_i_reset_n_i I=FE_OFN0_i_reset_n_i
XFE_OFC4_i_reset_n_i BUF1 $PINS O=FE_OFN4_i_reset_n_i I=FE_OFN0_i_reset_n_i
XFE_OFC2_i_reset_n_i BUF1 $PINS O=FE_OFN2_i_reset_n_i I=FE_OFN0_i_reset_n_i
XFE_OFC1_i_reset_n_i INV1S $PINS O=FE_OFN1_i_reset_n_i I=FE_OFN0_i_reset_n_i
XFE_OFC0_i_reset_n_i INV1S $PINS O=FE_OFN0_i_reset_n_i I=rst_n
XFE_DBTC69_It_0_6 INV1S $PINS O=FE_DBTN69_It_0_6 I=It[0][6]
XFE_DBTC68_It_0_5 INV1S $PINS O=FE_DBTN68_It_0_5 I=It[0][5]
XFE_DBTC67_It_0_4 INV1S $PINS O=FE_DBTN67_It_0_4 I=It[0][4]
XFE_DBTC66_It_0_3 INV1S $PINS O=FE_DBTN66_It_0_3 I=It[0][3]
XFE_DBTC65_It_0_2 INV1S $PINS O=FE_DBTN65_It_0_2 I=It[0][2]
XFE_DBTC64_It_0_1 INV1S $PINS O=FE_DBTN64_It_0_1 I=It[0][1]
XFE_DBTC63_It_0_0 INV1S $PINS O=FE_DBTN63_It_0_0 I=It[0][0]
XFE_DBTC61_It_4_6 INV1S $PINS O=FE_DBTN61_It_4_6 I=It[4][6]
XFE_DBTC60_It_4_5 INV1S $PINS O=FE_DBTN60_It_4_5 I=It[4][5]
XFE_DBTC59_It_4_4 INV1S $PINS O=FE_DBTN59_It_4_4 I=It[4][4]
XFE_DBTC58_It_4_3 INV1S $PINS O=FE_DBTN58_It_4_3 I=It[4][3]
XFE_DBTC57_It_4_2 INV1S $PINS O=FE_DBTN57_It_4_2 I=It[4][2]
XFE_DBTC56_It_4_1 INV1S $PINS O=FE_DBTN56_It_4_1 I=It[4][1]
XFE_DBTC55_It_4_0 INV1S $PINS O=FE_DBTN55_It_4_0 I=It[4][0]
XFE_DBTC53_Ix_0_6 INV1S $PINS O=FE_DBTN53_Ix_0_6 I=Ix[0][6]
XFE_DBTC52_Ix_0_5 INV1S $PINS O=FE_DBTN52_Ix_0_5 I=Ix[0][5]
XFE_DBTC51_Ix_0_4 INV1S $PINS O=FE_DBTN51_Ix_0_4 I=Ix[0][4]
XFE_DBTC50_Ix_0_3 INV1S $PINS O=FE_DBTN50_Ix_0_3 I=Ix[0][3]
XFE_DBTC49_Ix_0_2 INV1S $PINS O=FE_DBTN49_Ix_0_2 I=Ix[0][2]
XFE_DBTC48_Ix_0_1 INV1S $PINS O=FE_DBTN48_Ix_0_1 I=Ix[0][1]
XFE_DBTC47_Ix_0_0 INV1S $PINS O=FE_DBTN47_Ix_0_0 I=Ix[0][0]
XFE_DBTC45_intadd_21_SUM_1 INV1S $PINS O=FE_DBTN45_intadd_21_SUM_1
+ I=intadd_21/SUM[1]
XFE_DBTC44_n4488 INV1S $PINS O=FE_DBTN44_n4488 I=FE_OFN1254_n4488
XFE_DBTC43_n4487 INV1S $PINS O=FE_DBTN43_n4487 I=FE_OFN1248_n4487
XFE_DBTC37_n4365 INV1S $PINS O=FE_DBTN37_n4365 I=FE_OFN527_n4365
XFE_DBTC35_n1689 INV1S $PINS O=FE_DBTN35_n1689 I=n1689
XFE_DBTC34_n2158 INV1S $PINS O=FE_DBTN34_n2158 I=n2158
XFE_DBTC33_shift_amount_reg_3 INV2 $PINS O=FE_DBTN33_shift_amount_reg_3
+ I=FE_OFN603_shift_amount_reg_3
XFE_DBTC32_div_pos_reg_3 INV1S $PINS O=FE_DBTN32_div_pos_reg_3
+ I=FE_OFN608_div_pos_reg_3
XFE_DBTC30_IxIy_shift_5 INV2 $PINS O=FE_DBTN30_IxIy_shift_5 I=IxIy_shift[5]
XFE_DBTC28_IxIt_shift_7 INV1S $PINS O=FE_DBTN28_IxIt_shift_7
+ I=FE_OFN1366_IxIt_shift_7
XFE_DBTC24_n2351 INV1S $PINS O=FE_DBTN24_n2351 I=n2351
XFE_DBTC22_IyIt_shift_15 INV1S $PINS O=FE_DBTN22_IyIt_shift_15
+ I=FE_OFN1126_IyIt_shift_15
XFE_DBTC19_n2355 INV1S $PINS O=FE_DBTN19_n2355 I=n2355
XFE_DBTC18_n1690 INV1S $PINS O=FE_DBTN18_n1690 I=n1690
XFE_DBTC15_n2359 INV1S $PINS O=FE_DBTN15_n2359 I=FE_OFN490_n2359
XFE_DBTC13_n4339 INV1S $PINS O=FE_DBTN13_n4339 I=n4339
XFE_DBTC11_n4099 INV1S $PINS O=FE_DBTN11_n4099 I=FE_OFN938_n4099
XFE_DBTC10_IxIy_shift_4 INV2 $PINS O=FE_DBTN10_IxIy_shift_4 I=IxIy_shift[4]
XFE_DBTC9_n2102 INV1S $PINS O=FE_DBTN9_n2102 I=n2102
XFE_DBTC5_div_pos_reg_1 INV1S $PINS O=FE_DBTN5_div_pos_reg_1
+ I=FE_OFN625_div_pos_reg_1
XFE_DBTC4_n1819 INV1S $PINS O=FE_DBTN4_n1819 I=n1819
XFE_DBTC3_div_pos_reg_4 INV1S $PINS O=FE_DBTN3_div_pos_reg_4 I=div_pos_reg[4]
XFE_DBTC1_n3943 INV1S $PINS O=FE_DBTN1_n3943 I=FE_OFN806_n3943
XFE_DBTC0_n4229 INV1S $PINS O=FE_DBTN0_n4229 I=n4229
Xa_reg_reg[7] QDFFRBN $PINS Q=FE_PHN3304_a_reg_7 D=a[7] CK=CTS_129
+ RB=FE_OFN217_i_reset_n_i
Ximg1_reg[13][7] QDFFRBN $PINS Q=img1[13][7] D=a_reg[7] CK=CTS_118
+ RB=FE_OFN157_i_reset_n_i
Ximg1_reg[12][7] QDFFRBN $PINS Q=img1[12][7] D=FE_PHN3003_img1_13_7 CK=CTS_118
+ RB=FE_OFN157_i_reset_n_i
Ximg1_reg[11][7] QDFFRBN $PINS Q=FE_PHN3047_img1_11_7 D=FE_PHN3131_img1_12_7
+ CK=CTS_118 RB=FE_OFN107_i_reset_n_i
Ximg1_reg[10][7] QDFFRBN $PINS Q=FE_PHN2966_img1_10_7 D=img1[11][7] CK=CTS_118
+ RB=FE_OFN107_i_reset_n_i
Ximg1_reg[9][7] QDFFRBN $PINS Q=img1[9][7] D=img1[10][7] CK=CTS_118
+ RB=FE_OFN157_i_reset_n_i
Ximg1_reg[8][7] QDFFRBN $PINS Q=FE_PHN3082_img1_8_7 D=FE_PHN2968_img1_9_7
+ CK=CTS_118 RB=FE_OFN157_i_reset_n_i
Ximg1_reg[7][7] QDFFRBN $PINS Q=img1[7][7] D=img1[8][7] CK=CTS_118
+ RB=FE_OFN205_i_reset_n_i
Ximg1_reg[6][7] QDFFRBN $PINS Q=img1[6][7] D=FE_PHN2947_img1_7_7 CK=CTS_115
+ RB=FE_OFN205_i_reset_n_i
Ximg1_reg[5][7] QDFFRBN $PINS Q=img1[5][7] D=FE_PHN3064_img1_6_7 CK=CTS_115
+ RB=FE_OFN206_i_reset_n_i
Ximg1_reg[4][7] QDFFRBN $PINS Q=img1[4][7] D=FE_PHN3120_img1_5_7 CK=CTS_118
+ RB=FE_OFN206_i_reset_n_i
Ximg1_reg[3][7] QDFFRBN $PINS Q=img1[3][7] D=FE_PHN2997_img1_4_7 CK=CTS_118
+ RB=FE_OFN238_i_reset_n_i
Ximg1_reg[2][7] QDFFRBN $PINS Q=img1[2][7] D=FE_PHN3001_img1_3_7 CK=CTS_118
+ RB=FE_OFN238_i_reset_n_i
Ximg1_reg[1][7] QDFFRBN $PINS Q=img1[1][7] D=FE_PHN3048_img1_2_7 CK=CTS_118
+ RB=FE_OFN238_i_reset_n_i
Xa_reg_reg[6] QDFFRBN $PINS Q=a_reg[6] D=a[6] CK=CTS_129
+ RB=FE_OFN217_i_reset_n_i
Ximg1_reg[13][6] QDFFRBN $PINS Q=img1[13][6] D=FE_PHN3285_a_reg_6 CK=CTS_118
+ RB=FE_OFN107_i_reset_n_i
Ximg1_reg[12][6] QDFFRBN $PINS Q=img1[12][6] D=FE_PHN3002_img1_13_6 CK=CTS_118
+ RB=FE_OFN67_i_reset_n_i
Ximg1_reg[11][6] QDFFRBN $PINS Q=img1[11][6] D=FE_PHN3127_img1_12_6 CK=CTS_118
+ RB=FE_OFN67_i_reset_n_i
Ximg1_reg[10][6] QDFFRBN $PINS Q=FE_PHN3057_img1_10_6 D=FE_PHN2954_img1_11_6
+ CK=CTS_118 RB=FE_OFN34_i_reset_n_i
Ximg1_reg[9][6] QDFFRBN $PINS Q=img1[9][6] D=img1[10][6] CK=CTS_118
+ RB=FE_OFN68_i_reset_n_i
Ximg1_reg[8][6] QDFFRBN $PINS Q=img1[8][6] D=FE_PHN2970_img1_9_6 CK=CTS_118
+ RB=FE_OFN68_i_reset_n_i
Ximg1_reg[7][6] QDFFRBN $PINS Q=img1[7][6] D=FE_PHN3100_img1_8_6 CK=CTS_118
+ RB=FE_OFN66_i_reset_n_i
Ximg1_reg[6][6] QDFFRBN $PINS Q=FE_PHN3039_img1_6_6 D=FE_PHN2969_img1_7_6
+ CK=CTS_118 RB=FE_OFN34_i_reset_n_i
Ximg1_reg[5][6] QDFFRBN $PINS Q=img1[5][6] D=img1[6][6] CK=CTS_118
+ RB=FE_OFN66_i_reset_n_i
Ximg1_reg[4][6] QDFFRBN $PINS Q=img1[4][6] D=FE_PHN3022_img1_5_6 CK=CTS_118
+ RB=FE_OFN68_i_reset_n_i
Ximg1_reg[3][6] QDFFRBN $PINS Q=img1[3][6] D=FE_PHN3076_img1_4_6 CK=CTS_118
+ RB=FE_OFN68_i_reset_n_i
Ximg1_reg[2][6] QDFFRBN $PINS Q=FE_PHN2998_img1_2_6 D=FE_PHN2979_img1_3_6
+ CK=CTS_118 RB=FE_OFN68_i_reset_n_i
Ximg1_reg[1][6] QDFFRBN $PINS Q=img1[1][6] D=img1[2][6] CK=CTS_118
+ RB=FE_OFN107_i_reset_n_i
Xa_reg_reg[5] QDFFRBN $PINS Q=a_reg[5] D=a[5] CK=CTS_129
+ RB=FE_OFN217_i_reset_n_i
Ximg1_reg[13][5] QDFFRBN $PINS Q=img1[13][5] D=FE_PHN3284_a_reg_5 CK=CTS_118
+ RB=FE_OFN66_i_reset_n_i
Ximg1_reg[12][5] QDFFRBN $PINS Q=img1[12][5] D=FE_PHN2980_img1_13_5 CK=CTS_118
+ RB=FE_OFN12_i_reset_n_i
Ximg1_reg[11][5] QDFFRBN $PINS Q=img1[11][5] D=FE_PHN3134_img1_12_5 CK=CTS_118
+ RB=FE_OFN34_i_reset_n_i
Ximg1_reg[10][5] QDFFRBN $PINS Q=FE_PHN3012_img1_10_5 D=FE_PHN3046_img1_11_5
+ CK=CTS_118 RB=FE_OFN66_i_reset_n_i
Ximg1_reg[9][5] QDFFRBN $PINS Q=img1[9][5] D=img1[10][5] CK=CTS_118
+ RB=FE_OFN66_i_reset_n_i
Ximg1_reg[8][5] QDFFRBN $PINS Q=FE_PHN3075_img1_8_5 D=FE_PHN2973_img1_9_5
+ CK=CTS_118 RB=FE_OFN253_i_reset_n_i
Ximg1_reg[7][5] QDFFRBN $PINS Q=img1[7][5] D=img1[8][5] CK=CTS_118
+ RB=FE_OFN253_i_reset_n_i
Ximg1_reg[6][5] QDFFRBN $PINS Q=img1[6][5] D=FE_PHN2981_img1_7_5 CK=CTS_118
+ RB=FE_OFN253_i_reset_n_i
Ximg1_reg[5][5] QDFFRBN $PINS Q=img1[5][5] D=FE_PHN2974_img1_6_5 CK=CTS_129
+ RB=FE_OFN253_i_reset_n_i
Ximg1_reg[4][5] QDFFRBN $PINS Q=FE_PHN3040_img1_4_5 D=FE_PHN3018_img1_5_5
+ CK=CTS_129 RB=FE_OFN253_i_reset_n_i
Ximg1_reg[3][5] QDFFRBN $PINS Q=FE_PHN2972_img1_3_5 D=img1[4][5] CK=CTS_118
+ RB=FE_OFN253_i_reset_n_i
Ximg1_reg[2][5] QDFFRBN $PINS Q=FE_PHN3113_img1_2_5 D=img1[3][5] CK=CTS_118
+ RB=FE_OFN218_i_reset_n_i
Ximg1_reg[1][5] QDFFRBN $PINS Q=img1[1][5] D=img1[2][5] CK=CTS_118
+ RB=FE_OFN12_i_reset_n_i
Xa_reg_reg[4] QDFFRBN $PINS Q=a_reg[4] D=a[4] CK=CTS_107
+ RB=FE_OFN73_i_reset_n_i
Ximg1_reg[13][4] QDFFRBN $PINS Q=img1[13][4] D=FE_OFN1641_a_reg_4 CK=CTS_118
+ RB=FE_OFN127_i_reset_n_i
Ximg1_reg[12][4] QDFFRBN $PINS Q=img1[12][4] D=FE_PHN3041_img1_13_4 CK=CTS_118
+ RB=FE_OFN127_i_reset_n_i
Ximg1_reg[11][4] QDFFRBN $PINS Q=img1[11][4] D=FE_PHN3138_img1_12_4 CK=CTS_129
+ RB=FE_OFN126_i_reset_n_i
Ximg1_reg[10][4] QDFFRBN $PINS Q=img1[10][4] D=FE_PHN2994_img1_11_4 CK=CTS_129
+ RB=FE_OFN126_i_reset_n_i
Ximg1_reg[9][4] QDFFRBN $PINS Q=img1[9][4] D=FE_PHN3025_img1_10_4 CK=CTS_129
+ RB=FE_OFN125_i_reset_n_i
Ximg1_reg[8][4] QDFFRBN $PINS Q=img1[8][4] D=FE_PHN3087_img1_9_4 CK=CTS_129
+ RB=FE_OFN125_i_reset_n_i
Ximg1_reg[7][4] QDFFRBN $PINS Q=FE_PHN3017_img1_7_4 D=FE_PHN2993_img1_8_4
+ CK=CTS_129 RB=FE_OFN174_i_reset_n_i
Ximg1_reg[6][4] QDFFRBN $PINS Q=FE_PHN3031_img1_6_4 D=img1[7][4] CK=CTS_129
+ RB=FE_OFN174_i_reset_n_i
Ximg1_reg[5][4] QDFFRBN $PINS Q=FE_PHN3074_img1_5_4 D=img1[6][4] CK=CTS_129
+ RB=FE_OFN174_i_reset_n_i
Ximg1_reg[4][4] QDFFRBN $PINS Q=img1[4][4] D=img1[5][4] CK=CTS_129
+ RB=FE_OFN174_i_reset_n_i
Ximg1_reg[3][4] QDFFRBN $PINS Q=img1[3][4] D=FE_PHN2985_img1_4_4 CK=CTS_129
+ RB=FE_OFN174_i_reset_n_i
Ximg1_reg[2][4] QDFFRBN $PINS Q=FE_PHN3110_img1_2_4 D=FE_PHN3058_img1_3_4
+ CK=CTS_129 RB=FE_OFN126_i_reset_n_i
Ximg1_reg[1][4] QDFFRBN $PINS Q=img1[1][4] D=img1[2][4] CK=CTS_118
+ RB=FE_OFN218_i_reset_n_i
Xa_reg_reg[3] QDFFRBN $PINS Q=a_reg[3] D=a[3] CK=CTS_107
+ RB=FE_OFN73_i_reset_n_i
Ximg1_reg[13][3] QDFFRBN $PINS Q=img1[13][3] D=FE_OFN1632_a_reg_3 CK=CTS_118
+ RB=FE_OFN218_i_reset_n_i
Ximg1_reg[12][3] QDFFRBN $PINS Q=img1[12][3] D=FE_PHN2967_img1_13_3 CK=CTS_118
+ RB=FE_OFN175_i_reset_n_i
Ximg1_reg[11][3] QDFFRBN $PINS Q=img1[11][3] D=FE_PHN3141_img1_12_3 CK=CTS_118
+ RB=FE_OFN218_i_reset_n_i
Ximg1_reg[10][3] QDFFRBN $PINS Q=img1[10][3] D=FE_PHN3049_img1_11_3 CK=CTS_129
+ RB=FE_OFN127_i_reset_n_i
Ximg1_reg[9][3] QDFFRBN $PINS Q=FE_PHN3051_img1_9_3 D=FE_PHN3052_img1_10_3
+ CK=CTS_129 RB=FE_OFN79_i_reset_n_i
Ximg1_reg[8][3] QDFFRBN $PINS Q=img1[8][3] D=img1[9][3] CK=CTS_129
+ RB=FE_OFN124_i_reset_n_i
Ximg1_reg[7][3] QDFFRBN $PINS Q=FE_PHN3016_img1_7_3 D=FE_PHN3043_img1_8_3
+ CK=CTS_129 RB=FE_OFN79_i_reset_n_i
Ximg1_reg[6][3] QDFFRBN $PINS Q=FE_PHN3023_img1_6_3 D=img1[7][3] CK=CTS_129
+ RB=FE_OFN45_i_reset_n_i
Ximg1_reg[5][3] QDFFRBN $PINS Q=img1[5][3] D=img1[6][3] CK=CTS_129
+ RB=FE_OFN45_i_reset_n_i
Ximg1_reg[4][3] QDFFRBN $PINS Q=FE_PHN3067_img1_4_3 D=FE_PHN3055_img1_5_3
+ CK=CTS_129 RB=FE_OFN124_i_reset_n_i
Ximg1_reg[3][3] QDFFRBN $PINS Q=img1[3][3] D=img1[4][3] CK=CTS_129
+ RB=FE_OFN124_i_reset_n_i
Ximg1_reg[2][3] QDFFRBN $PINS Q=img1[2][3] D=FE_PHN2977_img1_3_3 CK=CTS_129
+ RB=FE_OFN124_i_reset_n_i
Ximg1_reg[1][3] QDFFRBN $PINS Q=img1[1][3] D=FE_PHN3088_img1_2_3 CK=CTS_129
+ RB=FE_OFN127_i_reset_n_i
Ximg1_reg[13][2] QDFFRBN $PINS Q=img1[13][2] D=FE_OFN1604_a_reg_2 CK=CTS_118
+ RB=FE_OFN33_i_reset_n_i
Ximg1_reg[12][2] QDFFRBN $PINS Q=img1[12][2] D=FE_PHN3053_img1_13_2 CK=CTS_118
+ RB=FE_OFN33_i_reset_n_i
Ximg1_reg[11][2] QDFFRBN $PINS Q=img1[11][2] D=FE_PHN3132_img1_12_2 CK=CTS_118
+ RB=FE_OFN175_i_reset_n_i
Ximg1_reg[10][2] QDFFRBN $PINS Q=img1[10][2] D=FE_PHN3015_img1_11_2 CK=CTS_118
+ RB=FE_OFN175_i_reset_n_i
Ximg1_reg[9][2] QDFFRBN $PINS Q=img1[9][2] D=FE_PHN3044_img1_10_2 CK=CTS_129
+ RB=FE_OFN127_i_reset_n_i
Ximg1_reg[8][2] QDFFRBN $PINS Q=img1[8][2] D=FE_PHN3032_img1_9_2 CK=CTS_129
+ RB=FE_OFN254_i_reset_n_i
Ximg1_reg[7][2] QDFFRBN $PINS Q=FE_PHN3035_img1_7_2 D=FE_PHN3038_img1_8_2
+ CK=CTS_129 RB=FE_OFN254_i_reset_n_i
Ximg1_reg[6][2] QDFFRBN $PINS Q=img1[6][2] D=img1[7][2] CK=CTS_129
+ RB=FE_OFN254_i_reset_n_i
Ximg1_reg[5][2] QDFFRBN $PINS Q=img1[5][2] D=FE_PHN2989_img1_6_2 CK=CTS_129
+ RB=FE_OFN254_i_reset_n_i
Ximg1_reg[4][2] QDFFRBN $PINS Q=FE_PHN3029_img1_4_2 D=FE_PHN3061_img1_5_2
+ CK=CTS_129 RB=FE_OFN254_i_reset_n_i
Ximg1_reg[3][2] QDFFRBN $PINS Q=img1[3][2] D=img1[4][2] CK=CTS_129
+ RB=FE_OFN219_i_reset_n_i
Ximg1_reg[2][2] QDFFRBN $PINS Q=img1[2][2] D=FE_PHN2991_img1_3_2 CK=CTS_129
+ RB=FE_OFN219_i_reset_n_i
Ximg1_reg[1][2] QDFFRBN $PINS Q=FE_PHN3237_img1_1_2 D=FE_PHN3020_img1_2_2
+ CK=CTS_118 RB=FE_OFN220_i_reset_n_i
Ximg1_reg[0][2] QDFFRBN $PINS Q=img1[0][2] D=FE_PHN3300_img1_1_2 CK=CTS_118
+ RB=FE_OFN220_i_reset_n_i
Xa_reg_reg[1] QDFFRBN $PINS Q=a_reg[1] D=a[1] CK=CTS_131
+ RB=FE_OFN22_i_reset_n_i
Ximg1_reg[13][1] QDFFRBN $PINS Q=img1[13][1] D=FE_OFN1656_a_reg_1 CK=CTS_118
+ RB=FE_OFN33_i_reset_n_i
Ximg1_reg[12][1] QDFFRBN $PINS Q=img1[12][1] D=FE_PHN2963_img1_13_1 CK=CTS_118
+ RB=FE_OFN33_i_reset_n_i
Ximg1_reg[11][1] QDFFRBN $PINS Q=img1[11][1] D=FE_PHN3142_img1_12_1 CK=CTS_118
+ RB=FE_OFN220_i_reset_n_i
Ximg1_reg[10][1] QDFFRBN $PINS Q=img1[10][1] D=FE_PHN3063_img1_11_1 CK=CTS_118
+ RB=FE_OFN255_i_reset_n_i
Ximg1_reg[9][1] QDFFRBN $PINS Q=img1[9][1] D=FE_PHN3021_img1_10_1 CK=CTS_129
+ RB=FE_OFN219_i_reset_n_i
Ximg1_reg[8][1] QDFFRBN $PINS Q=img1[8][1] D=FE_PHN2990_img1_9_1 CK=CTS_129
+ RB=FE_OFN264_i_reset_n_i
Ximg1_reg[7][1] QDFFRBN $PINS Q=FE_PHN3050_img1_7_1 D=FE_PHN3028_img1_8_1
+ CK=CTS_129 RB=FE_OFN264_i_reset_n_i
Ximg1_reg[6][1] QDFFRBN $PINS Q=FE_PHN2992_img1_6_1 D=img1[7][1] CK=CTS_129
+ RB=FE_OFN264_i_reset_n_i
Ximg1_reg[5][1] QDFFRBN $PINS Q=FE_PHN3036_img1_5_1 D=img1[6][1] CK=CTS_129
+ RB=FE_OFN264_i_reset_n_i
Ximg1_reg[4][1] QDFFRBN $PINS Q=img1[4][1] D=img1[5][1] CK=CTS_127
+ RB=FE_OFN264_i_reset_n_i
Ximg1_reg[3][1] QDFFRBN $PINS Q=FE_PHN3070_img1_3_1 D=FE_PHN3019_img1_4_1
+ CK=CTS_129 RB=FE_OFN264_i_reset_n_i
Ximg1_reg[2][1] QDFFRBN $PINS Q=FE_PHN2996_img1_2_1 D=img1[3][1] CK=CTS_127
+ RB=FE_OFN255_i_reset_n_i
Ximg1_reg[1][1] QDFFRBN $PINS Q=FE_PHN3045_img1_1_1 D=img1[2][1] CK=CTS_118
+ RB=FE_OFN256_i_reset_n_i
Ximg1_reg[0][1] QDFFRBN $PINS Q=img1[0][1] D=img1[1][1] CK=CTS_127
+ RB=FE_OFN220_i_reset_n_i
Ximg1_reg[12][0] QDFFRBN $PINS Q=img1[12][0] D=img1[13][0] CK=CTS_127
+ RB=FE_OFN64_i_reset_n_i
Ximg1_reg[11][0] QDFFRBN $PINS Q=img1[11][0] D=FE_PHN3137_img1_12_0 CK=CTS_127
+ RB=FE_OFN256_i_reset_n_i
Ximg1_reg[10][0] QDFFRBN $PINS Q=FE_PHN3062_img1_10_0 D=FE_PHN2978_img1_11_0
+ CK=CTS_127 RB=FE_OFN256_i_reset_n_i
Ximg1_reg[9][0] QDFFRBN $PINS Q=img1[9][0] D=img1[10][0] CK=CTS_127
+ RB=FE_OFN256_i_reset_n_i
Ximg1_reg[8][0] QDFFRBN $PINS Q=img1[8][0] D=FE_PHN3081_img1_9_0 CK=CTS_129
+ RB=FE_OFN265_i_reset_n_i
Ximg1_reg[7][0] QDFFRBN $PINS Q=img1[7][0] D=FE_PHN2986_img1_8_0 CK=CTS_127
+ RB=FE_OFN265_i_reset_n_i
Ximg1_reg[6][0] QDFFRBN $PINS Q=FE_PHN3007_img1_6_0 D=FE_PHN3056_img1_7_0
+ CK=CTS_127 RB=FE_OFN265_i_reset_n_i
Ximg1_reg[5][0] QDFFRBN $PINS Q=img1[5][0] D=img1[6][0] CK=CTS_127
+ RB=FE_OFN265_i_reset_n_i
Ximg1_reg[4][0] QDFFRBN $PINS Q=FE_PHN3091_img1_4_0 D=FE_PHN3033_img1_5_0
+ CK=CTS_127 RB=FE_OFN256_i_reset_n_i
Ximg1_reg[3][0] QDFFRBN $PINS Q=img1[3][0] D=img1[4][0] CK=CTS_127
+ RB=FE_OFN11_i_reset_n_i
Ximg1_reg[2][0] QDFFRBN $PINS Q=FE_PHN3106_img1_2_0 D=FE_PHN3013_img1_3_0
+ CK=CTS_127 RB=FE_OFN11_i_reset_n_i
Ximg1_reg[1][0] QDFFRBN $PINS Q=FE_PHN2952_img1_1_0 D=img1[2][0] CK=CTS_119
+ RB=FE_OFN32_i_reset_n_i
Ximg1_reg[0][0] QDFFRBN $PINS Q=img1[0][0] D=img1[1][0] CK=CTS_127
+ RB=FE_OFN64_i_reset_n_i
XUy_reg_reg[32] QDFFRBN $PINS Q=Uy_pad_43 D=Uy[32] CK=CTS_110
+ RB=FE_OFN143_i_reset_n_i
XUy_reg_reg[30] QDFFRBN $PINS Q=Uy_pad[38] D=FE_PHN3266_Uy_30 CK=CTS_110
+ RB=FE_OFN192_i_reset_n_i
XUy_reg_reg[29] QDFFRBN $PINS Q=Uy_pad[37] D=FE_PHN3273_Uy_29 CK=CTS_110
+ RB=FE_OFN143_i_reset_n_i
XUy_reg_reg[28] QDFFRBN $PINS Q=Uy_pad[36] D=Uy[28] CK=CTS_110
+ RB=FE_OFN143_i_reset_n_i
XUy_reg_reg[27] QDFFRBN $PINS Q=Uy_pad[35] D=Uy[27] CK=CTS_110
+ RB=FE_OFN95_i_reset_n_i
XUy_reg_reg[26] QDFFRBN $PINS Q=Uy_pad[34] D=FE_PHN3265_Uy_26 CK=CTS_110
+ RB=FE_OFN261_i_reset_n_i
XUy_reg_reg[25] QDFFRBN $PINS Q=Uy_pad[33] D=Uy[25] CK=CTS_110
+ RB=FE_OFN95_i_reset_n_i
XUy_reg_reg[24] QDFFRBN $PINS Q=Uy_pad[32] D=Uy[24] CK=CTS_110
+ RB=FE_OFN95_i_reset_n_i
XUy_reg_reg[23] QDFFRBN $PINS Q=Uy_pad[31] D=Uy[23] CK=CTS_110
+ RB=FE_OFN94_i_reset_n_i
XUy_reg_reg[22] QDFFRBN $PINS Q=Uy_pad[30] D=Uy[22] CK=CTS_110
+ RB=FE_OFN94_i_reset_n_i
XUy_reg_reg[21] QDFFRBN $PINS Q=Uy_pad[29] D=Uy[21] CK=CTS_110
+ RB=FE_OFN57_i_reset_n_i
XUy_reg_reg[20] QDFFRBN $PINS Q=Uy_pad[28] D=Uy[20] CK=CTS_110
+ RB=FE_OFN57_i_reset_n_i
XUy_reg_reg[19] QDFFRBN $PINS Q=Uy_pad[27] D=Uy[19] CK=CTS_110
+ RB=FE_OFN57_i_reset_n_i
XUy_reg_reg[18] QDFFRBN $PINS Q=Uy_pad[26] D=Uy[18] CK=CTS_110
+ RB=FE_OFN27_i_reset_n_i
XUy_reg_reg[17] QDFFRBN $PINS Q=Uy_pad[25] D=Uy[17] CK=CTS_111
+ RB=FE_OFN27_i_reset_n_i
XUy_reg_reg[15] QDFFRBN $PINS Q=Uy_pad[23] D=Uy[15] CK=CTS_111
+ RB=FE_OFN93_i_reset_n_i
XUy_reg_reg[14] QDFFRBN $PINS Q=Uy_pad[22] D=Uy[14] CK=CTS_111
+ RB=FE_OFN93_i_reset_n_i
XUy_reg_reg[13] QDFFRBN $PINS Q=Uy_pad[21] D=Uy[13] CK=CTS_111
+ RB=FE_OFN186_i_reset_n_i
XUy_reg_reg[12] QDFFRBN $PINS Q=Uy_pad[20] D=Uy[12] CK=CTS_111
+ RB=FE_OFN27_i_reset_n_i
XUy_reg_reg[11] QDFFRBN $PINS Q=Uy_pad[19] D=Uy[11] CK=CTS_111
+ RB=FE_OFN186_i_reset_n_i
XUy_reg_reg[10] QDFFRBN $PINS Q=Uy_pad[18] D=Uy[10] CK=CTS_111
+ RB=FE_OFN183_i_reset_n_i
XUy_reg_reg[9] QDFFRBN $PINS Q=Uy_pad[17] D=Uy[9] CK=CTS_111
+ RB=FE_OFN183_i_reset_n_i
XUy_reg_reg[8] QDFFRBN $PINS Q=Uy_pad[16] D=Uy[8] CK=CTS_111
+ RB=FE_OFN183_i_reset_n_i
XUy_reg_reg[7] QDFFRBN $PINS Q=Uy_pad[15] D=Uy[7] CK=CTS_111
+ RB=FE_OFN182_i_reset_n_i
XUy_reg_reg[6] QDFFRBN $PINS Q=Uy_pad[14] D=Uy[6] CK=CTS_111
+ RB=FE_OFN182_i_reset_n_i
XUy_reg_reg[5] QDFFRBN $PINS Q=Uy_pad[13] D=Uy[5] CK=CTS_111
+ RB=FE_OFN183_i_reset_n_i
XUy_reg_reg[4] QDFFRBN $PINS Q=Uy_pad[12] D=Uy[4] CK=CTS_111
+ RB=FE_OFN182_i_reset_n_i
XUy_reg_reg[3] QDFFRBN $PINS Q=Uy_pad[11] D=Uy[3] CK=CTS_111
+ RB=FE_OFN136_i_reset_n_i
XUy_reg_reg[2] QDFFRBN $PINS Q=Uy_pad[10] D=Uy[2] CK=CTS_111
+ RB=FE_OFN136_i_reset_n_i
XUy_reg_reg[0] QDFFRBN $PINS Q=Uy_pad[8] D=FE_PHN3203_Uy_0 CK=CTS_111
+ RB=FE_OFN136_i_reset_n_i
Xb_reg_reg[7] QDFFRBN $PINS Q=b_reg[7] D=b[7] CK=CTS_115
+ RB=FE_OFN242_i_reset_n_i
Xb_reg_reg[6] QDFFRBN $PINS Q=b_reg[6] D=b[6] CK=CTS_114
+ RB=FE_OFN242_i_reset_n_i
Xb_reg_reg[5] QDFFRBN $PINS Q=b_reg[5] D=b[5] CK=CTS_115
+ RB=FE_OFN243_i_reset_n_i
Xb_reg_reg[4] QDFFRBN $PINS Q=b_reg[4] D=b[4] CK=CTS_115
+ RB=FE_OFN243_i_reset_n_i
Xb_reg_reg[3] QDFFRBN $PINS Q=b_reg[3] D=b[3] CK=CTS_115
+ RB=FE_OFN161_i_reset_n_i
Xb_reg_reg[2] QDFFRBN $PINS Q=b_reg[2] D=b[2] CK=CTS_115
+ RB=FE_OFN14_i_reset_n_i
Xb_reg_reg[1] QDFFRBN $PINS Q=b_reg[1] D=b[1] CK=CTS_115
+ RB=FE_OFN240_i_reset_n_i
Xb_reg_reg[0] QDFFRBN $PINS Q=b_reg[0] D=b[0] CK=CTS_115
+ RB=FE_OFN205_i_reset_n_i
XUx_reg_reg[32] QDFFRBN $PINS Q=Ux_pad_43 D=Ux[32] CK=CTS_106
+ RB=FE_OFN150_i_reset_n_i
XUx_reg_reg[31] QDFFRBN $PINS Q=Ux_pad[39] D=Ux[31] CK=CTS_106
+ RB=FE_OFN150_i_reset_n_i
XUx_reg_reg[30] QDFFRBN $PINS Q=Ux_pad[38] D=Ux[30] CK=CTS_106
+ RB=FE_OFN195_i_reset_n_i
XUx_reg_reg[29] QDFFRBN $PINS Q=Ux_pad[37] D=Ux[29] CK=CTS_106
+ RB=FE_OFN150_i_reset_n_i
XUx_reg_reg[28] QDFFRBN $PINS Q=Ux_pad[36] D=Ux[28] CK=CTS_106
+ RB=FE_OFN151_i_reset_n_i
XUx_reg_reg[26] QDFFRBN $PINS Q=Ux_pad[34] D=FE_PHN3256_Ux_26 CK=CTS_106
+ RB=FE_OFN151_i_reset_n_i
XUx_reg_reg[25] QDFFRBN $PINS Q=Ux_pad[33] D=Ux[25] CK=CTS_106
+ RB=FE_OFN196_i_reset_n_i
XUx_reg_reg[24] QDFFRBN $PINS Q=Ux_pad[32] D=FE_PHN3257_Ux_24 CK=CTS_106
+ RB=FE_OFN196_i_reset_n_i
XUx_reg_reg[23] QDFFRBN $PINS Q=Ux_pad[31] D=Ux[23] CK=CTS_106
+ RB=FE_OFN196_i_reset_n_i
XUx_reg_reg[22] QDFFRBN $PINS Q=Ux_pad[30] D=Ux[22] CK=CTS_106
+ RB=FE_OFN196_i_reset_n_i
XUx_reg_reg[21] QDFFRBN $PINS Q=Ux_pad[29] D=Ux[21] CK=CTS_106
+ RB=FE_OFN196_i_reset_n_i
XUx_reg_reg[20] QDFFRBN $PINS Q=Ux_pad[28] D=Ux[20] CK=CTS_106
+ RB=FE_OFN196_i_reset_n_i
XUx_reg_reg[19] QDFFRBN $PINS Q=Ux_pad[27] D=Ux[19] CK=CTS_106
+ RB=FE_OFN60_i_reset_n_i
XUx_reg_reg[18] QDFFRBN $PINS Q=Ux_pad[26] D=Ux[18] CK=CTS_106
+ RB=FE_OFN147_i_reset_n_i
XUx_reg_reg[17] QDFFRBN $PINS Q=Ux_pad[25] D=Ux[17] CK=CTS_106
+ RB=FE_OFN147_i_reset_n_i
XUx_reg_reg[16] QDFFRBN $PINS Q=Ux_pad[24] D=Ux[16] CK=CTS_106
+ RB=FE_OFN147_i_reset_n_i
XUx_reg_reg[15] QDFFRBN $PINS Q=Ux_pad[23] D=Ux[15] CK=CTS_106
+ RB=FE_OFN147_i_reset_n_i
XUx_reg_reg[14] QDFFRBN $PINS Q=Ux_pad[22] D=Ux[14] CK=CTS_109
+ RB=FE_OFN147_i_reset_n_i
XUx_reg_reg[13] QDFFRBN $PINS Q=Ux_pad[21] D=Ux[13] CK=CTS_109
+ RB=FE_OFN194_i_reset_n_i
XUx_reg_reg[11] QDFFRBN $PINS Q=Ux_pad[19] D=Ux[11] CK=CTS_109
+ RB=FE_OFN194_i_reset_n_i
XUx_reg_reg[10] QDFFRBN $PINS Q=Ux_pad[18] D=Ux[10] CK=CTS_109
+ RB=FE_OFN194_i_reset_n_i
XUx_reg_reg[9] QDFFRBN $PINS Q=Ux_pad[17] D=Ux[9] CK=CTS_109
+ RB=FE_OFN194_i_reset_n_i
XUx_reg_reg[8] QDFFRBN $PINS Q=Ux_pad[16] D=Ux[8] CK=CTS_109
+ RB=FE_OFN194_i_reset_n_i
XUx_reg_reg[7] QDFFRBN $PINS Q=Ux_pad[15] D=Ux[7] CK=CTS_109
+ RB=FE_OFN89_i_reset_n_i
XUx_reg_reg[6] QDFFRBN $PINS Q=Ux_pad[14] D=Ux[6] CK=CTS_109
+ RB=FE_OFN89_i_reset_n_i
XUx_reg_reg[5] QDFFRBN $PINS Q=Ux_pad[13] D=Ux[5] CK=CTS_109
+ RB=FE_OFN25_i_reset_n_i
XUx_reg_reg[4] QDFFRBN $PINS Q=Ux_pad[12] D=Ux[4] CK=CTS_109
+ RB=FE_OFN25_i_reset_n_i
XUx_reg_reg[3] QDFFRBN $PINS Q=Ux_pad[11] D=Ux[3] CK=CTS_109
+ RB=FE_OFN25_i_reset_n_i
XUx_reg_reg[2] QDFFRBN $PINS Q=Ux_pad[10] D=Ux[2] CK=CTS_109
+ RB=FE_OFN25_i_reset_n_i
XUx_reg_reg[1] QDFFRBN $PINS Q=Ux_pad[9] D=Ux[1] CK=CTS_111
+ RB=FE_OFN89_i_reset_n_i
XUx_reg_reg[0] QDFFRBN $PINS Q=Ux_pad[8] D=FE_PHN3183_Ux_0 CK=CTS_109
+ RB=FE_OFN25_i_reset_n_i
Xdiv_pos_reg_reg[2] QDFFRBN $PINS Q=div_pos_reg[2] D=div_pos[2] CK=CTS_107
+ RB=FE_OFN97_i_reset_n_i
Xdiv_pos_reg_reg[1] QDFFRBN $PINS Q=div_pos_reg[1] D=div_pos[1] CK=CTS_107
+ RB=FE_OFN58_i_reset_n_i
Xcol_reg_reg[3] QDFFRBN $PINS Q=col_reg[3] D=N593 CK=CTS_124
+ RB=FE_OFN103_i_reset_n_i
XIt_reg[4][0] QDFFRBN $PINS Q=It[4][0] D=n1254 CK=CTS_115
+ RB=FE_OFN239_i_reset_n_i
XIt_reg[4][1] QDFFRBN $PINS Q=It[4][1] D=n1253 CK=CTS_115
+ RB=FE_OFN240_i_reset_n_i
XIt_reg[4][2] QDFFRBN $PINS Q=It[4][2] D=n1252 CK=CTS_115
+ RB=FE_OFN240_i_reset_n_i
XIt_reg[4][3] QDFFRBN $PINS Q=It[4][3] D=n1251 CK=CTS_115
+ RB=FE_OFN240_i_reset_n_i
XIt_reg[4][4] QDFFRBN $PINS Q=It[4][4] D=n1250 CK=CTS_115
+ RB=FE_OFN240_i_reset_n_i
XIt_reg[4][5] QDFFRBN $PINS Q=It[4][5] D=n1249 CK=CTS_115
+ RB=FE_OFN240_i_reset_n_i
XIt_reg[4][6] QDFFRBN $PINS Q=It[4][6] D=n1248 CK=CTS_115
+ RB=FE_OFN206_i_reset_n_i
XIt_reg[4][7] QDFFRBN $PINS Q=It[4][7] D=n1247 CK=CTS_115
+ RB=FE_OFN239_i_reset_n_i
XIt_reg[4][8] QDFFRBN $PINS Q=It[4][8] D=n1246 CK=CTS_115
+ RB=FE_OFN239_i_reset_n_i
XIt_reg[3][0] QDFFRBN $PINS Q=It[3][0] D=n1245 CK=CTS_115
+ RB=FE_OFN72_i_reset_n_i
XIt_reg[3][1] QDFFRBN $PINS Q=FE_PHN3180_It_3_1 D=n1244 CK=CTS_115
+ RB=FE_OFN72_i_reset_n_i
XIt_reg[3][2] QDFFRBN $PINS Q=It[3][2] D=n1243 CK=CTS_115
+ RB=FE_OFN36_i_reset_n_i
XIt_reg[3][3] QDFFRBN $PINS Q=FE_PHN3188_It_3_3 D=n1242 CK=CTS_115
+ RB=FE_OFN161_i_reset_n_i
XIt_reg[3][5] QDFFRBN $PINS Q=FE_PHN3192_It_3_5 D=n1240 CK=CTS_115
+ RB=FE_OFN14_i_reset_n_i
XIt_reg[3][6] QDFFRBN $PINS Q=FE_PHN3162_It_3_6 D=n1239 CK=CTS_115
+ RB=FE_OFN14_i_reset_n_i
XIt_reg[3][7] QDFFRBN $PINS Q=FE_PHN3169_It_3_7 D=n1238 CK=CTS_115
+ RB=FE_OFN37_i_reset_n_i
XIt_reg[3][8] QDFFRBN $PINS Q=It[3][8] D=n1237 CK=CTS_115
+ RB=FE_OFN37_i_reset_n_i
XIt_reg[2][0] QDFFRBN $PINS Q=FE_PHN3145_It_2_0 D=n1236 CK=CTS_115
+ RB=FE_OFN72_i_reset_n_i
XIt_reg[2][1] QDFFRBN $PINS Q=FE_PHN3201_It_2_1 D=n1235 CK=CTS_115
+ RB=FE_OFN112_i_reset_n_i
XIt_reg[2][2] QDFFRBN $PINS Q=FE_PHN3174_It_2_2 D=n1234 CK=CTS_115
+ RB=FE_OFN161_i_reset_n_i
XIt_reg[2][3] QDFFRBN $PINS Q=FE_PHN3172_It_2_3 D=n1233 CK=CTS_115
+ RB=FE_OFN161_i_reset_n_i
XIt_reg[2][4] QDFFRBN $PINS Q=FE_PHN3173_It_2_4 D=n1232 CK=CTS_115
+ RB=FE_OFN112_i_reset_n_i
XIt_reg[2][5] QDFFRBN $PINS Q=FE_PHN3166_It_2_5 D=n1231 CK=CTS_115
+ RB=FE_OFN36_i_reset_n_i
XIt_reg[2][6] QDFFRBN $PINS Q=FE_PHN3167_It_2_6 D=n1230 CK=CTS_115
+ RB=FE_OFN36_i_reset_n_i
XIt_reg[2][7] QDFFRBN $PINS Q=It[2][7] D=n1229 CK=CTS_115
+ RB=FE_OFN72_i_reset_n_i
XIt_reg[2][8] QDFFRBN $PINS Q=It[2][8] D=n1228 CK=CTS_115
+ RB=FE_OFN37_i_reset_n_i
XIt_reg[1][0] QDFFRBN $PINS Q=It[1][0] D=n1227 CK=CTS_115
+ RB=FE_OFN113_i_reset_n_i
XIt_reg[1][2] QDFFRBN $PINS Q=FE_PHN3144_It_1_2 D=n1225 CK=CTS_115
+ RB=FE_OFN113_i_reset_n_i
XIt_reg[1][3] QDFFRBN $PINS Q=It[1][3] D=n1224 CK=CTS_115
+ RB=FE_OFN161_i_reset_n_i
XIt_reg[1][4] QDFFRBN $PINS Q=FE_PHN3161_It_1_4 D=n1223 CK=CTS_115
+ RB=FE_OFN113_i_reset_n_i
XIt_reg[1][5] QDFFRBN $PINS Q=FE_PHN3196_It_1_5 D=n1222 CK=CTS_115
+ RB=FE_OFN37_i_reset_n_i
XIt_reg[1][6] QDFFRBN $PINS Q=FE_PHN3221_It_1_6 D=n1221 CK=CTS_115
+ RB=FE_OFN112_i_reset_n_i
XIt_reg[1][7] QDFFRBN $PINS Q=FE_PHN3215_It_1_7 D=n1220 CK=CTS_115
+ RB=FE_OFN71_i_reset_n_i
XIt_reg[1][8] QDFFRBN $PINS Q=FE_PHN3207_It_1_8 D=n1219 CK=CTS_115
+ RB=FE_OFN71_i_reset_n_i
XIt_reg[0][0] QDFFRBN $PINS Q=It[0][0] D=n1218 CK=CTS_120
+ RB=FE_OFN109_i_reset_n_i
XIt_reg[0][1] QDFFRBN $PINS Q=It[0][1] D=n1217 CK=CTS_115
+ RB=FE_OFN163_i_reset_n_i
XIt_reg[0][2] QDFFRBN $PINS Q=It[0][2] D=n1216 CK=CTS_115
+ RB=FE_OFN113_i_reset_n_i
XIt_reg[0][3] QDFFRBN $PINS Q=It[0][3] D=n1215 CK=CTS_115
+ RB=FE_OFN163_i_reset_n_i
XIt_reg[0][4] QDFFRBN $PINS Q=It[0][4] D=n1214 CK=CTS_115
+ RB=FE_OFN113_i_reset_n_i
XIt_reg[0][5] QDFFRBN $PINS Q=It[0][5] D=n1213 CK=CTS_115
+ RB=FE_OFN71_i_reset_n_i
XIt_reg[0][6] QDFFRBN $PINS Q=It[0][6] D=n1212 CK=CTS_120
+ RB=FE_OFN71_i_reset_n_i
XIt_reg[0][8] QDFFRBN $PINS Q=It[0][8] D=n1210 CK=CTS_120
+ RB=FE_OFN13_i_reset_n_i
Xstart_valid_reg QDFFRBN $PINS Q=start_valid D=n1255 CK=CTS_124
+ RB=FE_OFN154_i_reset_n_i
XIx2_reg[0] QDFFRBN $PINS Q=Ix2[0] D=n1209 CK=CTS_119 RB=FE_OFN156_i_reset_n_i
XIx2_reg[1] QDFFRBN $PINS Q=Ix2[1] D=n1208 CK=CTS_119 RB=FE_OFN106_i_reset_n_i
XIx2_reg[2] QDFFRBN $PINS Q=Ix2[2] D=n1207 CK=CTS_119 RB=FE_OFN106_i_reset_n_i
XIx2_reg[15] QDFFRBN $PINS Q=Ix2[15] D=n1194 CK=CTS_119
+ RB=FE_OFN106_i_reset_n_i
XIx2_reg[16] QDFFRBN $PINS Q=Ix2[16] D=n1193 CK=CTS_119
+ RB=FE_OFN202_i_reset_n_i
XIx2_reg[17] QDFFRBN $PINS Q=Ix2[17] D=n1192 CK=CTS_119
+ RB=FE_OFN202_i_reset_n_i
XIx2_reg[18] QDFFRBN $PINS Q=Ix2[18] D=n1191 CK=CTS_119
+ RB=FE_OFN234_i_reset_n_i
XIx2_reg[19] QDFFRBN $PINS Q=Ix2[19] D=n1190 CK=CTS_119
+ RB=FE_OFN234_i_reset_n_i
XIx2_reg[20] QDFFRBN $PINS Q=Ix2[20] D=n1189 CK=CTS_119
+ RB=FE_OFN234_i_reset_n_i
XIx2_reg[22] QDFFRBN $PINS Q=Ix2[22] D=n1187 CK=CTS_119
+ RB=FE_OFN234_i_reset_n_i
XIxIt_reg[0] QDFFRBN $PINS Q=IxIt[0] D=FE_PHN3298_n1186 CK=CTS_120
+ RB=FE_OFN204_i_reset_n_i
XIxIt_reg[1] QDFFRBN $PINS Q=IxIt[1] D=n1185 CK=CTS_120
+ RB=FE_OFN235_i_reset_n_i
XIxIt_reg[3] QDFFRBN $PINS Q=IxIt[3] D=n1183 CK=CTS_120 RB=FE_OFN13_i_reset_n_i
XIxIt_reg[4] QDFFRBN $PINS Q=IxIt[4] D=n1182 CK=CTS_120
+ RB=FE_OFN235_i_reset_n_i
XIxIt_reg[5] QDFFRBN $PINS Q=IxIt[5] D=n1181 CK=CTS_120
+ RB=FE_OFN237_i_reset_n_i
XIxIt_reg[6] QDFFRBN $PINS Q=IxIt[6] D=n1180 CK=CTS_120
+ RB=FE_OFN237_i_reset_n_i
XIxIt_reg[7] QDFFRBN $PINS Q=IxIt[7] D=n1179 CK=CTS_120
+ RB=FE_OFN237_i_reset_n_i
XIxIt_reg[9] QDFFRBN $PINS Q=IxIt[9] D=n1177 CK=CTS_120
+ RB=FE_OFN204_i_reset_n_i
XIxIt_reg[10] QDFFRBN $PINS Q=IxIt[10] D=n1176 CK=CTS_120
+ RB=FE_OFN237_i_reset_n_i
XIxIt_reg[11] QDFFRBN $PINS Q=IxIt[11] D=n1175 CK=CTS_120
+ RB=FE_OFN236_i_reset_n_i
XIxIt_reg[12] QDFFRBN $PINS Q=IxIt[12] D=n1174 CK=CTS_119
+ RB=FE_OFN236_i_reset_n_i
XIxIt_reg[13] QDFFRBN $PINS Q=IxIt[13] D=n1173 CK=CTS_120
+ RB=FE_OFN236_i_reset_n_i
XIxIt_reg[14] QDFFRBN $PINS Q=IxIt[14] D=n1172 CK=CTS_119
+ RB=FE_OFN236_i_reset_n_i
XIxIt_reg[15] QDFFRBN $PINS Q=IxIt[15] D=n1171 CK=CTS_120
+ RB=FE_OFN204_i_reset_n_i
XIxIt_reg[16] QDFFRBN $PINS Q=IxIt[16] D=n1170 CK=CTS_120
+ RB=FE_OFN156_i_reset_n_i
XIxIt_reg[19] QDFFRBN $PINS Q=IxIt[19] D=n1167 CK=CTS_119
+ RB=FE_OFN155_i_reset_n_i
XIy2_reg[0] QDFFRBN $PINS Q=Iy2[0] D=n1163 CK=CTS_120 RB=FE_OFN69_i_reset_n_i
XIy2_reg[1] QDFFRBN $PINS Q=Iy2[1] D=n1162 CK=CTS_120 RB=FE_OFN35_i_reset_n_i
XIy2_reg[2] QDFFRBN $PINS Q=Iy2[2] D=n1161 CK=CTS_120 RB=FE_OFN235_i_reset_n_i
XIy2_reg[15] QDFFRBN $PINS Q=Iy2[15] D=n1148 CK=CTS_124
+ RB=FE_OFN102_i_reset_n_i
XIy2_reg[16] QDFFRBN $PINS Q=Iy2[16] D=n1147 CK=CTS_124 RB=FE_OFN31_i_reset_n_i
XIy2_reg[17] QDFFRBN $PINS Q=Iy2[17] D=n1146 CK=CTS_124 RB=FE_OFN31_i_reset_n_i
XIy2_reg[18] QDFFRBN $PINS Q=Iy2[18] D=n1145 CK=CTS_124 RB=FE_OFN10_i_reset_n_i
XIy2_reg[19] QDFFRBN $PINS Q=Iy2[19] D=n1144 CK=CTS_119 RB=FE_OFN30_i_reset_n_i
XIy2_reg[20] QDFFRBN $PINS Q=FE_PHN3288_Iy2_20 D=n1143 CK=CTS_119
+ RB=FE_OFN30_i_reset_n_i
XIy2_reg[22] QDFFRBN $PINS Q=Iy2[22] D=n1141 CK=CTS_119 RB=FE_OFN61_i_reset_n_i
XIxIy_reg[0] QDFFRBN $PINS Q=IxIy[0] D=n1140 CK=CTS_114
+ RB=FE_OFN158_i_reset_n_i
XIxIy_reg[1] QDFFRBN $PINS Q=IxIy[1] D=n1139 CK=CTS_114
+ RB=FE_OFN158_i_reset_n_i
XIxIy_reg[2] QDFFRBN $PINS Q=IxIy[2] D=n1138 CK=CTS_114
+ RB=FE_OFN158_i_reset_n_i
XIxIy_reg[3] QDFFRBN $PINS Q=IxIy[3] D=n1137 CK=CTS_114
+ RB=FE_OFN158_i_reset_n_i
XIxIy_reg[4] QDFFRBN $PINS Q=IxIy[4] D=n1136 CK=CTS_114
+ RB=FE_OFN158_i_reset_n_i
XIxIy_reg[5] QDFFRBN $PINS Q=IxIy[5] D=n1135 CK=CTS_114
+ RB=FE_OFN207_i_reset_n_i
XIxIy_reg[7] QDFFRBN $PINS Q=IxIy[7] D=n1133 CK=CTS_124
+ RB=FE_OFN153_i_reset_n_i
XIxIy_reg[9] QDFFRBN $PINS Q=IxIy[9] D=n1131 CK=CTS_124
+ RB=FE_OFN153_i_reset_n_i
XIxIy_reg[10] QDFFRBN $PINS Q=IxIy[10] D=n1130 CK=CTS_124
+ RB=FE_OFN153_i_reset_n_i
XIxIy_reg[11] QDFFRBN $PINS Q=IxIy[11] D=n1129 CK=CTS_124
+ RB=FE_OFN104_i_reset_n_i
XIxIy_reg[12] QDFFRBN $PINS Q=IxIy[12] D=n1128 CK=CTS_124
+ RB=FE_OFN104_i_reset_n_i
XIxIy_reg[13] QDFFRBN $PINS Q=IxIy[13] D=n1127 CK=CTS_124
+ RB=FE_OFN63_i_reset_n_i
XIxIy_reg[14] QDFFRBN $PINS Q=IxIy[14] D=n1126 CK=CTS_124
+ RB=FE_OFN63_i_reset_n_i
XIxIy_reg[15] QDFFRBN $PINS Q=IxIy[15] D=n1125 CK=CTS_124
+ RB=FE_OFN63_i_reset_n_i
XIxIy_reg[16] QDFFRBN $PINS Q=IxIy[16] D=n1124 CK=CTS_124
+ RB=FE_OFN102_i_reset_n_i
XIxIy_reg[17] QDFFRBN $PINS Q=IxIy[17] D=n1123 CK=CTS_124
+ RB=FE_OFN102_i_reset_n_i
XIxIy_reg[18] QDFFRBN $PINS Q=IxIy[18] D=n1122 CK=CTS_124
+ RB=FE_OFN31_i_reset_n_i
XIxIy_reg[19] QDFFRBN $PINS Q=IxIy[19] D=n1121 CK=CTS_119
+ RB=FE_OFN10_i_reset_n_i
XIxIy_reg[21] QDFFRBN $PINS Q=IxIy[21] D=n1119 CK=CTS_119
+ RB=FE_OFN100_i_reset_n_i
XIyIt_reg[1] QDFFRBN $PINS Q=IyIt[1] D=n1116 CK=CTS_114
+ RB=FE_OFN111_i_reset_n_i
XIyIt_reg[2] QDFFRBN $PINS Q=IyIt[2] D=n1115 CK=CTS_114
+ RB=FE_OFN111_i_reset_n_i
XIyIt_reg[3] QDFFRBN $PINS Q=IyIt[3] D=n1114 CK=CTS_120
+ RB=FE_OFN109_i_reset_n_i
XIyIt_reg[4] QDFFRBN $PINS Q=IyIt[4] D=n1113 CK=CTS_120
+ RB=FE_OFN109_i_reset_n_i
XIyIt_reg[5] QDFFRBN $PINS Q=IyIt[5] D=n1112 CK=CTS_120
+ RB=FE_OFN109_i_reset_n_i
XIyIt_reg[6] QDFFRBN $PINS Q=IyIt[6] D=n1111 CK=CTS_120
+ RB=FE_OFN109_i_reset_n_i
XIyIt_reg[8] QDFFRBN $PINS Q=IyIt[8] D=n1109 CK=CTS_120 RB=FE_OFN70_i_reset_n_i
XIyIt_reg[9] QDFFRBN $PINS Q=FE_PHN3286_IyIt_9 D=n1108 CK=CTS_120
+ RB=FE_OFN110_i_reset_n_i
XIyIt_reg[10] QDFFRBN $PINS Q=IyIt[10] D=n1107 CK=CTS_120
+ RB=FE_OFN69_i_reset_n_i
XIyIt_reg[11] QDFFRBN $PINS Q=IyIt[11] D=n1106 CK=CTS_120
+ RB=FE_OFN35_i_reset_n_i
XIyIt_reg[12] QDFFRBN $PINS Q=IyIt[12] D=n1105 CK=CTS_120
+ RB=FE_OFN35_i_reset_n_i
XIyIt_reg[13] QDFFRBN $PINS Q=IyIt[13] D=n1104 CK=CTS_120
+ RB=FE_OFN35_i_reset_n_i
XIyIt_reg[14] QDFFRBN $PINS Q=IyIt[14] D=n1103 CK=CTS_120
+ RB=FE_OFN13_i_reset_n_i
XIyIt_reg[15] QDFFRBN $PINS Q=IyIt[15] D=n1102 CK=CTS_120
+ RB=FE_OFN203_i_reset_n_i
XIyIt_reg[17] QDFFRBN $PINS Q=IyIt[17] D=n1100 CK=CTS_120
+ RB=FE_OFN156_i_reset_n_i
XIyIt_reg[18] QDFFRBN $PINS Q=IyIt[18] D=n1099 CK=CTS_119
+ RB=FE_OFN202_i_reset_n_i
XIyIt_reg[19] QDFFRBN $PINS Q=IyIt[19] D=n1098 CK=CTS_119
+ RB=FE_OFN234_i_reset_n_i
XIyIt_reg[20] QDFFRBN $PINS Q=IyIt[20] D=n1097 CK=CTS_119
+ RB=FE_OFN30_i_reset_n_i
XIyIt_reg[21] QDFFRBN $PINS Q=IyIt[21] D=n1096 CK=CTS_119
+ RB=FE_OFN10_i_reset_n_i
Xmul_pos_buffer_reg[0] QDFFRBN $PINS Q=mul_pos_buffer[0] D=n1093 CK=CTS_124
+ RB=FE_OFN31_i_reset_n_i
Xmul_pos_buffer_reg[1] QDFFRBN $PINS Q=mul_pos_buffer[1] D=n1094 CK=CTS_124
+ RB=FE_OFN103_i_reset_n_i
Xmul_pos_buffer_reg[2] QDFFRBN $PINS Q=mul_pos_buffer[2] D=n1092 CK=CTS_124
+ RB=FE_OFN103_i_reset_n_i
Xmul_pos_buffer_reg[3] QDFFRBN $PINS Q=mul_pos_buffer[3] D=n1091 CK=CTS_124
+ RB=FE_OFN103_i_reset_n_i
Xmul_pos_buffer_reg[4] QDFFRBN $PINS Q=mul_pos_buffer[4] D=n1090 CK=CTS_124
+ RB=FE_OFN103_i_reset_n_i
Xvalid_reg QDFFRBN $PINS Q=valid D=n1256 CK=CTS_124 RB=FE_OFN154_i_reset_n_i
XVout_reg[0] QDFFRBN $PINS Q=Vout[0] D=n1089 CK=CTS_110
+ RB=FE_OFN137_i_reset_n_i
XVout_reg[1] QDFFRBN $PINS Q=Vout[1] D=n1088 CK=CTS_110
+ RB=FE_OFN137_i_reset_n_i
XVout_reg[2] QDFFRBN $PINS Q=Vout[2] D=n1087 CK=CTS_110
+ RB=FE_OFN195_i_reset_n_i
XVout_reg[3] QDFFRBN $PINS Q=Vout[3] D=n1086 CK=CTS_110
+ RB=FE_OFN191_i_reset_n_i
XVout_reg[4] QDFFRBN $PINS Q=Vout[4] D=n1085 CK=CTS_110
+ RB=FE_OFN191_i_reset_n_i
XVout_reg[5] QDFFRBN $PINS Q=Vout[5] D=n1084 CK=CTS_110
+ RB=FE_OFN191_i_reset_n_i
XVout_reg[6] QDFFRBN $PINS Q=Vout[6] D=n1083 CK=CTS_110
+ RB=FE_OFN191_i_reset_n_i
XVout_reg[7] QDFFRBN $PINS Q=Vout[7] D=n1082 CK=CTS_110
+ RB=FE_OFN195_i_reset_n_i
XVout_reg[8] QDFFRBN $PINS Q=Vout[8] D=n1081 CK=CTS_110
+ RB=FE_OFN191_i_reset_n_i
XVout_reg[9] QDFFRBN $PINS Q=Vout[9] D=n1080 CK=CTS_106
+ RB=FE_OFN195_i_reset_n_i
XVout_reg[10] QDFFRBN $PINS Q=Vout[10] D=n1079 CK=CTS_106
+ RB=FE_OFN195_i_reset_n_i
XVout_reg[11] QDFFRBN $PINS Q=Vout[11] D=n1078 CK=CTS_106
+ RB=FE_OFN195_i_reset_n_i
Xcol_reg_reg[1] DFFSBN $PINS Q=col_reg[1] QB=n4364 D=FE_PHN3292_N591 CK=CTS_124
+ SB=FE_OFN104_i_reset_n_i
Xcol_reg_reg[2] DFFSBN $PINS Q=col_reg[2] QB=n4362 D=N592 CK=CTS_124
+ SB=FE_OFN104_i_reset_n_i
Xrow_reg_reg[0] QDFFRBN $PINS Q=row_reg[0] D=n1077 CK=CTS_124
+ RB=FE_OFN199_i_reset_n_i
Xrow_reg_reg[3] QDFFRBN $PINS Q=row_reg[3] D=n1076 CK=CTS_124
+ RB=FE_OFN199_i_reset_n_i
XIx_reg[4][0] QDFFRBN $PINS Q=Ix[4][0] D=n1075 CK=CTS_114
+ RB=FE_OFN111_i_reset_n_i
XIx_reg[4][1] QDFFRBN $PINS Q=FE_PHN3163_Ix_4_1 D=n1074 CK=CTS_114
+ RB=FE_OFN160_i_reset_n_i
XIx_reg[4][3] QDFFRBN $PINS Q=FE_PHN3170_Ix_4_3 D=n1072 CK=CTS_114
+ RB=FE_OFN210_i_reset_n_i
XIx_reg[4][4] QDFFRBN $PINS Q=FE_PHN3150_Ix_4_4 D=n1071 CK=CTS_114
+ RB=FE_OFN241_i_reset_n_i
XIx_reg[4][5] QDFFRBN $PINS Q=FE_PHN3198_Ix_4_5 D=n1070 CK=CTS_115
+ RB=FE_OFN163_i_reset_n_i
XIx_reg[4][6] QDFFRBN $PINS Q=Ix[4][6] D=n1069 CK=CTS_115
+ RB=FE_OFN163_i_reset_n_i
XIx_reg[4][7] QDFFRBN $PINS Q=FE_PHN3152_Ix_4_7 D=n1068 CK=CTS_114
+ RB=FE_OFN163_i_reset_n_i
XIx_reg[4][8] QDFFRBN $PINS Q=Ix[4][8] D=n1067 CK=CTS_114
+ RB=FE_OFN268_i_reset_n_i
XIx_reg[3][0] QDFFRBN $PINS Q=FE_PHN3143_Ix_3_0 D=n1066 CK=CTS_114
+ RB=FE_OFN209_i_reset_n_i
XIx_reg[3][1] QDFFRBN $PINS Q=Ix[3][1] D=n1065 CK=CTS_114
+ RB=FE_OFN209_i_reset_n_i
XIx_reg[3][2] QDFFRBN $PINS Q=FE_PHN3149_Ix_3_2 D=n1064 CK=CTS_114
+ RB=FE_OFN267_i_reset_n_i
XIx_reg[3][3] QDFFRBN $PINS Q=Ix[3][3] D=n1063 CK=CTS_114
+ RB=FE_OFN242_i_reset_n_i
XIx_reg[3][4] QDFFRBN $PINS Q=FE_PHN3147_Ix_3_4 D=n1062 CK=CTS_114
+ RB=FE_OFN241_i_reset_n_i
XIx_reg[3][5] QDFFRBN $PINS Q=Ix[3][5] D=n1061 CK=CTS_114
+ RB=FE_OFN243_i_reset_n_i
XIx_reg[3][6] QDFFRBN $PINS Q=Ix[3][6] D=n1060 CK=CTS_115
+ RB=FE_OFN243_i_reset_n_i
XIx_reg[3][7] QDFFRBN $PINS Q=FE_PHN3224_Ix_3_7 D=n1059 CK=CTS_114
+ RB=FE_OFN210_i_reset_n_i
XIx_reg[2][0] QDFFRBN $PINS Q=Ix[2][0] D=n1057 CK=CTS_114
+ RB=FE_OFN209_i_reset_n_i
XIx_reg[2][1] QDFFRBN $PINS Q=Ix[2][1] D=n1056 CK=CTS_114
+ RB=FE_OFN209_i_reset_n_i
XIx_reg[2][2] QDFFRBN $PINS Q=Ix[2][2] D=n1055 CK=CTS_114
+ RB=FE_OFN267_i_reset_n_i
XIx_reg[2][3] QDFFRBN $PINS Q=FE_PHN3171_Ix_2_3 D=n1054 CK=CTS_114
+ RB=FE_OFN267_i_reset_n_i
XIx_reg[2][4] QDFFRBN $PINS Q=Ix[2][4] D=n1053 CK=CTS_114
+ RB=FE_OFN267_i_reset_n_i
XIx_reg[2][5] QDFFRBN $PINS Q=FE_PHN3197_Ix_2_5 D=n1052 CK=CTS_115
+ RB=FE_OFN242_i_reset_n_i
XIx_reg[2][6] QDFFRBN $PINS Q=FE_PHN3206_Ix_2_6 D=n1051 CK=CTS_114
+ RB=FE_OFN210_i_reset_n_i
XIx_reg[2][7] QDFFRBN $PINS Q=Ix[2][7] D=n1050 CK=CTS_114
+ RB=FE_OFN160_i_reset_n_i
XIx_reg[2][8] QDFFRBN $PINS Q=FE_PHN3154_Ix_2_8 D=n1049 CK=CTS_114
+ RB=FE_OFN111_i_reset_n_i
XIx_reg[1][0] QDFFRBN $PINS Q=Ix[1][0] D=n1048 CK=CTS_114
+ RB=FE_OFN208_i_reset_n_i
XIx_reg[1][1] QDFFRBN $PINS Q=FE_PHN3176_Ix_1_1 D=n1047 CK=CTS_114
+ RB=FE_OFN208_i_reset_n_i
XIx_reg[1][2] QDFFRBN $PINS Q=Ix[1][2] D=n1046 CK=CTS_114
+ RB=FE_OFN209_i_reset_n_i
XIx_reg[1][3] QDFFRBN $PINS Q=Ix[1][3] D=n1045 CK=CTS_114
+ RB=FE_OFN267_i_reset_n_i
XIx_reg[1][4] QDFFRBN $PINS Q=Ix[1][4] D=n1044 CK=CTS_114
+ RB=FE_OFN160_i_reset_n_i
XIx_reg[1][6] QDFFRBN $PINS Q=Ix[1][6] D=n1042 CK=CTS_114
+ RB=FE_OFN160_i_reset_n_i
XIx_reg[1][7] QDFFRBN $PINS Q=Ix[1][7] D=n1041 CK=CTS_114
+ RB=FE_OFN159_i_reset_n_i
XIx_reg[1][8] QDFFRBN $PINS Q=FE_PHN3199_Ix_1_8 D=n1040 CK=CTS_114
+ RB=FE_OFN159_i_reset_n_i
XIx_reg[0][0] QDFFRBN $PINS Q=Ix[0][0] D=n1039 CK=CTS_114
+ RB=FE_OFN159_i_reset_n_i
XIx_reg[0][1] QDFFRBN $PINS Q=Ix[0][1] D=n1038 CK=CTS_114
+ RB=FE_OFN208_i_reset_n_i
XIx_reg[0][2] QDFFRBN $PINS Q=Ix[0][2] D=n1037 CK=CTS_114
+ RB=FE_OFN208_i_reset_n_i
XIx_reg[0][3] QDFFRBN $PINS Q=Ix[0][3] D=n1036 CK=CTS_114
+ RB=FE_OFN208_i_reset_n_i
XIx_reg[0][4] QDFFRBN $PINS Q=Ix[0][4] D=n1035 CK=CTS_114
+ RB=FE_OFN207_i_reset_n_i
XIx_reg[0][5] QDFFRBN $PINS Q=Ix[0][5] D=n1034 CK=CTS_114
+ RB=FE_OFN207_i_reset_n_i
XIx_reg[0][6] QDFFRBN $PINS Q=Ix[0][6] D=n1033 CK=CTS_114
+ RB=FE_OFN159_i_reset_n_i
XIx_reg[0][7] QDFFRBN $PINS Q=Ix[0][7] D=n1032 CK=CTS_114
+ RB=FE_OFN207_i_reset_n_i
XIx_reg[0][8] QDFFRBN $PINS Q=Ix[0][8] D=n1031 CK=CTS_114
+ RB=FE_OFN207_i_reset_n_i
Xrow_reg_reg[2] DFFSBN $PINS Q=row_reg[2] D=FE_PHN3296_n1029 CK=CTS_124
+ SB=FE_OFN199_i_reset_n_i
Xintadd_22/U8 FA1S $PINS S=intadd_22/SUM[0] CO=intadd_22/n7 A=intadd_22/B[0]
+ B=FE_OFN1656_a_reg_1 CI=intadd_22/CI
Xintadd_22/U7 FA1S $PINS S=intadd_22/SUM[1] CO=intadd_22/n6 A=intadd_22/B[1]
+ B=FE_OFN1604_a_reg_2 CI=intadd_22/n7
Xintadd_22/U6 FA1S $PINS S=intadd_22/SUM[2] CO=intadd_22/n5 A=intadd_22/B[2]
+ B=FE_OFN1632_a_reg_3 CI=intadd_22/n6
Xintadd_22/U5 FA1S $PINS S=intadd_22/SUM[3] CO=intadd_22/n4 A=intadd_22/B[3]
+ B=FE_OFN1641_a_reg_4 CI=intadd_22/n5
Xintadd_22/U4 FA1S $PINS S=intadd_22/SUM[4] CO=intadd_22/n3 A=intadd_22/B[4]
+ B=FE_PHN3284_a_reg_5 CI=intadd_22/n4
Xintadd_22/U3 FA1S $PINS S=intadd_22/SUM[5] CO=intadd_22/n2 A=intadd_22/B[5]
+ B=FE_PHN3285_a_reg_6 CI=intadd_22/n3
Xintadd_22/U2 FA1S $PINS S=intadd_22/SUM[6] CO=intadd_22/n1 A=intadd_22/B[6]
+ B=a_reg[7] CI=intadd_22/n2
Xintadd_26/U6 FA1S $PINS S=intadd_26/SUM[0] CO=intadd_26/n5 A=intadd_26/B[0]
+ B=intadd_26/A[0] CI=intadd_26/CI
Xintadd_26/U5 FA1S $PINS S=intadd_26/SUM[1] CO=intadd_26/n4 A=intadd_26/B[1]
+ B=intadd_26/n5 CI=intadd_26/A[1]
Xintadd_26/U4 FA1S $PINS S=intadd_26/SUM[2] CO=intadd_26/n3 A=intadd_26/B[2]
+ B=intadd_26/A[2] CI=intadd_26/n4
Xintadd_26/U3 FA1S $PINS S=intadd_26/SUM[3] CO=intadd_26/n2 A=intadd_26/B[3]
+ B=intadd_26/A[3] CI=intadd_26/n3
Xintadd_27/U6 FA1S $PINS S=intadd_27/SUM[0] CO=intadd_27/n5 A=intadd_27/B[0]
+ B=intadd_27/A[0] CI=intadd_27/CI
Xintadd_27/U5 FA1S $PINS S=intadd_27/SUM[1] CO=intadd_27/n4 A=intadd_27/B[1]
+ B=intadd_27/A[1] CI=intadd_27/n5
Xintadd_27/U4 FA1S $PINS S=intadd_27/SUM[2] CO=intadd_27/n3 A=intadd_27/B[2]
+ B=intadd_27/A[2] CI=intadd_27/n4
Xintadd_27/U3 FA1 $PINS S=intadd_27/SUM[3] CO=intadd_27/n2 A=intadd_27/B[3]
+ B=intadd_27/A[3] CI=intadd_27/n3
Xintadd_28/U6 FA1S $PINS S=intadd_28/SUM[0] CO=intadd_28/n5 A=intadd_28/B[0]
+ B=intadd_28/A[0] CI=intadd_28/CI
Xintadd_28/U5 FA1S $PINS S=intadd_28/SUM[1] CO=intadd_28/n4 A=intadd_28/B[1]
+ B=intadd_28/A[1] CI=intadd_28/n5
Xintadd_28/U4 FA1S $PINS S=intadd_28/SUM[2] CO=intadd_28/n3 A=intadd_28/B[2]
+ B=intadd_28/A[2] CI=intadd_28/n4
Xintadd_28/U3 FA1 $PINS S=intadd_28/SUM[3] CO=intadd_28/n2 A=intadd_28/B[3]
+ B=intadd_28/A[3] CI=intadd_28/n3
Xintadd_29/U6 FA1 $PINS S=intadd_29/SUM[0] CO=intadd_29/n5 A=intadd_29/B[0]
+ B=intadd_29/A[0] CI=intadd_29/CI
Xintadd_29/U5 FA1S $PINS S=intadd_29/SUM[1] CO=intadd_29/n4 A=intadd_29/B[1]
+ B=intadd_29/A[1] CI=intadd_29/n5
Xintadd_29/U4 FA1S $PINS S=intadd_29/SUM[2] CO=intadd_29/n3 A=intadd_29/B[2]
+ B=intadd_29/A[2] CI=intadd_29/n4
Xintadd_29/U3 FA1S $PINS S=intadd_29/SUM[3] CO=intadd_29/n2 A=intadd_29/B[3]
+ B=intadd_29/A[3] CI=intadd_29/n3
Xintadd_29/U2 FA1S $PINS S=intadd_29/SUM[4] CO=intadd_29/n1 A=intadd_29/B[4]
+ B=intadd_29/A[4] CI=intadd_29/n2
Xintadd_30/U6 FA1 $PINS S=intadd_30/SUM[0] CO=intadd_30/n5 A=intadd_30/B[0]
+ B=intadd_30/A[0] CI=intadd_30/CI
Xintadd_30/U5 FA1S $PINS S=intadd_30/SUM[1] CO=intadd_30/n4 A=intadd_30/B[1]
+ B=intadd_30/A[1] CI=intadd_30/n5
Xintadd_30/U4 FA1S $PINS S=intadd_30/SUM[2] CO=intadd_30/n3 A=intadd_30/B[2]
+ B=intadd_30/A[2] CI=intadd_30/n4
Xintadd_30/U3 FA1S $PINS S=intadd_30/SUM[3] CO=intadd_30/n2 A=intadd_30/B[3]
+ B=intadd_30/A[3] CI=intadd_30/n3
Xintadd_30/U2 FA1S $PINS S=intadd_30/SUM[4] CO=intadd_30/n1 A=intadd_30/B[4]
+ B=intadd_30/A[4] CI=intadd_30/n2
Xintadd_31/U5 FA1S $PINS S=intadd_31/SUM[1] CO=intadd_31/n4 A=intadd_31/B[1]
+ B=intadd_31/A[1] CI=intadd_31/n5
Xintadd_31/U4 FA1S $PINS S=intadd_31/SUM[2] CO=intadd_31/n3 A=intadd_31/B[2]
+ B=intadd_31/A[2] CI=intadd_31/n4
Xintadd_31/U3 FA1S $PINS S=intadd_31/SUM[3] CO=intadd_31/n2 A=intadd_31/B[3]
+ B=intadd_31/A[3] CI=intadd_31/n3
Xintadd_31/U2 FA1S $PINS S=intadd_31/SUM[4] CO=intadd_31/n1 A=intadd_31/B[4]
+ B=intadd_31/A[4] CI=intadd_31/n2
Xintadd_32/U5 FA1S $PINS S=intadd_32/SUM[0] CO=intadd_32/n4 A=intadd_32/B[0]
+ B=intadd_32/A[0] CI=intadd_32/CI
Xintadd_32/U4 FA1S $PINS S=intadd_32/SUM[1] CO=intadd_32/n3 A=intadd_32/B[1]
+ B=intadd_32/A[1] CI=intadd_32/n4
Xintadd_32/U2 FA1 $PINS S=intadd_32/SUM[3] CO=intadd_32/n1 A=intadd_32/B[3]
+ B=intadd_32/A[3] CI=intadd_32/n2
Xintadd_33/U5 FA1S $PINS S=intadd_33/SUM[0] CO=intadd_33/n4 A=intadd_33/B[0]
+ B=intadd_33/A[0] CI=intadd_33/CI
Xintadd_33/U4 FA1S $PINS S=intadd_33/SUM[1] CO=intadd_33/n3 A=intadd_33/B[1]
+ B=intadd_33/A[1] CI=intadd_33/n4
Xintadd_33/U3 FA1S $PINS S=intadd_33/SUM[2] CO=intadd_33/n2 A=intadd_33/B[2]
+ B=intadd_33/A[2] CI=intadd_33/n3
Xintadd_33/U2 FA1S $PINS S=intadd_33/SUM[3] CO=intadd_33/n1 A=intadd_33/B[3]
+ B=intadd_33/A[3] CI=intadd_33/n2
Xintadd_34/U4 FA1S $PINS S=intadd_34/SUM[0] CO=intadd_34/n3 A=intadd_34/B[0]
+ B=intadd_34/A[0] CI=intadd_34/CI
Xintadd_34/U3 FA1S $PINS S=intadd_34/SUM[1] CO=intadd_34/n2 A=intadd_34/B[1]
+ B=intadd_34/A[1] CI=intadd_34/n3
Xintadd_35/U4 FA1S $PINS S=intadd_35/SUM[0] CO=intadd_35/n3 A=intadd_35/B[0]
+ B=intadd_35/A[0] CI=intadd_35/CI
Xintadd_35/U3 FA1S $PINS S=intadd_35/SUM[1] CO=intadd_35/n2 A=intadd_35/B[1]
+ B=intadd_35/A[1] CI=intadd_35/n3
Xintadd_36/U4 FA1S $PINS S=intadd_36/SUM[0] CO=intadd_36/n3 A=intadd_36/B[0]
+ B=intadd_36/A[0] CI=intadd_36/CI
Xintadd_36/U3 FA1S $PINS S=intadd_36/SUM[1] CO=intadd_36/n2 A=intadd_36/B[1]
+ B=intadd_36/A[1] CI=intadd_36/n3
Xintadd_0/U11 FA1S $PINS S=intadd_0/SUM[0] CO=intadd_0/n10 A=intadd_0/B[0]
+ B=intadd_0/A[0] CI=intadd_0/CI
Xintadd_0/U10 FA1S $PINS S=intadd_0/SUM[1] CO=intadd_0/n9 A=intadd_0/B[1]
+ B=intadd_0/A[1] CI=intadd_0/n10
Xintadd_0/U9 FA1S $PINS S=intadd_0/SUM[2] CO=intadd_0/n8 A=intadd_0/B[2]
+ B=intadd_33/SUM[0] CI=intadd_0/n9
Xintadd_0/U8 FA1 $PINS S=intadd_0/SUM[3] CO=intadd_0/n7 A=intadd_0/B[3]
+ B=intadd_33/SUM[1] CI=intadd_0/n8
Xintadd_0/U7 FA1S $PINS S=intadd_0/SUM[4] CO=intadd_0/n6 A=intadd_0/B[4]
+ B=intadd_33/SUM[2] CI=intadd_0/n7
Xintadd_0/U6 FA1 $PINS S=intadd_0/SUM[5] CO=intadd_0/n5 A=intadd_33/SUM[3]
+ B=intadd_0/A[5] CI=intadd_0/n6
Xintadd_0/U5 FA1 $PINS S=intadd_0/SUM[6] CO=intadd_0/n4 A=intadd_0/B[6]
+ B=intadd_33/n1 CI=intadd_0/n5
Xintadd_0/U4 FA1 $PINS S=intadd_0/SUM[7] CO=intadd_0/n3 A=intadd_0/B[7]
+ B=intadd_0/A[7] CI=intadd_0/n4
Xintadd_0/U3 FA1 $PINS S=intadd_0/SUM[8] CO=intadd_0/n2 A=intadd_0/B[8]
+ B=intadd_0/A[8] CI=intadd_0/n3
Xintadd_1/U11 FA1S $PINS S=intadd_1/SUM[0] CO=intadd_1/n10 A=intadd_1/B[0]
+ B=intadd_1/A[0] CI=intadd_1/CI
Xintadd_1/U9 FA1S $PINS S=intadd_1/SUM[2] CO=intadd_1/n8 A=intadd_1/B[2]
+ B=intadd_32/SUM[0] CI=intadd_1/n9
Xintadd_1/U6 FA1S $PINS S=intadd_1/SUM[5] CO=intadd_1/n5 A=intadd_32/SUM[3]
+ B=intadd_1/A[5] CI=intadd_1/n6
Xintadd_1/U5 FA1 $PINS S=intadd_1/SUM[6] CO=intadd_1/n4 A=intadd_1/B[6]
+ B=intadd_32/n1 CI=intadd_1/n5
Xintadd_1/U4 FA1 $PINS S=intadd_1/SUM[7] CO=intadd_1/n3 A=intadd_1/B[7]
+ B=intadd_1/A[7] CI=intadd_1/n4
Xintadd_1/U3 FA1S $PINS S=intadd_1/SUM[8] CO=intadd_1/n2 A=intadd_1/B[8]
+ B=intadd_1/A[8] CI=intadd_1/n3
Xintadd_2/U8 FA1S $PINS S=intadd_2/SUM[0] CO=intadd_2/n7 A=intadd_2/B[0]
+ B=intadd_2/A[0] CI=intadd_2/CI
Xintadd_2/U7 FA1 $PINS S=intadd_2/SUM[1] CO=intadd_2/n6 A=intadd_2/B[1]
+ B=intadd_2/n7 CI=intadd_2/A[1]
Xintadd_2/U6 FA1S $PINS S=intadd_2/SUM[2] CO=intadd_2/n5 A=intadd_2/B[2]
+ B=intadd_2/A[2] CI=intadd_2/n6
Xintadd_2/U5 FA1S $PINS S=intadd_2/SUM[3] CO=intadd_2/n4 A=intadd_2/B[3]
+ B=intadd_2/A[3] CI=intadd_2/n5
Xintadd_2/U4 FA1S $PINS S=intadd_2/SUM[4] CO=intadd_2/n3 A=intadd_2/B[4]
+ B=intadd_2/A[4] CI=intadd_2/n4
Xintadd_2/U3 FA1S $PINS S=intadd_2/SUM[5] CO=intadd_2/n2 A=intadd_2/B[5]
+ B=intadd_2/A[5] CI=intadd_2/n3
Xintadd_2/U2 FA1S $PINS S=intadd_2/SUM[6] CO=intadd_2/n1 A=intadd_2/B[6]
+ B=intadd_2/A[6] CI=intadd_2/n2
Xintadd_3/U8 FA1S $PINS S=intadd_3/SUM[0] CO=intadd_3/n7 A=intadd_3/B[0]
+ B=intadd_3/A[0] CI=intadd_3/CI
Xintadd_3/U7 FA1S $PINS S=intadd_3/SUM[1] CO=intadd_3/n6 A=intadd_3/B[1]
+ B=intadd_2/SUM[0] CI=intadd_3/n7
Xintadd_3/U6 FA1S $PINS S=intadd_3/SUM[2] CO=intadd_3/n5 A=intadd_3/B[2]
+ B=intadd_2/SUM[1] CI=intadd_3/n6
Xintadd_3/U5 FA1S $PINS S=intadd_3/SUM[3] CO=intadd_3/n4 A=intadd_3/B[3]
+ B=intadd_3/A[3] CI=intadd_3/n5
Xintadd_3/U4 FA1S $PINS S=intadd_3/SUM[4] CO=intadd_3/n3 A=intadd_3/B[4]
+ B=intadd_3/A[4] CI=intadd_3/n4
Xintadd_3/U3 FA1S $PINS S=intadd_3/SUM[5] CO=intadd_3/n2 A=intadd_3/B[5]
+ B=intadd_3/A[5] CI=intadd_3/n3
Xintadd_3/U2 FA1S $PINS S=intadd_3/SUM[6] CO=intadd_3/n1 A=intadd_3/B[6]
+ B=intadd_2/SUM[5] CI=intadd_3/n2
Xintadd_4/U8 FA1S $PINS S=intadd_4/SUM[0] CO=intadd_4/n7 A=intadd_4/B[0]
+ B=intadd_4/A[0] CI=intadd_4/CI
Xintadd_4/U7 FA1S $PINS S=intadd_4/SUM[1] CO=intadd_4/n6 A=intadd_4/B[1]
+ B=intadd_3/SUM[0] CI=intadd_4/n7
Xintadd_4/U6 FA1S $PINS S=intadd_4/SUM[2] CO=intadd_4/n5 A=intadd_4/B[2]
+ B=intadd_3/SUM[1] CI=intadd_4/n6
Xintadd_4/U5 FA1S $PINS S=intadd_4/SUM[3] CO=intadd_4/n4 A=intadd_4/B[3]
+ B=intadd_3/SUM[2] CI=intadd_4/n5
Xintadd_4/U4 FA1S $PINS S=intadd_4/SUM[4] CO=intadd_4/n3 A=intadd_4/B[4]
+ B=intadd_2/SUM[2] CI=intadd_4/n4
Xintadd_4/U3 FA1S $PINS S=intadd_4/SUM[5] CO=intadd_4/n2 A=intadd_2/SUM[3]
+ B=intadd_4/A[5] CI=intadd_4/n3
Xintadd_4/U2 FA1S $PINS S=intadd_4/SUM[6] CO=intadd_4/n1 A=intadd_2/SUM[4]
+ B=intadd_3/SUM[5] CI=intadd_4/n2
Xintadd_5/U8 FA1S $PINS S=intadd_5/SUM[0] CO=intadd_5/n7 A=intadd_5/B[0]
+ B=intadd_5/A[0] CI=intadd_5/CI
Xintadd_5/U7 FA1S $PINS S=intadd_5/SUM[1] CO=intadd_5/n6 A=intadd_5/B[1]
+ B=intadd_4/SUM[0] CI=intadd_5/n7
Xintadd_5/U6 FA1S $PINS S=intadd_5/SUM[2] CO=intadd_5/n5 A=intadd_5/B[2]
+ B=intadd_4/SUM[1] CI=intadd_5/n6
Xintadd_5/U5 FA1 $PINS S=intadd_5/SUM[3] CO=intadd_5/n4 A=intadd_5/B[3]
+ B=intadd_4/SUM[2] CI=intadd_5/n5
Xintadd_5/U4 FA1 $PINS S=intadd_5/SUM[4] CO=intadd_5/n3 A=intadd_5/B[4]
+ B=intadd_5/A[4] CI=intadd_5/n4
Xintadd_5/U2 FA1S $PINS S=intadd_5/SUM[6] CO=intadd_5/n1 A=intadd_3/SUM[4]
+ B=intadd_4/SUM[5] CI=intadd_5/n2
Xintadd_6/U8 FA1S $PINS S=intadd_28/A[1] CO=intadd_6/n7 A=intadd_6/B[0]
+ B=intadd_6/A[0] CI=intadd_6/CI
Xintadd_6/U7 FA1S $PINS S=intadd_28/A[2] CO=intadd_6/n6 A=intadd_6/B[1]
+ B=intadd_5/SUM[0] CI=intadd_6/n7
Xintadd_6/U6 FA1S $PINS S=intadd_28/A[3] CO=intadd_6/n5 A=intadd_6/B[2]
+ B=intadd_5/SUM[1] CI=intadd_6/n6
Xintadd_6/U5 FA1 $PINS S=intadd_6/SUM[3] CO=intadd_6/n4 A=intadd_6/B[3]
+ B=intadd_5/SUM[2] CI=intadd_6/n5
Xintadd_6/U4 FA1 $PINS S=intadd_6/SUM[4] CO=intadd_6/n3 A=intadd_6/B[4]
+ B=intadd_6/A[4] CI=intadd_6/n4
Xintadd_6/U3 FA1 $PINS S=intadd_6/SUM[5] CO=intadd_6/n2 A=intadd_4/SUM[3]
+ B=intadd_6/A[5] CI=intadd_6/n3
Xintadd_6/U2 FA1S $PINS S=intadd_6/SUM[6] CO=intadd_6/n1 A=intadd_4/SUM[4]
+ B=intadd_5/SUM[5] CI=intadd_6/n2
Xintadd_7/U8 FA1S $PINS S=intadd_7/SUM[0] CO=intadd_7/n7 A=intadd_7/B[0]
+ B=intadd_7/A[0] CI=intadd_7/CI
Xintadd_7/U7 FA1S $PINS S=intadd_7/SUM[1] CO=intadd_7/n6 A=intadd_7/B[1]
+ B=intadd_28/SUM[0] CI=intadd_7/n7
Xintadd_7/U6 FA1S $PINS S=intadd_7/SUM[2] CO=intadd_7/n5 A=intadd_7/B[2]
+ B=intadd_28/SUM[1] CI=intadd_7/n6
Xintadd_7/U4 FA1 $PINS S=intadd_7/SUM[4] CO=intadd_7/n3 A=intadd_7/B[4]
+ B=intadd_7/A[4] CI=intadd_7/n4
Xintadd_8/U8 FA1 $PINS S=intadd_8/SUM[0] CO=intadd_8/n7 A=intadd_8/B[0]
+ B=intadd_8/A[0] CI=intadd_8/CI
Xintadd_8/U7 FA1S $PINS S=intadd_8/SUM[1] CO=intadd_8/n6 A=intadd_8/B[1]
+ B=intadd_8/A[1] CI=intadd_8/n7
Xintadd_8/U6 FA1S $PINS S=intadd_8/SUM[2] CO=intadd_8/n5 A=intadd_8/B[2]
+ B=intadd_8/A[2] CI=intadd_8/n6
Xintadd_8/U5 FA1S $PINS S=intadd_8/SUM[3] CO=intadd_8/n4 A=intadd_8/B[3]
+ B=intadd_8/A[3] CI=intadd_8/n5
Xintadd_8/U4 FA1S $PINS S=intadd_8/SUM[4] CO=intadd_8/n3 A=intadd_8/B[4]
+ B=intadd_8/A[4] CI=intadd_8/n4
Xintadd_8/U3 FA1S $PINS S=intadd_8/SUM[5] CO=intadd_8/n2 A=intadd_8/B[5]
+ B=intadd_8/A[5] CI=intadd_8/n3
Xintadd_8/U2 FA1S $PINS S=intadd_8/SUM[6] CO=intadd_8/n1 A=intadd_8/B[6]
+ B=intadd_8/A[6] CI=intadd_8/n2
Xintadd_9/U8 FA1S $PINS S=intadd_9/SUM[0] CO=intadd_9/n7 A=intadd_9/B[0]
+ B=intadd_9/A[0] CI=intadd_9/CI
Xintadd_9/U7 FA1S $PINS S=intadd_9/SUM[1] CO=intadd_9/n6 A=intadd_9/B[1]
+ B=intadd_8/SUM[0] CI=intadd_9/n7
Xintadd_9/U6 FA1S $PINS S=intadd_9/SUM[2] CO=intadd_9/n5 A=intadd_9/B[2]
+ B=intadd_8/SUM[1] CI=intadd_9/n6
Xintadd_9/U5 FA1 $PINS S=intadd_9/SUM[3] CO=intadd_9/n4 A=intadd_9/B[3]
+ B=intadd_9/A[3] CI=intadd_9/n5
Xintadd_9/U4 FA1S $PINS S=intadd_9/SUM[4] CO=intadd_9/n3 A=intadd_9/B[4]
+ B=intadd_9/A[4] CI=intadd_9/n4
Xintadd_9/U3 FA1S $PINS S=intadd_9/SUM[5] CO=intadd_9/n2 A=intadd_9/B[5]
+ B=intadd_9/A[5] CI=intadd_9/n3
Xintadd_9/U2 FA1S $PINS S=intadd_9/SUM[6] CO=intadd_9/n1 A=intadd_9/B[6]
+ B=intadd_8/SUM[5] CI=intadd_9/n2
Xintadd_10/U8 FA1S $PINS S=intadd_10/SUM[0] CO=intadd_10/n7 A=intadd_10/B[0]
+ B=intadd_10/A[0] CI=intadd_10/CI
Xintadd_10/U7 FA1 $PINS S=intadd_10/SUM[1] CO=intadd_10/n6 A=intadd_10/B[1]
+ B=intadd_10/n7 CI=intadd_9/SUM[0]
Xintadd_10/U6 FA1S $PINS S=intadd_10/SUM[2] CO=intadd_10/n5 A=intadd_10/B[2]
+ B=intadd_9/SUM[1] CI=intadd_10/n6
Xintadd_10/U4 FA1S $PINS S=intadd_10/SUM[4] CO=intadd_10/n3 A=intadd_10/B[4]
+ B=intadd_8/SUM[2] CI=intadd_10/n4
Xintadd_10/U3 FA1S $PINS S=intadd_10/SUM[5] CO=intadd_10/n2 A=intadd_8/SUM[3]
+ B=intadd_10/A[5] CI=intadd_10/n3
Xintadd_10/U2 FA1S $PINS S=intadd_10/SUM[6] CO=intadd_10/n1 A=intadd_8/SUM[4]
+ B=intadd_9/SUM[5] CI=intadd_10/n2
Xintadd_11/U8 FA1S $PINS S=intadd_11/SUM[0] CO=intadd_11/n7 A=intadd_11/B[0]
+ B=intadd_11/A[0] CI=intadd_11/CI
Xintadd_11/U7 FA1 $PINS S=intadd_11/SUM[1] CO=intadd_11/n6 A=intadd_11/B[1]
+ B=intadd_10/SUM[0] CI=intadd_11/n7
Xintadd_11/U6 FA1S $PINS S=intadd_11/SUM[2] CO=intadd_11/n5 A=intadd_11/B[2]
+ B=intadd_10/SUM[1] CI=intadd_11/n6
Xintadd_11/U5 FA1S $PINS S=intadd_11/SUM[3] CO=intadd_11/n4 A=intadd_11/B[3]
+ B=intadd_10/SUM[2] CI=intadd_11/n5
Xintadd_11/U4 FA1 $PINS S=intadd_11/SUM[4] CO=intadd_11/n3 A=intadd_11/B[4]
+ B=intadd_11/A[4] CI=intadd_11/n4
Xintadd_11/U2 FA1S $PINS S=intadd_11/SUM[6] CO=intadd_11/n1 A=intadd_9/SUM[4]
+ B=intadd_10/SUM[5] CI=intadd_11/n2
Xintadd_12/U8 FA1S $PINS S=intadd_27/A[1] CO=intadd_12/n7 A=intadd_12/B[0]
+ B=intadd_12/A[0] CI=intadd_12/CI
Xintadd_12/U7 FA1 $PINS S=intadd_27/A[2] CO=intadd_12/n6 A=intadd_12/B[1]
+ B=intadd_12/n7 CI=intadd_11/SUM[0]
Xintadd_12/U6 FA1 $PINS S=intadd_27/A[3] CO=intadd_12/n5 A=intadd_12/B[2]
+ B=intadd_11/SUM[1] CI=intadd_12/n6
Xintadd_12/U4 FA1 $PINS S=intadd_12/SUM[4] CO=intadd_12/n3 A=intadd_12/B[4]
+ B=intadd_12/A[4] CI=intadd_12/n4
Xintadd_12/U3 FA1S $PINS S=intadd_12/SUM[5] CO=intadd_12/n2 A=intadd_10/SUM[3]
+ B=intadd_12/A[5] CI=intadd_12/n3
Xintadd_12/U2 FA1S $PINS S=intadd_12/SUM[6] CO=intadd_12/n1 A=intadd_10/SUM[4]
+ B=intadd_11/SUM[5] CI=intadd_12/n2
Xintadd_13/U8 FA1S $PINS S=intadd_13/SUM[0] CO=intadd_13/n7 A=intadd_13/B[0]
+ B=intadd_13/A[0] CI=intadd_13/CI
Xintadd_13/U7 FA1S $PINS S=intadd_13/SUM[1] CO=intadd_13/n6 A=intadd_13/B[1]
+ B=intadd_27/SUM[0] CI=intadd_13/n7
Xintadd_13/U6 FA1S $PINS S=intadd_13/SUM[2] CO=intadd_13/n5 A=intadd_13/B[2]
+ B=intadd_27/SUM[1] CI=intadd_13/n6
Xintadd_13/U4 FA1 $PINS S=intadd_13/SUM[4] CO=intadd_13/n3 A=intadd_13/B[4]
+ B=intadd_13/A[4] CI=intadd_13/n4
Xintadd_15/U8 FA1S $PINS S=intadd_15/SUM[0] CO=intadd_15/n7 A=intadd_15/B[0]
+ B=intadd_15/A[0] CI=intadd_15/CI
Xintadd_15/U7 FA1 $PINS S=intadd_15/SUM[1] CO=intadd_15/n6 A=intadd_15/B[1]
+ B=intadd_15/n7 CI=intadd_15/A[1]
Xintadd_15/U6 FA1S $PINS S=intadd_15/SUM[2] CO=intadd_15/n5 A=intadd_15/B[2]
+ B=intadd_15/A[2] CI=intadd_15/n6
Xintadd_15/U5 FA1S $PINS S=intadd_15/SUM[3] CO=intadd_15/n4 A=intadd_15/B[3]
+ B=intadd_15/A[3] CI=intadd_15/n5
Xintadd_15/U4 FA1S $PINS S=intadd_15/SUM[4] CO=intadd_15/n3 A=intadd_15/B[4]
+ B=intadd_15/A[4] CI=intadd_15/n4
Xintadd_15/U3 FA1S $PINS S=intadd_15/SUM[5] CO=intadd_15/n2 A=intadd_15/B[5]
+ B=intadd_15/A[5] CI=intadd_15/n3
Xintadd_15/U2 FA1S $PINS S=intadd_15/SUM[6] CO=intadd_15/n1 A=intadd_15/B[6]
+ B=intadd_15/A[6] CI=intadd_15/n2
Xintadd_16/U8 FA1S $PINS S=intadd_16/SUM[0] CO=intadd_16/n7 A=intadd_16/B[0]
+ B=intadd_16/A[0] CI=intadd_16/CI
Xintadd_16/U7 FA1S $PINS S=intadd_16/SUM[1] CO=intadd_16/n6 A=intadd_16/B[1]
+ B=intadd_15/SUM[0] CI=intadd_16/n7
Xintadd_16/U6 FA1S $PINS S=intadd_16/SUM[2] CO=intadd_16/n5 A=intadd_16/B[2]
+ B=intadd_15/SUM[1] CI=intadd_16/n6
Xintadd_16/U5 FA1S $PINS S=intadd_16/SUM[3] CO=intadd_16/n4 A=intadd_16/B[3]
+ B=intadd_16/A[3] CI=intadd_16/n5
Xintadd_16/U4 FA1S $PINS S=intadd_16/SUM[4] CO=intadd_16/n3 A=intadd_16/B[4]
+ B=intadd_16/A[4] CI=intadd_16/n4
Xintadd_16/U3 FA1S $PINS S=intadd_16/SUM[5] CO=intadd_16/n2 A=intadd_16/B[5]
+ B=intadd_16/A[5] CI=intadd_16/n3
Xintadd_16/U2 FA1S $PINS S=intadd_16/SUM[6] CO=intadd_16/n1 A=intadd_16/B[6]
+ B=intadd_15/SUM[5] CI=intadd_16/n2
Xintadd_17/U8 FA1S $PINS S=intadd_17/SUM[0] CO=intadd_17/n7 A=intadd_17/B[0]
+ B=intadd_17/A[0] CI=intadd_17/CI
Xintadd_17/U7 FA1 $PINS S=intadd_17/SUM[1] CO=intadd_17/n6 A=intadd_17/B[1]
+ B=intadd_16/SUM[0] CI=intadd_17/n7
Xintadd_17/U6 FA1S $PINS S=intadd_17/SUM[2] CO=intadd_17/n5 A=intadd_17/B[2]
+ B=intadd_16/SUM[1] CI=intadd_17/n6
Xintadd_17/U5 FA1S $PINS S=intadd_17/SUM[3] CO=intadd_17/n4 A=intadd_17/B[3]
+ B=intadd_16/SUM[2] CI=intadd_17/n5
Xintadd_17/U4 FA1S $PINS S=intadd_17/SUM[4] CO=intadd_17/n3 A=intadd_17/B[4]
+ B=intadd_15/SUM[2] CI=intadd_17/n4
Xintadd_17/U3 FA1S $PINS S=intadd_17/SUM[5] CO=intadd_17/n2 A=intadd_15/SUM[3]
+ B=intadd_17/A[5] CI=intadd_17/n3
Xintadd_17/U2 FA1S $PINS S=intadd_17/SUM[6] CO=intadd_17/n1 A=intadd_15/SUM[4]
+ B=intadd_16/SUM[5] CI=intadd_17/n2
Xintadd_18/U8 FA1S $PINS S=intadd_18/SUM[0] CO=intadd_18/n7 A=intadd_18/B[0]
+ B=intadd_18/A[0] CI=intadd_18/CI
Xintadd_18/U7 FA1S $PINS S=intadd_18/SUM[1] CO=intadd_18/n6 A=intadd_18/B[1]
+ B=intadd_17/SUM[0] CI=intadd_18/n7
Xintadd_18/U6 FA1S $PINS S=intadd_18/SUM[2] CO=intadd_18/n5 A=intadd_18/B[2]
+ B=intadd_17/SUM[1] CI=intadd_18/n6
Xintadd_18/U5 FA1S $PINS S=intadd_18/SUM[3] CO=intadd_18/n4 A=intadd_18/B[3]
+ B=intadd_17/SUM[2] CI=intadd_18/n5
Xintadd_18/U4 FA1S $PINS S=intadd_18/SUM[4] CO=intadd_18/n3 A=intadd_18/B[4]
+ B=intadd_18/A[4] CI=intadd_18/n4
Xintadd_18/U3 FA1S $PINS S=intadd_18/SUM[5] CO=intadd_18/n2 A=intadd_16/SUM[3]
+ B=intadd_18/A[5] CI=intadd_18/n3
Xintadd_18/U2 FA1S $PINS S=intadd_18/SUM[6] CO=intadd_18/n1 A=intadd_16/SUM[4]
+ B=intadd_17/SUM[5] CI=intadd_18/n2
Xintadd_19/U8 FA1S $PINS S=intadd_26/A[1] CO=intadd_19/n7 A=intadd_19/B[0]
+ B=intadd_19/A[0] CI=intadd_19/CI
Xintadd_19/U7 FA1S $PINS S=intadd_26/A[2] CO=intadd_19/n6 A=intadd_19/B[1]
+ B=intadd_18/SUM[0] CI=intadd_19/n7
Xintadd_19/U6 FA1 $PINS S=intadd_26/A[3] CO=intadd_19/n5 A=intadd_19/B[2]
+ B=intadd_18/SUM[1] CI=intadd_19/n6
Xintadd_19/U5 FA1 $PINS S=intadd_19/SUM[3] CO=intadd_19/n4 A=intadd_19/B[3]
+ B=intadd_18/SUM[2] CI=intadd_19/n5
Xintadd_19/U4 FA1 $PINS S=intadd_19/SUM[4] CO=intadd_19/n3 A=intadd_19/B[4]
+ B=intadd_19/A[4] CI=intadd_19/n4
Xintadd_19/U3 FA1S $PINS S=intadd_19/SUM[5] CO=intadd_19/n2 A=intadd_19/n3
+ B=intadd_19/A[5] CI=intadd_17/SUM[3]
Xintadd_19/U2 FA1 $PINS S=intadd_19/SUM[6] CO=intadd_19/n1 A=intadd_17/SUM[4]
+ B=intadd_18/SUM[5] CI=intadd_19/n2
Xintadd_20/U8 FA1S $PINS S=intadd_20/SUM[0] CO=intadd_20/n7 A=intadd_20/B[0]
+ B=intadd_20/A[0] CI=intadd_20/CI
Xintadd_20/U7 FA1S $PINS S=intadd_20/SUM[1] CO=intadd_20/n6 A=intadd_20/B[1]
+ B=intadd_26/SUM[0] CI=intadd_20/n7
Xintadd_20/U6 FA1S $PINS S=intadd_20/SUM[2] CO=intadd_20/n5 A=intadd_20/B[2]
+ B=intadd_26/SUM[1] CI=intadd_20/n6
Xintadd_20/U4 FA1 $PINS S=intadd_20/SUM[4] CO=intadd_20/n3 A=intadd_20/B[4]
+ B=intadd_20/A[4] CI=intadd_20/n4
Xintadd_23/U7 FA1S $PINS S=intadd_29/A[1] CO=intadd_23/n6 A=intadd_23/B[0]
+ B=intadd_23/A[0] CI=intadd_23/CI
Xintadd_23/U6 FA1S $PINS S=intadd_29/A[2] CO=intadd_23/n5 A=intadd_23/B[1]
+ B=intadd_23/A[1] CI=intadd_23/n6
Xintadd_23/U5 FA1S $PINS S=intadd_29/A[3] CO=intadd_23/n4 A=intadd_23/B[2]
+ B=intadd_23/A[2] CI=intadd_23/n5
Xintadd_23/U4 FA1S $PINS S=intadd_29/A[4] CO=intadd_23/n3 A=intadd_23/B[3]
+ B=intadd_23/A[3] CI=intadd_23/n4
Xintadd_23/U3 FA1S $PINS S=intadd_23/SUM[4] CO=intadd_23/n2 A=intadd_23/B[4]
+ B=intadd_23/A[4] CI=intadd_23/n3
Xintadd_24/U7 FA1S $PINS S=intadd_30/A[1] CO=intadd_24/n6 A=intadd_24/B[0]
+ B=intadd_24/A[0] CI=intadd_24/CI
Xintadd_24/U6 FA1S $PINS S=intadd_30/A[2] CO=intadd_24/n5 A=intadd_24/B[1]
+ B=intadd_24/A[1] CI=intadd_24/n6
Xintadd_24/U5 FA1S $PINS S=intadd_30/A[3] CO=intadd_24/n4 A=intadd_24/B[2]
+ B=intadd_24/A[2] CI=intadd_24/n5
Xintadd_24/U4 FA1S $PINS S=intadd_30/A[4] CO=intadd_24/n3 A=intadd_24/B[3]
+ B=intadd_24/A[3] CI=intadd_24/n4
Xintadd_24/U3 FA1S $PINS S=intadd_24/SUM[4] CO=intadd_24/n2 A=intadd_24/B[4]
+ B=intadd_24/A[4] CI=intadd_24/n3
Xintadd_25/U7 FA1S $PINS S=intadd_31/A[1] CO=intadd_25/n6 A=intadd_25/B[0]
+ B=intadd_25/A[0] CI=intadd_25/CI
Xintadd_25/U6 FA1S $PINS S=intadd_31/A[2] CO=intadd_25/n5 A=intadd_25/B[1]
+ B=intadd_25/A[1] CI=intadd_25/n6
Xintadd_25/U5 FA1S $PINS S=intadd_31/A[3] CO=intadd_25/n4 A=intadd_25/B[2]
+ B=intadd_25/A[2] CI=intadd_25/n5
Xintadd_25/U4 FA1S $PINS S=intadd_31/A[4] CO=intadd_25/n3 A=intadd_25/B[3]
+ B=intadd_25/A[3] CI=intadd_25/n4
Xintadd_25/U3 FA1S $PINS S=intadd_25/SUM[4] CO=intadd_25/n2 A=intadd_25/B[4]
+ B=intadd_25/A[4] CI=intadd_25/n3
Xdiv_pos_reg_reg[4] QDFFRBN $PINS Q=div_pos_reg[4] D=FE_OFN4144_div_pos_4
+ CK=CTS_106 RB=FE_OFN146_i_reset_n_i
XIx2_reg[3] QDFFRBN $PINS Q=Ix2[3] D=n1206 CK=CTS_119 RB=FE_OFN106_i_reset_n_i
XIx2_reg[5] QDFFRBN $PINS Q=Ix2[5] D=n1204 CK=CTS_119 RB=FE_OFN65_i_reset_n_i
XIx2_reg[6] QDFFRBN $PINS Q=Ix2[6] D=n1203 CK=CTS_119 RB=FE_OFN65_i_reset_n_i
XIx2_reg[7] QDFFRBN $PINS Q=Ix2[7] D=n1202 CK=CTS_119 RB=FE_OFN65_i_reset_n_i
XIx2_reg[8] QDFFRBN $PINS Q=Ix2[8] D=n1201 CK=CTS_119 RB=FE_OFN65_i_reset_n_i
XIx2_reg[9] QDFFRBN $PINS Q=Ix2[9] D=n1200 CK=CTS_119 RB=FE_OFN32_i_reset_n_i
XIx2_reg[10] QDFFRBN $PINS Q=Ix2[10] D=n1199 CK=CTS_119 RB=FE_OFN32_i_reset_n_i
XIx2_reg[12] QDFFRBN $PINS Q=Ix2[12] D=n1197 CK=CTS_119
+ RB=FE_OFN105_i_reset_n_i
XIx2_reg[13] QDFFRBN $PINS Q=Ix2[13] D=n1196 CK=CTS_119
+ RB=FE_OFN105_i_reset_n_i
XIx2_reg[14] QDFFRBN $PINS Q=Ix2[14] D=n1195 CK=CTS_119
+ RB=FE_OFN105_i_reset_n_i
XIx2_reg[21] QDFFRBN $PINS Q=Ix2[21] D=n1188 CK=CTS_119
+ RB=FE_OFN234_i_reset_n_i
XIxIt_reg[8] QDFFRBN $PINS Q=IxIt[8] D=n1178 CK=CTS_120
+ RB=FE_OFN237_i_reset_n_i
XIxIt_reg[17] QDFFRBN $PINS Q=IxIt[17] D=n1169 CK=CTS_120
+ RB=FE_OFN156_i_reset_n_i
XIxIt_reg[18] QDFFRBN $PINS Q=IxIt[18] D=n1168 CK=CTS_120
+ RB=FE_OFN203_i_reset_n_i
XIxIt_reg[22] QDFFRBN $PINS Q=IxIt[22] D=n1164 CK=CTS_119
+ RB=FE_OFN202_i_reset_n_i
XIy2_reg[3] QDFFRBN $PINS Q=Iy2[3] D=n1160 CK=CTS_120 RB=FE_OFN235_i_reset_n_i
XIy2_reg[4] QDFFRBN $PINS Q=Iy2[4] D=n1159 CK=CTS_120 RB=FE_OFN69_i_reset_n_i
XIy2_reg[5] QDFFRBN $PINS Q=Iy2[5] D=n1158 CK=CTS_120 RB=FE_OFN70_i_reset_n_i
XIy2_reg[6] QDFFRBN $PINS Q=Iy2[6] D=n1157 CK=CTS_120 RB=FE_OFN69_i_reset_n_i
XIy2_reg[7] QDFFRBN $PINS Q=Iy2[7] D=n1156 CK=CTS_120 RB=FE_OFN108_i_reset_n_i
XIy2_reg[8] QDFFRBN $PINS Q=Iy2[8] D=n1155 CK=CTS_124 RB=FE_OFN108_i_reset_n_i
XIy2_reg[9] QDFFRBN $PINS Q=Iy2[9] D=n1154 CK=CTS_124 RB=FE_OFN108_i_reset_n_i
XIy2_reg[10] QDFFRBN $PINS Q=Iy2[10] D=n1153 CK=CTS_124
+ RB=FE_OFN108_i_reset_n_i
XIy2_reg[11] QDFFRBN $PINS Q=Iy2[11] D=n1152 CK=CTS_124
+ RB=FE_OFN108_i_reset_n_i
XIy2_reg[12] QDFFRBN $PINS Q=Iy2[12] D=n1151 CK=CTS_124
+ RB=FE_OFN108_i_reset_n_i
XIy2_reg[13] QDFFRBN $PINS Q=Iy2[13] D=n1150 CK=CTS_124
+ RB=FE_OFN102_i_reset_n_i
XIy2_reg[14] QDFFRBN $PINS Q=Iy2[14] D=n1149 CK=CTS_124
+ RB=FE_OFN102_i_reset_n_i
XIy2_reg[21] QDFFRBN $PINS Q=FE_PHN3287_Iy2_21 D=n1142 CK=CTS_119
+ RB=FE_OFN30_i_reset_n_i
XIxIy_reg[20] QDFFRBN $PINS Q=IxIy[20] D=n1120 CK=CTS_119
+ RB=FE_OFN100_i_reset_n_i
XIxIy_reg[22] QDFFRBN $PINS Q=IxIy[22] D=n1118 CK=CTS_119
+ RB=FE_OFN100_i_reset_n_i
XIyIt_reg[7] QDFFRBN $PINS Q=IyIt[7] D=n1110 CK=CTS_120 RB=FE_OFN70_i_reset_n_i
XIyIt_reg[22] QDFFRBN $PINS Q=IyIt[22] D=n1095 CK=CTS_119
+ RB=FE_OFN30_i_reset_n_i
Xshift_amount_reg_reg[1] QDFFRBP $PINS Q=shift_amount_reg[1] D=shift_amount[1]
+ CK=CTS_124 RB=FE_OFN62_i_reset_n_i
XR_115 QDFFRBN $PINS Q=n4365 D=FE_OFN508_n3751 CK=CTS_134
+ RB=FE_OFN252_i_reset_n_i
Xintadd_35/U2 FA1 $PINS S=intadd_35/SUM[2] CO=intadd_35/n1 A=intadd_35/B[2]
+ B=IxIy[17] CI=intadd_35/n2
XIxIy_reg[6] QDFFRBN $PINS Q=IxIy[6] D=n1134 CK=CTS_114
+ RB=FE_OFN207_i_reset_n_i
Xintadd_1/U2 FA1S $PINS S=intadd_1/SUM[9] CO=intadd_1/n1 A=intadd_1/B[9]
+ B=intadd_1/A[9] CI=intadd_1/n2
Xintadd_0/U2 FA1S $PINS S=intadd_0/SUM[9] CO=intadd_0/n1 A=intadd_0/B[9]
+ B=intadd_0/A[9] CI=intadd_0/n2
Xintadd_23/U2 FA1S $PINS S=intadd_23/SUM[5] CO=intadd_23/n1 A=intadd_23/B[5]
+ B=intadd_34/SUM[0] CI=intadd_23/n2
Xintadd_24/U2 FA1S $PINS S=intadd_24/SUM[5] CO=intadd_24/n1 A=intadd_24/B[5]
+ B=intadd_35/SUM[0] CI=intadd_24/n2
Xintadd_25/U2 FA1S $PINS S=intadd_25/SUM[5] CO=intadd_25/n1 A=intadd_25/B[5]
+ B=intadd_36/SUM[0] CI=intadd_25/n2
Xintadd_11/U3 FA1 $PINS S=intadd_11/SUM[5] CO=intadd_11/n2 A=intadd_9/SUM[3]
+ B=intadd_11/A[5] CI=intadd_11/n3
Xintadd_5/U3 FA1S $PINS S=intadd_5/SUM[5] CO=intadd_5/n2 A=intadd_3/SUM[3]
+ B=intadd_5/A[5] CI=intadd_5/n3
Xintadd_20/U5 FA1 $PINS S=intadd_20/SUM[3] CO=intadd_20/n4 A=intadd_20/B[3]
+ B=intadd_26/SUM[2] CI=intadd_20/n5
Xintadd_7/U3 FA1 $PINS S=intadd_7/SUM[5] CO=intadd_7/n2 A=intadd_7/B[5]
+ B=intadd_6/SUM[3] CI=intadd_7/n3
Xintadd_7/U5 FA1 $PINS S=intadd_7/SUM[3] CO=intadd_7/n4 A=intadd_7/B[3]
+ B=intadd_28/SUM[2] CI=intadd_7/n5
Xintadd_13/U5 FA1 $PINS S=intadd_13/SUM[3] CO=intadd_13/n4 A=intadd_13/B[3]
+ B=intadd_27/SUM[2] CI=intadd_13/n5
Xshift_amount_reg_reg[0] QDFFRBP $PINS Q=shift_amount_reg[0] D=shift_amount[0]
+ CK=CTS_124 RB=FE_OFN62_i_reset_n_i
Xintadd_1/U10 FA1S $PINS S=intadd_1/SUM[1] CO=intadd_1/n9 A=intadd_1/B[1]
+ B=intadd_1/A[1] CI=intadd_1/n10
Xintadd_36/U2 FA1 $PINS S=intadd_36/SUM[2] CO=intadd_36/n1 A=intadd_36/B[2]
+ B=IxIt[17] CI=intadd_36/n2
Xa_reg_reg[2] QDFFRBN $PINS Q=a_reg[2] D=a[2] CK=CTS_107
+ RB=FE_OFN15_i_reset_n_i
Xintadd_27/U2 FA1 $PINS S=intadd_27/SUM[4] CO=intadd_27/n1 A=intadd_27/B[4]
+ B=intadd_27/A[4] CI=intadd_27/n2
Xintadd_12/U5 FA1 $PINS S=intadd_12/SUM[3] CO=intadd_12/n4 A=intadd_12/B[3]
+ B=intadd_11/SUM[2] CI=intadd_12/n5
Xshift_amount_reg_reg[2] QDFFRBN $PINS Q=shift_amount_reg[2] D=n4363 CK=CTS_124
+ RB=FE_OFN62_i_reset_n_i
Xcol_reg_reg[0] QDFFRBN $PINS Q=FE_PHN3289_col_reg_0 D=N590 CK=CTS_124
+ RB=FE_OFN154_i_reset_n_i
Xshift_amount_reg_reg[3] QDFFRBP $PINS Q=shift_amount_reg[3] D=shift_amount[3]
+ CK=CTS_124 RB=FE_OFN62_i_reset_n_i
Xa_reg_reg[0] QDFFRBT $PINS Q=a_reg[0] D=a[0] CK=CTS_131
+ RB=FE_OFN22_i_reset_n_i
Xintadd_28/U2 FA1 $PINS S=intadd_28/SUM[4] CO=intadd_28/n1 A=intadd_28/B[4]
+ B=intadd_28/A[4] CI=intadd_28/n2
Xintadd_26/U2 FA1 $PINS S=intadd_26/SUM[4] CO=intadd_26/n1 A=intadd_26/B[4]
+ B=intadd_26/A[4] CI=intadd_26/n2
XU1425 ND2P $PINS O=n2842 I1=IyIt[18] I2=intadd_34/n1
XU1431 ND3 $PINS O=IxIy_shift[10] I1=n2275 I2=n2882 I3=n2274
XU1432 OAI12H $PINS O=n3530 A1=n3533 B1=n3535 B2=n3532
XU1437 MOAI1S $PINS O=intadd_18/B[0] A1=IxIt[5] A2=n4010 B1=IxIt[5] B2=n4010
XU1448 AOI12H $PINS O=n3380 A1=n2202 B1=n3382 B2=n3691
XU1486 INV1S $PINS O=n1290 I=IxIy[22]
XU1489 INV1S $PINS O=n1293 I=FE_OFN548_IxIt_22
XU1492 INV1S $PINS O=n1296 I=Ix[0][7]
XU1495 INV1S $PINS O=n1299 I=FE_OFN591_IyIt_21
XU1504 INV1S $PINS O=n1308 I=IyIt[8]
XU1507 INV1S $PINS O=n1311 I=FE_OFN598_IyIt_6
XU1510 INV1S $PINS O=n1314 I=IyIt[4]
XU1513 INV1S $PINS O=n1317 I=IyIt[3]
XU1516 INV1S $PINS O=n1320 I=FE_OFN579_IxIy_21
XU1525 INV1S $PINS O=n1329 I=IxIy[7]
XU1528 INV1S $PINS O=n1332 I=IxIy[3]
XU1543 INV1S $PINS O=n1347 I=IxIt[7]
XU1546 INV1S $PINS O=n1350 I=IxIt[6]
XU1549 INV1S $PINS O=n1353 I=IxIt[3]
XU1558 INV1S $PINS O=n1362 I=It[0][7]
XU1564 INV1S $PINS O=n1368 I=Ix2[4]
XU1605 INV1S $PINS O=n1410 I=IxIy[20]
XU1632 NR2 $PINS O=n2356 I1=col_reg[0] I2=n2499
XU1634 MOAI1S $PINS O=n3210 A1=FE_OFN1662_n3611 A2=n4005 B1=FE_OFN558_IxIt_6
+ B2=FE_OFN350_FE_DBTN24_n2351
XU1635 MOAI1S $PINS O=intadd_9/B[0] A1=IxIy[7] A2=n4196 B1=IxIy[7] B2=n4196
XU1636 MOAI1S $PINS O=intadd_10/B[0] A1=IxIy[6] A2=n4187 B1=IxIy[6] B2=n4187
XU1637 FA1S $PINS S=intadd_31/SUM[0] CO=intadd_31/n5 A=intadd_31/B[0]
+ B=intadd_31/A[0] CI=intadd_31/CI
XU1644 NR2 $PINS O=n3205 I1=n2457 I2=n2456
XU1645 INV1S $PINS O=n4212 I=FE_OFN394_intadd_14_SUM_5
XU1648 INV2 $PINS O=n2924 I=FE_OFN801_n2447
XU1654 NR2 $PINS O=n3806 I1=FE_OFN1028_FE_DBTN41_n4489 I2=FE_OCPN1_n1709
XU1655 MOAI1S $PINS O=intadd_32/B[0] A1=n3121 A2=n3120 B1=n3121 B2=n3120
XU1656 INV1S $PINS O=n4257 I=FE_OFN417_intadd_14_SUM_0
XU1657 ND2P $PINS O=Iy2_shift[8] I1=n2817 I2=n2816
XU1661 NR2 $PINS O=n3397 I1=Ix2_Iy2[3] I2=n2188
XU1663 FA1S $PINS S=intadd_21/SUM[5] CO=intadd_21/n2 A=intadd_14/B[5]
+ B=img1[12][6] CI=intadd_21/n3
XU1664 MOAI1 $PINS O=n2556 A1=intadd_0/n1 A2=n2555 B1=intadd_0/n1 B2=n2555
XU1665 FA1S $PINS S=intadd_1/SUM[3] CO=intadd_1/n7 A=intadd_1/B[3]
+ B=intadd_32/SUM[1] CI=intadd_1/n8
XU1666 MOAI1 $PINS O=n4276 A1=n3029 A2=n3027 B1=intadd_28/SUM[4]
+ B2=intadd_7/SUM[5]
XU1667 MOAI1 $PINS O=n2545 A1=n3974 A2=n2235 B1=n3974 B2=n2235
XU1668 AO222 $PINS O=n1079 A1=n3865 A2=FE_OFN1628_n3867 B1=n3863
+ B2=FE_OFN802_n3869 C1=n3861 C2=Vout[10]
XU1669 MOAI1S $PINS O=n1093 A1=n3597 A2=n4329 B1=FE_PHN3218_mul_pos_buffer_0
+ B2=n2853
XU1670 MOAI1S $PINS O=n1190 A1=n2847 A2=n1703 B1=FE_OFN534_Ix2_19
+ B2=FE_OFN939_n4099
XU1672 AN3 $PINS O=n1437 I1=n3208 I2=n3207 I3=n3206
XU1673 AN3 $PINS O=n1438 I1=n3176 I2=n3175 I3=n3174
XU1677 ND2 $PINS O=IxIt_shift[13] I1=n3307 I2=n3306
XU1678 MOAI1S $PINS O=intadd_33/B[0] A1=n4102 A2=n3320 B1=n4102 B2=n3320
XU1679 ND2S $PINS O=n2883 I1=n2881 I2=FE_OFN1043_FE_DBTN2_n2466
XU1680 ND2S $PINS O=n4106 I1=n4257 I2=n4120
XU1681 FA1S $PINS S=intadd_21/SUM[6] CO=intadd_21/n1 A=intadd_14/B[6]
+ B=img1[12][7] CI=intadd_21/n2
XU1682 NR2 $PINS O=n3271 I1=n2492 I2=n2491
XU1683 ND2S $PINS O=n2676 I1=n2471 I2=n2470
XU1684 ND2 $PINS O=n2903 I1=n2801 I2=n2800
XU1686 ND2S $PINS O=n2602 I1=n2461 I2=n2460
XU1687 ND2S $PINS O=n2860 I1=n2514 I2=n2513
XU1688 ND2S $PINS O=n3599 I1=n1712 I2=n1711
XU1689 ND2 $PINS O=n2861 I1=n2517 I2=n2516
XU1690 MOAI1S $PINS O=intadd_3/B[0] A1=IyIt[7] A2=n4271 B1=IyIt[7] B2=n4271
XU1693 ND2S $PINS O=n2340 I1=n2840 I2=FE_OFN758_n1715
XU1695 NR2 $PINS O=n1705 I1=shift_amount_reg[0] I2=FE_DBTN40_shift_amount_reg_1
XU1696 ND2S $PINS O=n3932 I1=col_reg[0] I2=n2498
XU1697 NR2 $PINS O=n2233 I1=img1[12][1] I2=intadd_14/B[0]
XU1698 ND2 $PINS O=n3593 I1=n3591 I2=n3313
XU1700 MOAI1S $PINS O=n4088 A1=intadd_36/SUM[1] A2=n4090 B1=intadd_36/SUM[1]
+ B2=n4090
XU1702 NR2 $PINS O=n3904 I1=n3903 I2=n3901
XU1703 ND2S $PINS O=n4183 I1=n4182 I2=n4181
XU1704 INV2 $PINS O=n3068 I=intadd_12/SUM[5]
XU1705 INV1S $PINS O=n2729 I=intadd_6/SUM[5]
XU1706 ND2S $PINS O=n4015 I1=n4021 I2=n4014
XU1707 ND2S $PINS O=n2723 I1=It[0][1] I2=FE_OFN393_intadd_14_SUM_6
XU1711 ND2S $PINS O=n2601 I1=n3194 I2=FE_DBTN33_shift_amount_reg_3
XU1713 ND2S $PINS O=n3215 I1=n3214 I2=FE_OFN4266_FE_OFN1030_FE_DBTN41_n4489
XU1714 AOI12H $PINS O=n3384 A1=n2199 B1=n3386 B2=n3679
XU1716 ND2S $PINS O=n2871 I1=n2866 I2=FE_OFN682_FE_DBTN33_shift_amount_reg_3
XU1717 ND2S $PINS O=n2927 I1=n3271 I2=FE_OFN1038_FE_DBTN2_n2466
XU1718 AOI22S $PINS O=n1720 A1=n2813 A2=FE_OFN4214_FE_OFN778_n2278
+ B1=FE_OFN795_n2447 B2=n3599
XU1719 ND2S $PINS O=n2929 I1=n2925 I2=FE_OFN681_FE_DBTN33_shift_amount_reg_3
XU1720 MOAI1S $PINS O=intadd_26/B[0] A1=IxIt[3] A2=n3998 B1=IxIt[3] B2=n3998
XU1721 MOAI1S $PINS O=n2673 A1=FE_OFN4358_n A2=IyIt[14] B1=FE_OFN2729_n1710
+ B2=intadd_34/A[0]
XU1722 ND2S $PINS O=n3274 I1=n3228 I2=n3227
XU1723 ND2 $PINS O=n3277 I1=n2758 I2=n2757
XU1724 ND2S $PINS O=n2872 I1=n2796 I2=n2795
XU1725 NR2 $PINS O=n3186 I1=n3109 I2=n3108
XU1726 ND2S $PINS O=n3190 I1=n2683 I2=n2682
XU1727 NR2 $PINS O=n2859 I1=n2522 I2=n2521
XU1728 ND2S $PINS O=n2714 I1=n3628 I2=FE_OFN788_n2278
XU1729 NR2 $PINS O=n2868 I1=n2519 I2=n2518
XU1730 MOAI1S $PINS O=intadd_16/B[0] A1=IxIt[7] A2=n4027 B1=IxIt[7] B2=n4027
XU1732 ND2S $PINS O=n2832 I1=n2693 I2=n2692
XU1733 ND2S $PINS O=n2750 I1=n2488 I2=n2487
XU1736 ND2 $PINS O=n2751 I1=n2490 I2=n2489
XU1738 MOAI1S $PINS O=intadd_11/B[0] A1=IxIy[5] A2=n4179 B1=IxIy[5] B2=n4179
XU1739 OR2 $PINS O=n2351 I1=n2350 I2=n2349
XU1741 MOAI1S $PINS O=n2519 A1=FE_OFN696_FE_DBTN7_n1709 A2=Iy2[17]
+ B1=FE_OFN692_FE_DBTN16_n1710 B2=n2888
XU1747 ND2S $PINS O=n2717 I1=Ix2[22] I2=FE_OFN604_shift_amount_reg_3
XU1748 ND2S $PINS O=n2923 I1=FE_OFN1735_Iy2_22 I2=FE_OFN603_shift_amount_reg_3
XU1749 OR2 $PINS O=n2355 I1=n3932 I2=n2948
XU1750 ND2S $PINS O=n3663 I1=n2194 I2=Ix2_Iy2[6]
XU1751 ND2S $PINS O=n3674 I1=n2197 I2=Ix2_Iy2[8]
XU1752 ND2S $PINS O=n3686 I1=n2200 I2=Ix2_Iy2[10]
XU1753 NR2 $PINS O=n3636 I1=n3633 I2=IxIy2[0]
XU1758 OA112 $PINS O=n4363 A1=n3593 B1=n3595 C1=n3591 C2=n3313
XU1759 MOAI1S $PINS O=n1092 A1=FE_PHN3270_n2898 A2=n4327 B1=n3313 B2=n2900
XU1760 MOAI1S $PINS O=n1094 A1=FE_PHN3229_n2901 A2=n4327 B1=n3591 B2=n2900
XU1761 INV2 $PINS O=n2176 I=n2054
XU1762 ND2 $PINS O=n3589 I1=mul_valid I2=n2852
XU1763 ND2S $PINS O=n3312 I1=mul_valid I2=mul_pos[4]
XU1765 OAI22S $PINS O=n2284 A1=n4237 A2=IxIy[21] B1=n4236 B2=n1320
XU1766 OAI22S $PINS O=n2288 A1=n2287 A2=IxIt[21] B1=n2286 B2=n2448
XU1767 ND3P $PINS O=n4237 I1=n3330 I2=n1410 I3=n4234
XU1768 ND2S $PINS O=n2785 I1=Iy2[21] I2=n2784
XU1769 ND3 $PINS O=n4236 I1=FE_OFN580_IxIy_20 I2=IxIy[19] I3=n2282
XU1770 NR2 $PINS O=n3979 I1=n3977 I2=n3976
XU1771 ND3 $PINS O=n2287 I1=n4096 I2=n4098 I3=n4095
XU1775 ND2S $PINS O=n3619 I1=n3621 I2=FE_OFN1032_FE_DBTN11_n4099
XU1776 NR2 $PINS O=n4096 I1=n1701 I2=n4092
XU1778 NR2P $PINS O=n2282 I1=n4231 I2=n2840
XU1779 ND3 $PINS O=n2286 I1=IxIt[20] I2=FE_OFN551_IxIt_19 I3=n1701
XU1781 ND2S $PINS O=n3621 I1=n2549 I2=n3993
XU1782 AN2 $PINS O=n4232 I1=FE_OFN4268_n4234 I2=n2281
XU1783 ND2S $PINS O=n3094 I1=n3096 I2=FE_OFN1051_FE_DBTN0_n4229
XU1784 ND2S $PINS O=n3620 I1=n3618 I2=FE_PHN3274_Ix2_16
XU1785 ND2S $PINS O=n3096 I1=n2890 I2=FE_OFN818_n4217
XU1786 ND2S $PINS O=n2895 I1=n2894 I2=n2893
XU1787 ND2S $PINS O=n2838 I1=n2837 I2=n2836
XU1788 AN2 $PINS O=n4314 I1=FE_OFN518_n4316 I2=n1694
XU1789 OAI12H $PINS O=n3341 A1=n3800 B1=n3344 B2=n3799
XU1790 ND2S $PINS O=n3095 I1=n3093 I2=n2908
XU1791 ND2 $PINS O=n2837 I1=FE_OFN581_IxIy_18 I2=intadd_35/n1
XU1792 ND2 $PINS O=n2894 I1=FE_OFN4277_IxIt_18 I2=intadd_36/n1
XU1793 OA12 $PINS O=n2263 A1=n2546 B1=n2545 B2=n2707
XU1794 NR2 $PINS O=n3924 I1=n3142 I2=n3140
XU1795 ND2S $PINS O=n3141 I1=n3140 I2=n3926
XU1797 ND2S $PINS O=n2640 I1=n2639 I2=FE_OFN934_n3926
XU1798 ND2 $PINS O=n2639 I1=n3915 I2=n3913
XU1799 ND2S $PINS O=n3131 I1=n3130 I2=FE_OFN934_n3926
XU1801 ND2 $PINS O=n3130 I1=n3912 I2=n3910
XU1802 ND2S $PINS O=n2662 I1=n2661 I2=FE_OFN934_n3926
XU1803 NR2 $PINS O=n3910 I1=n2663 I2=n2661
XU1804 OAI12H $PINS O=n3362 A1=n3742 B1=n3364 B2=n3741
XU1805 ND2S $PINS O=n2748 I1=n2747 I2=FE_OFN935_n3926
XU1806 ND2S $PINS O=n3902 I1=n3901 I2=FE_OFN935_n3926
XU1807 ND2S $PINS O=n2151 I1=n2150 I2=FE_OFN529_n4365
XU1808 ND2S $PINS O=n3896 I1=n3895 I2=FE_OFN935_n3926
XU1809 ND2S $PINS O=intadd_33/A[3] I1=n3302 I2=n4116
XU1810 ND2S $PINS O=n1994 I1=n2025 I2=n2027
XU1811 OR3B2S $PINS O=n2036 I1=n2035 B1=n3845 B2=n3847
XU1812 ND2S $PINS O=n3014 I1=n3013 I2=n3012
XU1813 ND2S $PINS O=n4117 I1=n4116 I2=n4115
XU1814 ND2S $PINS O=n3302 I1=n4118 I2=n4115
XU1815 FA1S $PINS S=n4040 CO=n4049 A=n4038 B=n4037 CI=n4036
XU1816 ND2S $PINS O=n3890 I1=n3889 I2=FE_OFN935_n3926
XU1817 ND2S $PINS O=n2142 I1=n2146 I2=n2138
XU1818 ND2S $PINS O=n3972 I1=n1536 I2=n1575
XU1819 ND2S $PINS O=n4220 I1=FE_OFN389_Ix_0__7 I2=FE_OFN393_intadd_14_SUM_6
XU1820 ND2S $PINS O=n4036 I1=It[4][1] I2=n1536
XU1821 ND2S $PINS O=n4115 I1=n3300 I2=n3301
XU1823 ND2S $PINS O=n4304 I1=FE_OFN387_It_0__7 I2=FE_OFN393_intadd_14_SUM_6
XU1824 ND2S $PINS O=n4082 I1=It[4][7] I2=n1536
XU1825 ND2S $PINS O=n4144 I1=FE_OFN1690_intadd_14_SUM_4
+ I2=FE_OFN393_intadd_14_SUM_6
XU1826 ND2S $PINS O=intadd_32/A[3] I1=n3956 I2=n3309
XU1828 ND2S $PINS O=n4138 I1=FE_OFN421_intadd_14_n1
+ I2=FE_OFN4120_intadd_14_SUM_2
XU1829 ND2S $PINS O=intadd_9/A[5] I1=FE_OFN747_n1439 I2=Ix[0][4]
XU1830 ND2S $PINS O=intadd_10/A[5] I1=FE_OFN747_n1439 I2=Ix[0][3]
XU1831 ND2 $PINS O=intadd_12/A[5] I1=FE_OFN747_n1439 I2=Ix[0][1]
XU1832 ND2S $PINS O=intadd_33/B[3] I1=FE_OFN421_intadd_14_n1 I2=n4257
XU1833 ND2S $PINS O=intadd_29/B[3] I1=FE_OFN387_It_0__7
+ I2=FE_OFN677_FE_DBTN46_intadd_14_SUM_4
XU1834 ND2S $PINS O=intadd_34/B[1] I1=intadd_14/n1 I2=It[0][8]
XU1835 ND2S $PINS O=n3839 I1=n1692 I2=n3831
XU1836 ND2S $PINS O=n4128 I1=FE_OFN421_intadd_14_n1
+ I2=FE_OFN4139_intadd_14_SUM_1
XU1837 ND2S $PINS O=intadd_11/A[5] I1=FE_OFN747_n1439 I2=Ix[0][2]
XU1838 ND2S $PINS O=intadd_8/A[5] I1=FE_OFN747_n1439 I2=Ix[0][5]
XU1840 ND2S $PINS O=intadd_5/A[5] I1=FE_OFN423_intadd_14_n1 I2=It[0][2]
XU1841 ND2S $PINS O=intadd_31/B[4] I1=FE_OFN4274_It_4__7
+ I2=FE_OFN431_intadd_21_SUM_5
XU1842 ND2S $PINS O=intadd_15/A[5] I1=FE_OFN444_intadd_21_n1 I2=It[4][5]
XU1843 ND2S $PINS O=intadd_3/A[5] I1=FE_OFN423_intadd_14_n1 I2=It[0][4]
XU1846 ND2S $PINS O=intadd_16/A[5] I1=FE_OFN444_intadd_21_n1 I2=It[4][4]
XU1847 AOI12H $PINS O=n3693 A1=n3685 B1=n3687 B2=n3686
XU1848 ND2S $PINS O=intadd_6/A[5] I1=FE_OFN423_intadd_14_n1 I2=It[0][1]
XU1849 ND2S $PINS O=intadd_36/B[1] I1=FE_OFN444_intadd_21_n1 I2=It[4][8]
XU1850 ND2S $PINS O=intadd_35/B[1] I1=FE_OFN747_n1439 I2=FE_OFN1760_Ix_0__8
XU1851 ND2S $PINS O=n3878 I1=mul_src[0] I2=FE_OFN935_n3926
XU1852 ND2S $PINS O=intadd_4/A[5] I1=FE_OFN423_intadd_14_n1 I2=It[0][3]
XU1853 ND2S $PINS O=n3884 I1=n3883 I2=FE_OFN935_n3926
XU1854 ND2S $PINS O=intadd_2/A[5] I1=intadd_14/n1 I2=It[0][5]
XU1855 ND2S $PINS O=intadd_32/A[2] I1=FE_OFN443_intadd_21_n1
+ I2=FE_OFN4136_n4336
XU1856 ND2S $PINS O=intadd_18/A[5] I1=FE_OFN444_intadd_21_n1 I2=It[4][2]
XU1857 ND2S $PINS O=intadd_32/B[3] I1=FE_OFN443_intadd_21_n1 I2=n3951
XU1858 ND2S $PINS O=n3102 I1=FE_OFN443_intadd_21_n1
+ I2=FE_OFN678_FE_DBTN45_intadd_21_SUM_1
XU1859 ND2S $PINS O=n3967 I1=intadd_21/n1 I2=n4339
XU1860 ND2S $PINS O=intadd_19/A[5] I1=FE_OFN444_intadd_21_n1 I2=It[4][1]
XU1861 ND2S $PINS O=intadd_17/A[5] I1=FE_OFN444_intadd_21_n1 I2=It[4][3]
XU1862 ND2S $PINS O=n2013 I1=n2011 I2=n4365
XU1863 ND2S $PINS O=n1992 I1=n1990 I2=n4365
XU1864 ND3 $PINS O=IxIt_shift[3] I1=n3217 I2=n3216 I3=n3215
XU1865 ND2S $PINS O=intadd_30/B[4] I1=FE_OFN389_Ix_0__7 I2=n4212
XU1866 ND2S $PINS O=intadd_30/B[3] I1=FE_OFN389_Ix_0__7
+ I2=FE_OFN1690_intadd_14_SUM_4
XU1867 ND2S $PINS O=n2129 I1=n2132 I2=FE_OFN527_n4365
XU1868 OA112 $PINS O=IyIt_shift[7] A1=n2475 B1=n2474 C1=n3251
+ C2=FE_OFN4244_n2466
XU1869 ND2S $PINS O=intadd_29/B[4] I1=FE_OFN387_It_0__7 I2=n4212
XU1870 ND2S $PINS O=intadd_31/B[3] I1=FE_OFN4274_It_4__7 I2=n1575
XU1871 OAI12H $PINS O=n3539 A1=n3542 B1=n3544 B2=n3541
XU1872 ND2S $PINS O=n1641 I1=n3632 I2=n3631
XU1874 ND2 $PINS O=Iy2_shift[7] I1=n3189 I2=n3188
XU1875 ND2S $PINS O=n1622 I1=n3189 I2=n3188
XU1876 ND2 $PINS O=n1626 I1=n1720 I2=n1719
XU1877 AN2P $PINS O=Ix2_shift[4] I1=n2835 I2=n2834
XU1878 AN2 $PINS O=IxIt_shift[7] I1=n2780 I2=n2779
XU1879 ND3 $PINS O=n3238 I1=n3237 I2=n3236 I3=n3235
XU1881 ND2 $PINS O=n3810 I1=n3805 I2=FE_OFN681_FE_DBTN33_shift_amount_reg_3
XU1882 ND2S $PINS O=n2512 I1=n2510 I2=FE_OFN780_n2278
XU1883 OA112 $PINS O=IyIt_shift[15] A1=n2678 B1=n2677 C1=n3251
+ C2=FE_OFN930_n2924
XU1884 OA112P $PINS O=IxIy_shift[5] A1=n2858 B1=n2857 C1=n3116
+ C2=FE_OFN952_n4489
XU1885 OA112 $PINS O=Ix2_shift[15] A1=n2717 B1=n2716 C1=n3136 C2=n2924
XU1886 AN3 $PINS O=Ix2_shift[12] I1=n3267 I2=n3266 I3=n3265
XU1888 OA112 $PINS O=IxIy_shift[4] A1=n2808 B1=n2807 C1=n2879
+ C2=FE_OFN952_n4489
XU1889 ND2S $PINS O=n2173 I1=n2170 I2=n2169
XU1890 ND2S $PINS O=n3206 I1=n3205 I2=FE_OFN4266_FE_OFN1030_FE_DBTN41_n4489
XU1891 ND2S $PINS O=intadd_29/B[2] I1=FE_OFN387_It_0__7 I2=n4120
XU1892 ND2S $PINS O=n2607 I1=n2606 I2=FE_OFN4308_n
XU1893 OR3B2S $PINS O=n1873 I1=n1872 B1=n1871 B2=n1870
XU1894 OR3B2S $PINS O=n1892 I1=n1891 B1=n1890 B2=n1889
XU1895 ND2S $PINS O=n2617 I1=n2856 I2=FE_OFN794_n2447
XU1896 ND2S $PINS O=n4121 I1=FE_OFN405_intadd_14_SUM_3
+ I2=FE_OFN412_intadd_14_SUM_2
XU1898 ND2S $PINS O=n3823 I1=n3822 I2=FE_OFN801_n2447
XU1899 ND2S $PINS O=n1932 I1=n1923 I2=n1922
XU1900 ND2S $PINS O=n2857 I1=n2856 I2=FE_OFN4345_n
XU1901 ND2S $PINS O=n2589 I1=n2643 I2=FE_OFN1043_FE_DBTN2_n2466
XU1903 ND2S $PINS O=n2807 I1=n2880 I2=FE_OFN4345_n
XU1904 OA112 $PINS O=Iy2_shift[14] A1=n2923 B1=n2922 C1=FE_OFN1708_n3177
+ C2=FE_OFN930_n2924
XU1906 ND2S $PINS O=n2702 I1=n3617 I2=FE_OFN681_FE_DBTN33_shift_amount_reg_3
XU1907 ND2S $PINS O=n2115 I1=n2067 I2=n2066
XU1909 ND2S $PINS O=n2677 I1=n2676 I2=FE_OFN790_n2278
XU1910 ND2S $PINS O=n2674 I1=n3244 I2=FE_OFN801_n2447
XU1911 OR3B2S $PINS O=n1731 I1=n1730 B1=n1729 B2=n1728
XU1913 ND2S $PINS O=n1751 I1=n1750 I2=n1749
XU1914 ND2S $PINS O=n2442 I1=n3303 I2=FE_OFN1039_FE_DBTN2_n2466
XU1916 ND2S $PINS O=n3265 I1=n3264 I2=FE_OFN1038_FE_DBTN2_n2466
XU1917 ND2S $PINS O=n2484 I1=n3822 I2=FE_OFN1038_FE_DBTN2_n2466
XU1918 ND2S $PINS O=n2474 I1=n3253 I2=FE_OFN790_n2278
XU1919 ND2S $PINS O=n3279 I1=n3814 I2=FE_DBTN2_n2466
XU1920 ND3 $PINS O=mul_src[0] I1=n2362 I2=n2361 I3=n2360
XU1921 AN3S $PINS O=n3832 I1=n1965 I2=n1964 I3=n1963
XU1922 ND2S $PINS O=n2502 I1=n2602 I2=FE_OFN781_n2278
XU1923 ND2S $PINS O=n3834 I1=n1957 I2=n1956
XU1924 ND3 $PINS O=n3879 I1=n2430 I2=n2429 I3=n2428
XU1925 ND2S $PINS O=n2027 I1=n1989 I2=n1988
XU1927 ND2S $PINS O=n2585 I1=n2676 I2=FE_OFN4324_n
XU1928 ND2S $PINS O=intadd_30/B[2] I1=FE_OFN389_Ix_0__7 I2=n4120
XU1929 ND2S $PINS O=n2444 I1=n3200 I2=FE_DBTN33_shift_amount_reg_3
XU1930 ND2S $PINS O=n1923 I1=n1917 I2=n1916
XU1931 ND2S $PINS O=n2372 I1=FE_OFN482_n2356 I2=Ix2[17]
XU1932 ND2S $PINS O=n2743 I1=n2902 I2=FE_OFN589_IxIy_3
XU1934 ND2S $PINS O=n2752 I1=FE_OFN4209_FE_OFN928_n2902 I2=Ix2[3]
XU1936 ND2S $PINS O=n2389 I1=FE_OFN345_FE_DBTN35_n1689 I2=FE_OFN568_Iy2_12
XU1937 ND2S $PINS O=n2423 I1=FE_OFN484_n2356 I2=Ix2[3]
XU1938 ND2S $PINS O=n3110 I1=n3186 I2=FE_OFN791_n2447
XU1939 ND2S $PINS O=n2503 I1=n3205 I2=FE_OFN794_n2447
XU1940 ND2S $PINS O=n2922 I1=n3323 I2=n2278
XU1941 ND2S $PINS O=n1957 I1=n1953 I2=FE_OFN746_FE_DBTN3_div_pos_reg_4
XU1942 ND2S $PINS O=n1889 I1=n1888 I2=n1916
XU1943 ND2S $PINS O=n2367 I1=FE_OFN482_n2356 I2=FE_OFN534_Ix2_19
XU1944 ND2S $PINS O=n3815 I1=n3814 I2=FE_OFN801_n2447
XU1945 ND2S $PINS O=n1870 I1=n1869 I2=n1916
XU1946 ND2S $PINS O=n2862 I1=FE_OFN4205_FE_OFN928_n2902 I2=FE_OFN577_Iy2_3
XU1947 ND2S $PINS O=n2810 I1=n3211 I2=FE_OFN792_n2447
XU1948 ND2S $PINS O=n2382 I1=FE_OFN345_FE_DBTN35_n1689 I2=FE_OFN566_Iy2_14
XU1949 ND2S $PINS O=n2511 I1=n3126 I2=FE_OFN797_n2447
XU1950 ND2S $PINS O=n2884 I1=n2880 I2=FE_OFN794_n2447
XU1951 ND2S $PINS O=n3235 I1=FE_OFN4209_FE_OFN928_n2902 I2=FE_OFN601_IyIt_3
XU1952 ND2S $PINS O=n3923 I1=FE_OFN482_n2356 I2=Ix2[21]
XU1953 ND2S $PINS O=n2604 I1=n3203 I2=FE_OFN794_n2447
XU1954 ND2S $PINS O=n2274 I1=n3124 I2=FE_OFN797_n2447
XU1955 ND2S $PINS O=n1750 I1=n1743 I2=n1916
XU1957 MAOI1 $PINS O=n2066 A1=FE_OFN1037_FE_DBTN9_n2102 A2=n2065
+ B1=FE_OFN890_FE_DBTN34_n2158 B2=n2064
XU1958 ND2S $PINS O=n3144 I1=n3241 I2=FE_OFN801_n2447
XU1959 ND2S $PINS O=n2401 I1=FE_OFN347_FE_DBTN35_n1689 I2=FE_OFN571_Iy2_9
XU1960 ND2S $PINS O=n2402 I1=FE_OFN484_n2356 I2=FE_OFN541_Ix2_9
XU1961 ND2S $PINS O=n1728 I1=n1727 I2=n1916
XU1962 ND2S $PINS O=n2409 I1=FE_OFN484_n2356 I2=FE_OFN543_Ix2_7
XU1963 ND2S $PINS O=n1760 I1=n2070 I2=FE_OFN746_FE_DBTN3_div_pos_reg_4
XU1964 ND2S $PINS O=n2452 I1=n2809 I2=FE_OFN781_n2278
XU1965 OA112 $PINS O=Ix2_shift[14] A1=n2717 B1=n2714 C1=n3622 C2=n2924
XU1966 ND2S $PINS O=n3196 I1=FE_OFN4205_FE_OFN928_n2902 I2=FE_OFN560_IxIt_3
XU1967 ND2S $PINS O=n2408 I1=FE_OFN347_FE_DBTN35_n1689 I2=FE_OFN573_Iy2_7
XU1968 ND2S $PINS O=n3101 I1=intadd_21/SUM[3] I2=FE_DBTN13_n4339
XU1969 ND2S $PINS O=n2415 I1=FE_OFN484_n2356 I2=FE_OFN545_Ix2_5
XU1970 NR2P $PINS O=n3253 I1=n2473 I2=n2472
XU1971 OA112 $PINS O=Iy2_shift[15] A1=n2923 B1=n2691 C1=n3173
+ C2=FE_OFN930_n2924
XU1972 ND2S $PINS O=n2398 I1=FE_OFN345_FE_DBTN35_n1689 I2=FE_OFN570_Iy2_10
XU1973 ND2S $PINS O=n2645 I1=n2644 I2=FE_OFN780_n2278
XU1974 ND2S $PINS O=n2453 I1=n3214 I2=FE_OFN794_n2447
XU1975 ND2S $PINS O=n2675 I1=n3143 I2=FE_OFN790_n2278
XU1976 ND2S $PINS O=n2716 I1=n3118 I2=FE_OFN788_n2278
XU1977 ND2S $PINS O=n2553 I1=n2643 I2=FE_OFN780_n2278
XU1978 ND2S $PINS O=n4104 I1=n4257 I2=FE_OFN4120_intadd_14_SUM_2
XU1979 MOAI1S $PINS O=n2483 A1=IyIt[15] A2=FE_OFN4186_FE_OFN906_FE_DBTN8_n1705
+ B1=FE_OFN899_FE_DBTN17_n1715 B2=intadd_34/A[1]
XU1983 ND2S $PINS O=n3327 I1=n3326 I2=FE_OFN791_n2447
XU1984 ND2S $PINS O=intadd_30/B[1] I1=FE_OFN389_Ix_0__7
+ I2=FE_OFN4120_intadd_14_SUM_2
XU1985 ND2S $PINS O=n2548 I1=n3993 I2=n2651
XU1986 FA1S $PINS S=intadd_14/SUM[4] CO=intadd_14/n3 A=intadd_14/B[4]
+ B=img1[0][5] CI=intadd_14/n4
XU1987 MOAI1S $PINS O=n2672 A1=IyIt[16] A2=FE_OFN4114_n
+ B1=FE_OFN899_FE_DBTN17_n1715 B2=FE_OFN594_IyIt_17
XU1988 ND2S $PINS O=n1964 I1=n1961 I2=FE_OFN1036_FE_DBTN9_n2102
XU1989 ND2S $PINS O=n1960 I1=n1959 I2=FE_OFN684_FE_DBTN32_div_pos_reg_3
XU1990 NR2 $PINS O=n3261 I1=n2695 I2=n2694
XU1991 ND3 $PINS O=n4243 I1=FE_OFN820_n4217 I2=FE_PHN3227_It_0_0
+ I3=FE_OFN951_n4268
XU1992 ND2S $PINS O=n1749 I1=n1748 I2=FE_OFN1037_FE_DBTN9_n2102
XU1993 ND2S $PINS O=n1922 I1=n1921 I2=FE_OFN1036_FE_DBTN9_n2102
XU1994 ND3 $PINS O=n1806 I1=FE_OFN608_div_pos_reg_3 I2=n1805
+ I3=FE_OFN746_FE_DBTN3_div_pos_reg_4
XU1995 ND2S $PINS O=n2376 I1=FE_OFN488_n2357 I2=IxIt[16]
XU1996 ND2S $PINS O=n2430 I1=IyIt[1] I2=FE_OFN357_FE_DBTN19_n2355
XU1997 ND2S $PINS O=n2362 I1=IyIt[0] I2=FE_OFN357_FE_DBTN19_n2355
XU1998 ND2S $PINS O=n2889 I1=FE_OFN818_n4217 I2=n2888
XU1999 ND2S $PINS O=n2383 I1=FE_OFN486_n2357 I2=IxIt[14]
XU2000 ND2S $PINS O=n2433 I1=n1404 I2=FE_OFN358_FE_DBTN19_n2355
XU2001 ND2S $PINS O=n2390 I1=FE_OFN486_n2357 I2=IxIt[12]
XU2002 ND2S $PINS O=intadd_29/B[1] I1=FE_OFN387_It_0__7
+ I2=FE_OFN4120_intadd_14_SUM_2
XU2003 ND2S $PINS O=n4327 I1=n4329 I2=n3931
XU2004 ND2S $PINS O=n2399 I1=FE_OFN486_n2357 I2=IxIt[10]
XU2006 ND3 $PINS O=n4148 I1=FE_OFN816_n4217 I2=Ix[0][0] I3=FE_OFN949_n4268
XU2007 FA1 $PINS S=intadd_21/SUM[4] CO=intadd_21/n3 A=intadd_14/B[4]
+ B=img1[12][5] CI=intadd_21/n4
XU2008 ND2S $PINS O=n2691 I1=n3184 I2=FE_OFN4141_n2278
XU2010 ND2S $PINS O=n2375 I1=FE_DBTN35_n1689 I2=Iy2[16]
XU2012 ND3 $PINS O=n1864 I1=FE_OFN609_div_pos_reg_2 I2=div_pos_reg[3] I3=n1935
XU2013 ND2S $PINS O=n1949 I1=FE_OFN632_div_pos_reg_1 I2=n1927
XU2014 ND2S $PINS O=n1963 I1=n1962 I2=FE_DBTN3_div_pos_reg_4
XU2016 ND3 $PINS O=n1723 I1=FE_OFN617_div_pos_reg_2 I2=FE_OFN608_div_pos_reg_3
+ I3=n1768
XU2019 ND2S $PINS O=n2269 I1=FE_OFN897_FE_DBTN17_n1715 I2=FE_OFN579_IxIy_21
XU2020 ND2S $PINS O=n2422 I1=FE_OFN347_FE_DBTN35_n1689 I2=FE_OFN577_Iy2_3
XU2021 ND2S $PINS O=n2397 I1=FE_DBTN15_n2359 I2=IxIy[10]
XU2025 ND2S $PINS O=n2414 I1=FE_OFN347_FE_DBTN35_n1689 I2=FE_OFN575_Iy2_5
XU2026 ND2S $PINS O=n3871 I1=n2181 I2=n2180
XU2027 ND2S $PINS O=n2792 I1=n2840 I2=FE_OFN749_n1705
XU2029 ND2S $PINS O=n2551 I1=FE_OFN897_FE_DBTN17_n1715 I2=FE_OFN578_IxIy_22
XU2030 ND2S $PINS O=n2477 I1=n2845 I2=FE_OFN686_FE_DBTN16_n1710
XU2031 ND2S $PINS O=n2381 I1=Ix2[14] I2=FE_OFN484_n2356
XU2032 ND2S $PINS O=n2388 I1=FE_OFN538_Ix2_12 I2=FE_OFN484_n2356
XU2034 ND2S $PINS O=n2666 I1=FE_OFN895_FE_DBTN17_n1715 I2=IyIt[21]
XU2035 ND2S $PINS O=n2374 I1=FE_OFN535_Ix2_16 I2=FE_OFN482_n2356
XU2038 ND2S $PINS O=n2767 I1=n2845 I2=FE_OFN905_FE_DBTN8_n1705
XU2039 ND2S $PINS O=n3762 I1=n3355 I2=n3765
XU2040 ND2S $PINS O=n3785 I1=n3347 I2=n3789
XU2042 ND2S $PINS O=n3750 I1=n3359 I2=n3754
XU2043 ND2S $PINS O=n3739 I1=n3363 I2=n3742
XU2044 ND2S $PINS O=n1859 I1=FE_OFN630_div_pos_reg_1 I2=FE_DBTN32_div_pos_reg_3
XU2045 ND2S $PINS O=n3797 I1=n3343 I2=n3800
XU2046 ND2S $PINS O=n3660 I1=n3391 I2=n3663
XU2047 ND2S $PINS O=n3705 I1=n3375 I2=n3708
XU2049 ND2S $PINS O=n1876 I1=FE_OFN768_n2090 I2=FE_OFN632_div_pos_reg_1
XU2051 ND2S $PINS O=n3774 I1=n3351 I2=n3777
XU2052 ND2S $PINS O=n3694 I1=n3379 I2=n3697
XU2053 FA1 $PINS S=intadd_21/SUM[1] CO=intadd_21/n6 A=intadd_14/B[1]
+ B=img1[12][2] CI=intadd_21/n7
XU2054 ND2S $PINS O=n3716 I1=n3371 I2=n3720
XU2055 ND2S $PINS O=n3728 I1=n3367 I2=n3731
XU2056 OR2 $PINS O=n2102 I1=FE_OFN746_FE_DBTN3_div_pos_reg_4
+ I2=FE_OFN685_FE_DBTN32_div_pos_reg_3
XU2057 ND2S $PINS O=n3671 I1=n3387 I2=n3674
XU2058 ND2S $PINS O=n2465 I1=n2845 I2=FE_OFN895_FE_DBTN17_n1715
XU2059 ND2S $PINS O=n3682 I1=n3383 I2=n3686
XU2061 ND3 $PINS O=n2084 I1=div_pos_reg[4] I2=FE_OFN685_FE_DBTN32_div_pos_reg_3
+ I3=FE_OFN768_n2090
XU2063 ND3 $PINS O=n1693 I1=n2947 I2=n2177 I3=n2966
XU2064 ND2S $PINS O=n3500 I1=n3498 I2=n3497
XU2065 ND2S $PINS O=n3665 I1=n3668 I2=n3389
XU2066 ND2S $PINS O=n3791 I1=n3794 I2=n3345
XU2067 ND2S $PINS O=n3676 I1=n3679 I2=n3385
XU2068 ND2S $PINS O=n3342 I1=n3340 I2=n3339
XU2069 ND2S $PINS O=n3409 I1=n3407 I2=n3406
XU2070 ND2S $PINS O=n3756 I1=n3759 I2=n3357
XU2071 ND2S $PINS O=n3744 I1=n3747 I2=n3361
XU2072 ND2S $PINS O=n3688 I1=n3691 I2=n3381
XU2073 ND2S $PINS O=n3699 I1=n3702 I2=n3377
XU2074 ND2S $PINS O=n3733 I1=n3736 I2=n3365
XU2075 ND2S $PINS O=n3779 I1=n3782 I2=n3349
XU2076 ND2S $PINS O=n3722 I1=n3725 I2=n3369
XU2077 ND2S $PINS O=n3710 I1=n3713 I2=n3373
XU2078 ND2S $PINS O=n3767 I1=n3771 I2=n3353
XU2079 XNR2HS $PINS O=n4337 I1=n2237 I2=n2236
XU2081 ND2S $PINS O=n2501 I1=FE_OFN548_IxIt_22 I2=FE_OFN603_shift_amount_reg_3
XU2089 OR2 $PINS O=n2359 I1=n2948 I2=n2947
XU2090 ND2S $PINS O=n3697 I1=n2203 I2=Ix2_Iy2[12]
XU2091 ND2S $PINS O=n3708 I1=n2206 I2=Ix2_Iy2[14]
XU2092 ND2S $PINS O=n3345 I1=n2228 I2=Ix2_Iy2[29]
XU2093 ND2S $PINS O=n3339 I1=IxIy2[31] I2=n2231
XU2095 ND2S $PINS O=n3349 I1=n2225 I2=Ix2_Iy2[27]
XU2096 ND2S $PINS O=n3720 I1=n2209 I2=Ix2_Iy2[16]
XU2097 ND3 $PINS O=n2966 I1=n3873 I2=col_reg[1] I3=n3872
XU2098 ND2S $PINS O=n3393 I1=n2192 I2=Ix2_Iy2[5]
XU2099 ND2S $PINS O=n3389 I1=n2195 I2=Ix2_Iy2[7]
XU2100 ND2S $PINS O=n3385 I1=n2198 I2=Ix2_Iy2[9]
XU2101 ND2S $PINS O=n3381 I1=n2201 I2=Ix2_Iy2[11]
XU2102 ND2S $PINS O=n3377 I1=n2204 I2=Ix2_Iy2[13]
XU2103 ND2S $PINS O=n3373 I1=n2207 I2=Ix2_Iy2[15]
XU2104 ND2S $PINS O=n3369 I1=n2210 I2=Ix2_Iy2[17]
XU2105 ND2S $PINS O=n3365 I1=n2213 I2=Ix2_Iy2[19]
XU2106 ND2S $PINS O=n3361 I1=n2216 I2=Ix2_Iy2[21]
XU2107 ND2S $PINS O=n3357 I1=n2219 I2=Ix2_Iy2[23]
XU2108 ND2S $PINS O=n3353 I1=n2222 I2=Ix2_Iy2[25]
XU2109 ND2S $PINS O=n3424 I1=n2311 I2=IxIy_IyIt[15]
XU2110 ND2S $PINS O=n3510 I1=n2336 I2=IxIy_IxIt[16]
XU2111 ND2S $PINS O=n3419 I1=n2312 I2=IxIy_IyIt[16]
XU2112 ND2S $PINS O=n3515 I1=n2335 I2=IxIy_IxIt[15]
XU2113 ND2S $PINS O=n3415 I1=n2531 I2=IxIy_IyIt[18]
XU2114 ND2S $PINS O=n3519 I1=n2333 I2=IxIy_IxIt[14]
XU2116 ND2S $PINS O=n3524 I1=n2332 I2=IxIy_IxIt[13]
XU2117 ND2S $PINS O=n3528 I1=n2330 I2=IxIy_IxIt[12]
XU2119 ND2S $PINS O=n3411 I1=n2623 I2=IxIy_IyIt[23]
XU2122 ND2S $PINS O=n3533 I1=n2329 I2=IxIy_IxIt[11]
XU2124 ND2S $PINS O=n3537 I1=n2327 I2=IxIy_IxIt[10]
XU2128 ND2S $PINS O=n3406 I1=n3285 I2=IxIy_IyIt[28]
XU2129 ND2S $PINS O=n3542 I1=n2326 I2=IxIy_IxIt[9]
XU2130 ND2S $PINS O=n3546 I1=n2324 I2=IxIy_IxIt[8]
XU2132 ND2S $PINS O=n3551 I1=n2323 I2=IxIy_IxIt[7]
XU2134 AN2 $PINS O=n2158 I1=div_pos_reg[3] I2=FE_DBTN3_div_pos_reg_4
XU2135 ND2S $PINS O=n3555 I1=n2321 I2=IxIy_IxIt[6]
XU2136 ND2S $PINS O=n3560 I1=n2320 I2=IxIy_IxIt[5]
XU2138 ND2S $PINS O=n3564 I1=n2318 I2=IxIy_IxIt[4]
XU2139 ND2S $PINS O=n1950 I1=FE_OFN654_div_pos_reg_0 I2=Ux_pad[8]
XU2140 ND2S $PINS O=n3569 I1=n2317 I2=IxIy_IxIt[3]
XU2143 ND2S $PINS O=n3497 I1=n3293 I2=IxIy_IxIt[28]
XU2146 ND2S $PINS O=n3502 I1=n2627 I2=IxIy_IxIt[23]
XU2147 ND2S $PINS O=n3478 I1=n2293 I2=IxIy_IyIt[3]
XU2148 ND2S $PINS O=n3473 I1=n2294 I2=IxIy_IyIt[4]
XU2149 ND2S $PINS O=n3469 I1=n2296 I2=IxIy_IyIt[5]
XU2150 ND2S $PINS O=n3464 I1=n2297 I2=IxIy_IyIt[6]
XU2151 ND2S $PINS O=n3460 I1=n2299 I2=IxIy_IyIt[7]
XU2152 ND2S $PINS O=n3455 I1=n2300 I2=IxIy_IyIt[8]
XU2153 ND2S $PINS O=n3451 I1=n2302 I2=IxIy_IyIt[9]
XU2154 ND2S $PINS O=n3446 I1=n2303 I2=IxIy_IyIt[10]
XU2155 ND2S $PINS O=n3442 I1=n2305 I2=IxIy_IyIt[11]
XU2156 ND2S $PINS O=n3437 I1=n2306 I2=IxIy_IyIt[12]
XU2157 ND2S $PINS O=n3506 I1=n2527 I2=IxIy_IxIt[18]
XU2158 ND2S $PINS O=n3433 I1=n2308 I2=IxIy_IyIt[13]
XU2159 ND2S $PINS O=n3428 I1=n2309 I2=IxIy_IyIt[14]
XU2160 ND2S $PINS O=n3777 I1=n2224 I2=Ix2_Iy2[26]
XU2161 ND2S $PINS O=n3765 I1=n2221 I2=Ix2_Iy2[24]
XU2162 ND2S $PINS O=n3789 I1=n2227 I2=Ix2_Iy2[28]
XU2163 ND2S $PINS O=n3754 I1=n2218 I2=Ix2_Iy2[22]
XU2164 ND2S $PINS O=n3742 I1=n2215 I2=Ix2_Iy2[20]
XU2165 ND2S $PINS O=n3731 I1=n2212 I2=Ix2_Iy2[18]
XU2180 ND2S $PINS O=n1796 I1=FE_OFN655_div_pos_reg_0 I2=Uy_pad[8]
XU2215 INV1S $PINS O=n1474 I=FE_OFN4277_IxIt_18
XU2236 INV1S $PINS O=n1495 I=FE_OFN443_intadd_21_n1
XU2270 INV1S $PINS O=n1536 I=FE_OFN428_intadd_21_SUM_6
XU2307 INV1S $PINS O=n1575 I=FE_OFN434_intadd_21_SUM_4
XU2354 NR2 $PINS O=n2434 I1=n3924 I2=n3930
XU2357 ND2 $PINS O=Iy2_shift[4] I1=n1720 I2=n1719
XU2359 MOAI1S $PINS O=n2695 A1=Ix2[14] A2=FE_OFN908_FE_DBTN8_n1705
+ B1=FE_OFN2727_FE_DBTN17_n1715 B2=n2707
XU2360 MOAI1S $PINS O=n2267 A1=IxIy[16] A2=FE_OFN2730_FE_DBTN8_n1705
+ B1=FE_OFN4248_FE_OFN758_n1715 B2=FE_OFN582_IxIy_17
XU2374 ND2 $PINS O=n1640 I1=n3632 I2=n3631
XU2375 ND3 $PINS O=Iy2_shift[2] I1=n3165 I2=n3164 I3=n3163
XU2394 ND3 $PINS O=n1658 I1=n2444 I2=n2443 I3=n2442
XU2395 ND3 $PINS O=IxIt_shift[9] I1=n2444 I2=n2443 I3=n2442
XU2397 XOR2HS $PINS O=n4339 I1=n2238 I2=intadd_21/n6
XU2406 ND3 $PINS O=n1668 I1=n3223 I2=n3328 I3=n3222
XU2407 ND3 $PINS O=Iy2_shift[12] I1=n3223 I2=n3328 I3=n3222
XU2408 NR2 $PINS O=n4099 I1=FE_OFN517_n4245 I2=n3993
XU2413 MOAI1S $PINS O=n1168 A1=FE_OFN1032_FE_DBTN11_n4099 A2=n1474 B1=n3993
+ B2=n2896
XU2421 FA1P $PINS S=intadd_14/SUM[6] CO=intadd_14/n1 A=intadd_14/B[6]
+ B=img1[0][7] CI=intadd_14/n2
XU2430 OR2 $PINS O=n1686 I1=img1[12][3] I2=intadd_14/B[2]
XU2431 AO22 $PINS O=n1687 A1=img1[12][3] A2=intadd_14/B[2] B1=intadd_21/n6
+ B2=n1686
XU2432 OR2 $PINS O=n1688 I1=FE_DBTN4_n1819 I2=FE_OFN616_div_pos_reg_2
XU2433 OR2 $PINS O=n1689 I1=n2966 I2=n2358
XU2434 AN2 $PINS O=n1690 I1=FE_OFN607_div_pos_reg_4
+ I2=FE_OFN685_FE_DBTN32_div_pos_reg_3
XU2435 NR2 $PINS O=n1691 I1=FE_OFN893_FE_DBTN18_n1690 I2=n2157
XU2436 ND3 $PINS O=n1692 I1=n1760 I2=FE_OFN744_FE_DBTN4_n1819 I3=n1759
XU2437 NR2 $PINS O=n3907 I1=n2749 I2=n2747
XU2440 MOAI1S $PINS O=n2492 A1=FE_OCPN0_n1709 A2=Ix2[17]
+ B1=FE_OFN686_FE_DBTN16_n1710 B2=n2651
XU2442 AOI22S $PINS O=n2830 A1=FE_OFN2727_FE_DBTN17_n1715 A2=FE_OFN543_Ix2_7
+ B1=FE_OFN4253_FE_DBTN8_n1705 B2=FE_OFN544_Ix2_6
XU2443 NR2 $PINS O=n3822 I1=n2483 I2=n2482
XU2444 MOAI1S $PINS O=n2761 A1=IyIt[14] A2=FE_OFN4114_n
+ B1=FE_OFN899_FE_DBTN17_n1715 B2=intadd_34/A[0]
XU2445 NR2 $PINS O=n2644 I1=n2347 I2=n2346
XU2447 AOI22S $PINS O=n1712 A1=FE_OFN4234_FE_OFN899_FE_DBTN17_n1715
+ A2=FE_OFN573_Iy2_7 B1=FE_OFN4195_FE_OFN910_FE_DBTN8_n1705 B2=FE_OFN574_Iy2_6
XU2448 MOAI1S $PINS O=n3209 A1=n3614 A2=n4011 B1=FE_OFN354_FE_DBTN23_n4483
+ B2=IxIt[3]
XU2449 OAI12H $PINS O=n3675 A1=n3668 B1=n3670 B2=n3669
XU2450 MOAI1S $PINS O=mul_src_abs[15] A1=n3132 A2=n3131 B1=n3132 B2=n3131
XU2452 AOI12HS $PINS O=n3796 A1=n3788 B1=n3790 B2=n3789
XU2458 NR2 $PINS O=n3814 I1=n2761 I2=n2760
XU2459 MOAI1S $PINS O=n2806 A1=IxIy[14] A2=FE_OFN909_FE_DBTN8_n1705
+ B1=FE_OFN4248_FE_OFN758_n1715 B2=intadd_35/A[0]
XU2460 ND3 $PINS O=IxIt_shift[12] I1=n2608 I2=n2811 I3=n2607
XU2461 NR2 $PINS O=n3214 I1=n2446 I2=n2445
XU2462 NR2 $PINS O=n3217 I1=n3210 I2=n3209
XU2464 MOAI1S $PINS O=mul_src_abs[19] A1=n3142 A2=n3141 B1=n3142 B2=n3141
XU2467 AOI22S $PINS O=n3613 A1=Ix2[3] A2=FE_OFN349_FE_DBTN24_n2351 B1=n3610
+ B2=FE_OFN786_n2278
XU2468 ND2 $PINS O=Iy2_shift[6] I1=n3181 I2=n3180
XU2469 ND3 $PINS O=IyIt_shift[10] I1=n3145 I2=n3811 I3=n3144
XU2470 ND3P $PINS O=IyIt_shift[3] I1=n3258 I2=n3257 I3=n3256
XU2471 NR2 $PINS O=n2880 I1=n2806 I2=n2805
XU2472 ND3P $PINS O=IxIt_shift[10] I1=n2605 I2=n2811 I3=n2604
XU2475 AO112 $PINS O=Ix2_shift[10] A1=n3248 B1=n3262 C1=FE_OFN800_n2447
+ C2=n3625
XU2476 ND2 $PINS O=n3136 I1=n2653 I2=n2652
XU2477 ND3 $PINS O=IyIt_shift[14] I1=n2675 I2=n2678 I3=n2674
XU2478 INV1S $PINS O=n2187 I=IxIy2[2]
XU2479 MOAI1S $PINS O=n2968 A1=n2242 A2=n3949 B1=n2242 B2=n3949
XU2482 AO12 $PINS O=IxIy_shift[0] A1=n2906 B1=n2907
+ B2=FE_OFN602_shift_amount_reg_3
XU2483 INV1S $PINS O=n3634 I=Ix2_Iy2[1]
XU2484 MOAI1 $PINS O=intadd_21/n7 A1=n2237 A2=n2233 B1=img1[12][1]
+ B2=intadd_14/B[0]
XU2485 FA1 $PINS S=intadd_7/SUM[6] CO=intadd_7/n1 A=intadd_28/n1
+ B=intadd_6/SUM[4] CI=intadd_7/n2
XU2486 NR2P $PINS O=n3093 I1=n2579 I2=n2578
XU2487 MOAI1 $PINS O=n2781 A1=n4146 A2=n2556 B1=n4146 B2=n2556
XU2489 OAI12H $PINS O=n3378 A1=n3697 B1=n3380 B2=n3696
XU2490 AOI12H $PINS O=n3364 A1=n2214 B1=n3366 B2=n3736
XU2491 OAI12H $PINS O=n3346 A1=n3789 B1=n3348 B2=n3788
XU2492 XNR2HS $PINS O=n2285 I1=FE_OFN578_IxIy_22 I2=n2284
XU2493 XNR2HS $PINS O=n2289 I1=FE_PHN3195_IxIt_22 I2=n2288
XU2494 XNR2HS $PINS O=n1704 I1=IxIt[21] I2=n1702
XU2495 ND3 $PINS O=n2549 I1=n3618 I2=Ix2[16] I3=Ix2[17]
XU2498 AOI12H $PINS O=n3453 A1=n2301 B1=n3457 B2=n3456
XU2499 AOI12H $PINS O=n3435 A1=n2307 B1=n3439 B2=n3438
XU2500 AOI12H $PINS O=n3544 A1=n2325 B1=n3548 B2=n3547
XU2501 MOAI1 $PINS O=n1118 A1=FE_OFN449_n1693 A2=n2285 B1=FE_OFN944_n4229
+ B2=FE_OFN578_IxIy_22
XU2502 MOAI1 $PINS O=n1164 A1=FE_OFN456_n1703 A2=n2289 B1=FE_OFN938_n4099
+ B2=FE_PHN3195_IxIt_22
XU2503 MOAI1S $PINS O=n1099 A1=FE_OFN1051_FE_DBTN0_n4229 A2=n2845
+ B1=FE_OFN818_n4217 B2=n2844
XU2504 MOAI1S $PINS O=n1122 A1=FE_OFN1051_FE_DBTN0_n4229 A2=n2840
+ B1=FE_OFN818_n4217 B2=n2839
XU2505 OAI22S $PINS O=n1165 A1=FE_OFN456_n1703 A2=n1704
+ B1=FE_OFN1032_FE_DBTN11_n4099 B2=n2448
XU2506 MOAI1S $PINS O=n1187 A1=n2265 A2=FE_OFN456_n1703 B1=FE_OFN939_n4099
+ B2=Ix2[22]
XU2507 NR3 $PINS O=n2498 I1=col_reg[3] I2=col_reg[2] I3=col_reg[1]
XU2508 INV1S $PINS O=n3872 I=col_reg[0]
XU2510 OR3 $PINS O=n2177 I1=row_reg[2] I2=row_reg[1] I3=row_reg[3]
XU2511 NR2 $PINS O=n3873 I1=col_reg[3] I2=n4362
XU2512 INV1S $PINS O=n4217 I=FE_OFN450_n1693
XU2514 INV1S $PINS O=n4316 I=IyIt[19]
XU2516 NR2P $PINS O=n4313 I1=FE_OFN518_n4316 I2=n1694
XU2518 NR2P $PINS O=n1695 I1=n4313 I2=n2845
XU2519 NR2 $PINS O=n3335 I1=n4314 I2=n1695
XU2520 INV1S $PINS O=n3337 I=IyIt[20]
XU2521 ND3 $PINS O=n4321 I1=n3335 I2=n3337 I3=n4316
XU2524 ND3 $PINS O=n4320 I1=FE_OFN592_IyIt_20 I2=IyIt[19] I3=n1695
XU2525 OAI22S $PINS O=n1697 A1=n4321 A2=FE_OFN591_IyIt_21 B1=n4320 B2=n1299
XU2526 MOAI1 $PINS O=n1698 A1=n1404 A2=n1697 B1=n1404 B2=n1697
XU2527 OR2 $PINS O=n2948 I1=row_reg[0] I2=n2177
XU2528 NR2 $PINS O=n4245 I1=n2948 I2=n2966
XU2529 NR2 $PINS O=n4229 I1=FE_OFN517_n4245 I2=FE_OFN819_n4217
XU2532 MOAI1 $PINS O=n1095 A1=FE_OFN451_n1693 A2=n1698 B1=FE_OFN944_n4229
+ B2=n1404
XU2533 ND2 $PINS O=n4334 I1=row_reg[2] I2=row_reg[1]
XU2534 NR3 $PINS O=n4331 I1=row_reg[0] I2=row_reg[3] I3=n4334
XU2535 OR2B1S $PINS O=n1699 I1=n2498 B1=n2948
XU2536 OR2 $PINS O=n1703 I1=n4331 I2=n1699
XU2539 INV1S $PINS O=n4095 I=IxIt[19]
XU2541 MOAI1H $PINS O=n1700 A1=FE_OFN4277_IxIt_18 A2=intadd_36/n1 B1=IxIt[17]
+ B2=n2894
XU2542 NR2P $PINS O=n4091 I1=n4095 I2=n1700
XU2544 AN2 $PINS O=n4092 I1=n4095 I2=n1700
XU2545 INV1S $PINS O=n4098 I=IxIt[20]
XU2546 ND2S $PINS O=n1702 I1=n2287 I2=n2286
XU2547 INV1S $PINS O=n3993 I=FE_OFN461_n1703
XU2548 INV1S $PINS O=n2448 I=IxIt[21]
XU2551 OR2 $PINS O=n1715 I1=FE_DBTN40_shift_amount_reg_1 I2=n2350
XU2552 AOI22S $PINS O=n1708 A1=FE_OFN761_n1715 A2=FE_OFN569_Iy2_11
+ B1=FE_OFN910_FE_DBTN8_n1705 B2=FE_OFN570_Iy2_10
XU2553 NR2P $PINS O=n1709 I1=shift_amount_reg[1] I2=shift_amount_reg[0]
XU2554 OR2 $PINS O=n1710 I1=shift_amount_reg[1] I2=n2350
XU2557 AOI22S $PINS O=n1707 A1=FE_OCPN4373_n1709 A2=FE_OFN572_Iy2_8
+ B1=FE_OFN2728_FE_DBTN16_n1710 B2=FE_OFN571_Iy2_9
XU2559 INV1S $PINS O=n1718 I=FE_OFN605_shift_amount_reg_2
XU2560 NR2T $PINS O=n2278 I1=FE_OFN603_shift_amount_reg_3 I2=n1718
XU2563 NR2F $PINS O=n2447 I1=shift_amount_reg[3]
+ I2=FE_OFN605_shift_amount_reg_2
XU2568 AOI22S $PINS O=n1711 A1=FE_OFN2738_FE_DBTN7_n1709 A2=Iy2[4]
+ B1=FE_OFN693_FE_DBTN16_n1710 B2=FE_OFN575_Iy2_5
XU2570 MOAI1S $PINS O=n1714 A1=FE_OFN566_Iy2_14 A2=FE_OFN907_FE_DBTN8_n1705
+ B1=FE_OFN761_n1715 B2=n2911
XU2572 OAI22S $PINS O=n1713 A1=FE_OFN567_Iy2_13 A2=FE_OFN475_n1710
+ B1=FE_OFN2734_FE_DBTN7_n1709 B2=FE_OFN568_Iy2_12
XU2573 NR2 $PINS O=n3219 I1=n1714 I2=n1713
XU2574 OR2P $PINS O=n2466 I1=FE_OFN605_shift_amount_reg_2
+ I2=FE_DBTN33_shift_amount_reg_3
XU2577 OAI22S $PINS O=n1717 A1=Iy2[17] A2=FE_OFN4197_FE_OFN479_n1710
+ B1=FE_OFN696_FE_DBTN7_n1709 B2=n2908
XU2578 OAI22S $PINS O=n1716 A1=FE_OFN564_Iy2_19 A2=FE_OFN764_n1715 B1=Iy2[18]
+ B2=FE_OFN4188_FE_OFN906_FE_DBTN8_n1705
XU2579 NR2 $PINS O=n3218 I1=n1717 I2=n1716
XU2581 AOI22S $PINS O=n1719 A1=n3219 A2=FE_OFN1040_FE_DBTN2_n2466 B1=n3218
+ B2=FE_DBTN41_n4489
XU2582 INV1S $PINS O=n2090 I=div_pos_reg[2]
XU2586 AOI22S $PINS O=n1741 A1=FE_OFN720_FE_DBTN6_div_pos_reg_0 A2=Uy_pad[24]
+ B1=FE_OFN661_div_pos_reg_0 B2=Uy_pad[25]
XU2588 AOI22S $PINS O=n1739 A1=FE_OFN720_FE_DBTN6_div_pos_reg_0 A2=Uy_pad[22]
+ B1=FE_OFN661_div_pos_reg_0 B2=Uy_pad[23]
XU2590 AOI22S $PINS O=n1769 A1=FE_OFN639_div_pos_reg_1 A2=n1741 B1=n1739
+ B2=FE_OFN739_FE_DBTN5_div_pos_reg_1
XU2593 AOI22S $PINS O=n2074 A1=FE_OFN723_FE_DBTN6_div_pos_reg_0 A2=Uy_pad[36]
+ B1=FE_OFN665_div_pos_reg_0 B2=Uy_pad[37]
XU2594 AOI22S $PINS O=n1747 A1=FE_OFN722_FE_DBTN6_div_pos_reg_0 A2=Uy_pad[34]
+ B1=FE_OFN665_div_pos_reg_0 B2=Uy_pad[35]
XU2596 AOI22S $PINS O=n2122 A1=FE_OFN644_div_pos_reg_1 A2=n2074 B1=n1747
+ B2=FE_OFN743_FE_DBTN5_div_pos_reg_1
XU2597 AOI22S $PINS O=n1746 A1=FE_OFN722_FE_DBTN6_div_pos_reg_0 A2=Uy_pad[32]
+ B1=FE_OFN664_div_pos_reg_0 B2=Uy_pad[33]
XU2599 AOI22S $PINS O=n1745 A1=FE_OFN722_FE_DBTN6_div_pos_reg_0 A2=Uy_pad[30]
+ B1=FE_OFN663_div_pos_reg_0 B2=Uy_pad[31]
XU2600 AOI22S $PINS O=n1775 A1=FE_OFN642_div_pos_reg_1 A2=n1746 B1=n1745
+ B2=FE_OFN742_FE_DBTN5_div_pos_reg_1
XU2601 AOI22S $PINS O=n1721 A1=FE_OFN624_div_pos_reg_2 A2=n2122 B1=n1775
+ B2=FE_OFN773_n2090
XU2602 MOAI1S $PINS O=n1730 A1=FE_OFN923_n2084 A2=n1769
+ B1=FE_OFN1037_FE_DBTN9_n2102 B2=n1721
XU2604 INV1S $PINS O=n1927 I=n2099
XU2605 AOI22S $PINS O=n1734 A1=FE_OFN715_FE_DBTN6_div_pos_reg_0 A2=Uy_pad[12]
+ B1=FE_OFN657_div_pos_reg_0 B2=Uy_pad[13]
XU2608 AOI22S $PINS O=n1736 A1=FE_OFN715_FE_DBTN6_div_pos_reg_0 A2=Uy_pad[10]
+ B1=FE_OFN655_div_pos_reg_0 B2=Uy_pad[11]
XU2609 AOI22S $PINS O=n1770 A1=FE_OFN633_div_pos_reg_1 A2=n1734 B1=n1736
+ B2=FE_OFN734_FE_DBTN5_div_pos_reg_1
XU2612 AOI22S $PINS O=n1772 A1=FE_OFN713_FE_DBTN6_div_pos_reg_0 A2=Uy_pad[8]
+ B1=FE_OFN655_div_pos_reg_0 B2=Uy_pad[9]
XU2614 AOI22S $PINS O=n1732 A1=FE_OFN718_FE_DBTN6_div_pos_reg_0 A2=Uy_pad[16]
+ B1=FE_OFN657_div_pos_reg_0 B2=Uy_pad[17]
XU2615 AOI22S $PINS O=n1735 A1=FE_OFN715_FE_DBTN6_div_pos_reg_0 A2=Uy_pad[14]
+ B1=FE_OFN657_div_pos_reg_0 B2=Uy_pad[15]
XU2617 AOI22S $PINS O=n1771 A1=FE_OFN638_div_pos_reg_1 A2=n1732 B1=n1735
+ B2=FE_OFN735_FE_DBTN5_div_pos_reg_1
XU2618 MOAI1S $PINS O=n1722 A1=n1772 A2=n1859 B1=FE_OFN608_div_pos_reg_3
+ B2=n1771
XU2619 AOI22S $PINS O=n1724 A1=n1927 A2=n1770 B1=FE_OFN770_n2090 B2=n1722
XU2620 AOI22S $PINS O=n1738 A1=FE_OFN719_FE_DBTN6_div_pos_reg_0 A2=Uy_pad[20]
+ B1=FE_OFN658_div_pos_reg_0 B2=Uy_pad[21]
XU2621 AOI22S $PINS O=n1733 A1=FE_OFN718_FE_DBTN6_div_pos_reg_0 A2=Uy_pad[18]
+ B1=FE_OFN658_div_pos_reg_0 B2=Uy_pad[19]
XU2622 AOI22S $PINS O=n1768 A1=FE_OFN639_div_pos_reg_1 A2=n1738 B1=n1733
+ B2=FE_OFN739_FE_DBTN5_div_pos_reg_1
XU2623 ND3 $PINS O=n1729 I1=n1724 I2=FE_OFN746_FE_DBTN3_div_pos_reg_4 I3=n1723
XU2624 AOI22S $PINS O=n1744 A1=FE_OFN721_FE_DBTN6_div_pos_reg_0 A2=Uy_pad[28]
+ B1=FE_OFN663_div_pos_reg_0 B2=Uy_pad[29]
XU2625 AOI22S $PINS O=n1742 A1=FE_OFN721_FE_DBTN6_div_pos_reg_0 A2=Uy_pad[26]
+ B1=FE_OFN661_div_pos_reg_0 B2=Uy_pad[27]
XU2626 AOI22S $PINS O=n1774 A1=FE_OFN642_div_pos_reg_1 A2=n1744 B1=n1742
+ B2=FE_OFN741_FE_DBTN5_div_pos_reg_1
XU2627 INV1S $PINS O=n1727 I=n1774
XU2628 INV1S $PINS O=n1916 I=n2107
XU2629 INV1S $PINS O=n2082 I=n1731
XU2632 AOI22S $PINS O=n1757 A1=FE_OFN638_div_pos_reg_1 A2=n1733 B1=n1732
+ B2=FE_OFN735_FE_DBTN5_div_pos_reg_1
XU2634 AOI22S $PINS O=n1753 A1=FE_OFN633_div_pos_reg_1 A2=n1735 B1=n1734
+ B2=FE_OFN734_FE_DBTN5_div_pos_reg_1
XU2636 AOI22S $PINS O=n1737 A1=FE_OFN619_div_pos_reg_2 A2=n1757 B1=n1753
+ B2=FE_OFN770_n2090
XU2638 AOI22S $PINS O=n1754 A1=FE_OFN734_FE_DBTN5_div_pos_reg_1 A2=n1772
+ B1=FE_OFN633_div_pos_reg_1 B2=n1736
XU2639 MOAI1S $PINS O=n1740 A1=FE_DBTN32_div_pos_reg_3 A2=n1737 B1=n1927
+ B2=n1754
XU2640 AOI22S $PINS O=n1758 A1=FE_OFN639_div_pos_reg_1 A2=n1739 B1=n1738
+ B2=FE_OFN739_FE_DBTN5_div_pos_reg_1
XU2641 OAI22S $PINS O=n1752 A1=FE_OFN607_div_pos_reg_4 A2=n1740
+ B1=FE_OFN923_n2084 B2=n1758
XU2643 AOI22S $PINS O=n1755 A1=FE_OFN640_div_pos_reg_1 A2=n1742 B1=n1741
+ B2=FE_OFN739_FE_DBTN5_div_pos_reg_1
XU2644 INV1S $PINS O=n1743 I=n1755
XU2645 AOI22S $PINS O=n1756 A1=FE_OFN642_div_pos_reg_1 A2=n1745 B1=n1744
+ B2=FE_OFN741_FE_DBTN5_div_pos_reg_1
XU2646 AOI22S $PINS O=n2076 A1=FE_OFN644_div_pos_reg_1 A2=n1747 B1=n1746
+ B2=FE_OFN742_FE_DBTN5_div_pos_reg_1
XU2648 AOI22S $PINS O=n1748 A1=n1756 A2=FE_OFN774_n2090 B1=n2076
+ B2=FE_OFN623_div_pos_reg_2
XU2649 NR2 $PINS O=n2144 I1=n1752 I2=n1751
XU2651 AOI22S $PINS O=n2070 A1=FE_OFN770_n2090 A2=n1754
+ B1=FE_OFN614_div_pos_reg_2 B2=n1753
XU2652 NR2 $PINS O=n1819 I1=FE_OFN607_div_pos_reg_4 I2=FE_OFN608_div_pos_reg_3
XU2656 AOI22S $PINS O=n2068 A1=FE_OFN620_div_pos_reg_2 A2=n1756 B1=n1755
+ B2=FE_OFN773_n2090
XU2657 AOI22S $PINS O=n2069 A1=FE_OFN617_div_pos_reg_2 A2=n1758 B1=n1757
+ B2=FE_OFN770_n2090
XU2658 AOI22S $PINS O=n1759 A1=FE_OFN1037_FE_DBTN9_n2102 A2=n2068
+ B1=FE_OFN685_FE_DBTN32_div_pos_reg_3 B2=n2069
XU2660 AOI22S $PINS O=n1788 A1=FE_OFN721_FE_DBTN6_div_pos_reg_0 A2=Uy_pad[27]
+ B1=FE_OFN663_div_pos_reg_0 B2=Uy_pad[28]
XU2661 AOI22S $PINS O=n1784 A1=FE_OFN721_FE_DBTN6_div_pos_reg_0 A2=Uy_pad[25]
+ B1=FE_OFN661_div_pos_reg_0 B2=Uy_pad[26]
XU2662 AOI22S $PINS O=n1794 A1=FE_OFN640_div_pos_reg_1 A2=n1788 B1=n1784
+ B2=FE_OFN739_FE_DBTN5_div_pos_reg_1
XU2665 AOI22S $PINS O=n1790 A1=FE_OFN722_FE_DBTN6_div_pos_reg_0 A2=Uy_pad[31]
+ B1=FE_OFN664_div_pos_reg_0 B2=Uy_pad[32]
XU2666 AOI22S $PINS O=n1787 A1=FE_OFN721_FE_DBTN6_div_pos_reg_0 A2=Uy_pad[29]
+ B1=FE_OFN663_div_pos_reg_0 B2=Uy_pad[30]
XU2667 AOI22S $PINS O=n1800 A1=FE_OFN642_div_pos_reg_1 A2=n1790 B1=n1787
+ B2=FE_OFN741_FE_DBTN5_div_pos_reg_1
XU2668 AOI22S $PINS O=n2056 A1=n1794 A2=FE_OFN773_n2090
+ B1=FE_OFN621_div_pos_reg_2 B2=n1800
XU2670 AOI22S $PINS O=n1783 A1=FE_OFN720_FE_DBTN6_div_pos_reg_0 A2=Uy_pad[23]
+ B1=FE_OFN661_div_pos_reg_0 B2=Uy_pad[24]
XU2671 AOI22S $PINS O=n1786 A1=FE_OFN719_FE_DBTN6_div_pos_reg_0 A2=Uy_pad[21]
+ B1=FE_OFN658_div_pos_reg_0 B2=Uy_pad[22]
XU2672 AOI22S $PINS O=n1795 A1=FE_OFN640_div_pos_reg_1 A2=n1783 B1=n1786
+ B2=FE_OFN740_FE_DBTN5_div_pos_reg_1
XU2673 AOI22S $PINS O=n1785 A1=FE_OFN720_FE_DBTN6_div_pos_reg_0 A2=Uy_pad[19]
+ B1=FE_OFN658_div_pos_reg_0 B2=Uy_pad[20]
XU2674 AOI22S $PINS O=n1782 A1=FE_OFN718_FE_DBTN6_div_pos_reg_0 A2=Uy_pad[17]
+ B1=FE_OFN658_div_pos_reg_0 B2=Uy_pad[18]
XU2675 AOI22S $PINS O=n1804 A1=FE_OFN635_div_pos_reg_1 A2=n1785 B1=n1782
+ B2=FE_OFN735_FE_DBTN5_div_pos_reg_1
XU2676 AOI22S $PINS O=n2064 A1=FE_OFN620_div_pos_reg_2 A2=n1795 B1=n1804
+ B2=FE_OFN772_n2090
XU2677 NR2 $PINS O=n1763 I1=FE_OFN893_FE_DBTN18_n1690 I2=n2064
XU2679 OR2 $PINS O=n1938 I1=div_pos_reg[4] I2=n1949
XU2680 NR2 $PINS O=n1762 I1=n1796 I2=n1938
XU2681 NR2 $PINS O=n1764 I1=n1763 I2=n1762
XU2682 OAI12HS $PINS O=n1767 A1=n1764 B1=n2056 B2=FE_OFN924_n2102
XU2683 AOI22S $PINS O=n1781 A1=FE_OFN718_FE_DBTN6_div_pos_reg_0 A2=Uy_pad[15]
+ B1=FE_OFN657_div_pos_reg_0 B2=Uy_pad[16]
XU2684 AOI22S $PINS O=n1779 A1=FE_OFN715_FE_DBTN6_div_pos_reg_0 A2=Uy_pad[13]
+ B1=FE_OFN657_div_pos_reg_0 B2=Uy_pad[14]
XU2685 AOI22S $PINS O=n1803 A1=FE_OFN635_div_pos_reg_1 A2=n1781 B1=n1779
+ B2=FE_OFN735_FE_DBTN5_div_pos_reg_1
XU2686 AOI22S $PINS O=n1780 A1=FE_OFN715_FE_DBTN6_div_pos_reg_0 A2=Uy_pad[11]
+ B1=FE_OFN655_div_pos_reg_0 B2=Uy_pad[12]
XU2687 AOI22S $PINS O=n1791 A1=FE_OFN713_FE_DBTN6_div_pos_reg_0 A2=Uy_pad[9]
+ B1=FE_OFN655_div_pos_reg_0 B2=Uy_pad[10]
XU2688 AOI22S $PINS O=n1797 A1=FE_OFN633_div_pos_reg_1 A2=n1780 B1=n1791
+ B2=FE_OFN734_FE_DBTN5_div_pos_reg_1
XU2689 AOI22S $PINS O=n2055 A1=FE_OFN614_div_pos_reg_2 A2=n1803 B1=n1797
+ B2=FE_OFN768_n2090
XU2690 NR2 $PINS O=n1766 I1=FE_OFN890_FE_DBTN34_n2158 I2=n2055
XU2691 NR2 $PINS O=n3831 I1=n1767 I2=n1766
XU2692 AOI22S $PINS O=n2124 A1=FE_OFN620_div_pos_reg_2 A2=n1769 B1=n1768
+ B2=FE_OFN772_n2090
XU2693 AN2 $PINS O=n1778 I1=n1690 I2=n2124
XU2694 AOI22S $PINS O=n2116 A1=FE_OFN614_div_pos_reg_2 A2=n1771 B1=n1770
+ B2=FE_OFN768_n2090
XU2695 OAI22S $PINS O=n1776 A1=n1772 A2=n1949 B1=FE_DBTN32_div_pos_reg_3
+ B2=n2116
XU2697 AOI22S $PINS O=n2117 A1=FE_OFN620_div_pos_reg_2 A2=n1775 B1=n1774
+ B2=FE_OFN773_n2090
XU2698 MOAI1S $PINS O=n1777 A1=FE_OFN607_div_pos_reg_4 A2=n1776
+ B1=FE_DBTN9_n2102 B2=n2117
XU2699 NR2 $PINS O=n3841 I1=n1778 I2=n1777
XU2700 NR2 $PINS O=n2146 I1=n3839 I2=n3841
XU2701 AOI22S $PINS O=n2098 A1=FE_OFN734_FE_DBTN5_div_pos_reg_1 A2=n1780
+ B1=FE_OFN633_div_pos_reg_1 B2=n1779
XU2703 AOI22S $PINS O=n2094 A1=FE_OFN635_div_pos_reg_1 A2=n1782 B1=n1781
+ B2=FE_OFN735_FE_DBTN5_div_pos_reg_1
XU2704 AOI22S $PINS O=n2155 A1=FE_OFN772_n2090 A2=n2098
+ B1=FE_OFN617_div_pos_reg_2 B2=n2094
XU2705 NR2 $PINS O=n1793 I1=FE_OFN890_FE_DBTN34_n2158 I2=n2155
XU2706 AOI22S $PINS O=n2083 A1=FE_OFN640_div_pos_reg_1 A2=n1784 B1=n1783
+ B2=FE_OFN740_FE_DBTN5_div_pos_reg_1
XU2707 AOI22S $PINS O=n2095 A1=FE_OFN640_div_pos_reg_1 A2=n1786 B1=n1785
+ B2=FE_OFN740_FE_DBTN5_div_pos_reg_1
XU2708 AOI22S $PINS O=n2157 A1=FE_OFN621_div_pos_reg_2 A2=n2083 B1=n2095
+ B2=FE_OFN772_n2090
XU2709 AOI22S $PINS O=n2106 A1=FE_OFN741_FE_DBTN5_div_pos_reg_1 A2=n1788
+ B1=FE_OFN642_div_pos_reg_1 B2=n1787
XU2710 AOI22S $PINS O=n1798 A1=FE_OFN722_FE_DBTN6_div_pos_reg_0 A2=Uy_pad[33]
+ B1=FE_OFN665_div_pos_reg_0 B2=Uy_pad[34]
XU2711 AOI22S $PINS O=n2091 A1=FE_OFN644_div_pos_reg_1 A2=n1798 B1=n1790
+ B2=FE_OFN742_FE_DBTN5_div_pos_reg_1
XU2712 AOI22S $PINS O=n2167 A1=FE_OFN774_n2090 A2=n2106
+ B1=FE_OFN623_div_pos_reg_2 B2=n2091
XU2713 NR2 $PINS O=n1911 I1=FE_OFN607_div_pos_reg_4 I2=n2099
XU2715 AOI22S $PINS O=n2085 A1=n1796 A2=FE_OFN733_FE_DBTN5_div_pos_reg_1
+ B1=FE_OFN630_div_pos_reg_1 B2=n1791
XU2716 MOAI1S $PINS O=n1792 A1=FE_OFN924_n2102 A2=n2167 B1=n1911 B2=n2085
XU2717 NR3 $PINS O=n2138 I1=n1793 I2=n1691 I3=n1792
XU2718 OR2 $PINS O=n2150 I1=n2144 I2=n2142
XU2719 OA22 $PINS O=n1808 A1=FE_OFN923_n2084 A2=n1795 B1=n2107 B2=n1794
XU2720 MAOI1 $PINS O=n1802 A1=FE_OFN614_div_pos_reg_2 A2=n1797 B1=n1876
+ B2=n1796
XU2721 AOI22S $PINS O=n2087 A1=FE_OFN723_FE_DBTN6_div_pos_reg_0 A2=Uy_pad[35]
+ B1=FE_OFN665_div_pos_reg_0 B2=Uy_pad[36]
XU2722 AOI22S $PINS O=n2062 A1=FE_OFN644_div_pos_reg_1 A2=n2087 B1=n1798
+ B2=FE_OFN742_FE_DBTN5_div_pos_reg_1
XU2723 AOI22S $PINS O=n1801 A1=FE_OFN623_div_pos_reg_2 A2=n2062 B1=n1800
+ B2=FE_OFN773_n2090
XU2724 AOI22S $PINS O=n1807 A1=n1819 A2=n1802 B1=FE_OFN1037_FE_DBTN9_n2102
+ B2=n1801
XU2725 AOI22S $PINS O=n1805 A1=FE_OFN617_div_pos_reg_2 A2=n1804 B1=n1803
+ B2=FE_OFN772_n2090
XU2726 ND3 $PINS O=n2152 I1=n1808 I2=n1807 I3=n1806
XU2727 INV1S $PINS O=n1809 I=n2152
XU2729 OAI12HS $PINS O=n1810 A1=FE_OFN529_n4365 B1=n2150 B2=n1809
XU2730 XNR2HS $PINS O=n2145 I1=n2082 I2=n1810
XU2731 INV1S $PINS O=n2185 I=n2145
XU2734 AOI22S $PINS O=n1906 A1=FE_OFN712_FE_DBTN6_div_pos_reg_0 A2=Ux_pad[31]
+ B1=FE_OFN649_div_pos_reg_0 B2=Ux_pad[32]
XU2735 AOI22S $PINS O=n1909 A1=FE_OFN712_FE_DBTN6_div_pos_reg_0 A2=Ux_pad[29]
+ B1=FE_OFN649_div_pos_reg_0 B2=Ux_pad[30]
XU2737 AOI22S $PINS O=n1880 A1=FE_OFN631_div_pos_reg_1 A2=n1906 B1=n1909
+ B2=FE_OFN725_FE_DBTN5_div_pos_reg_1
XU2739 AOI22S $PINS O=n1908 A1=FE_OFN710_FE_DBTN6_div_pos_reg_0 A2=Ux_pad[27]
+ B1=FE_OFN647_div_pos_reg_0 B2=Ux_pad[28]
XU2740 AOI22S $PINS O=n1902 A1=FE_OFN710_FE_DBTN6_div_pos_reg_0 A2=Ux_pad[25]
+ B1=FE_OFN647_div_pos_reg_0 B2=Ux_pad[26]
XU2741 AOI22S $PINS O=n1887 A1=FE_OFN627_div_pos_reg_1 A2=n1908 B1=n1902
+ B2=FE_OFN725_FE_DBTN5_div_pos_reg_1
XU2742 AOI22S $PINS O=n1955 A1=FE_OFN612_div_pos_reg_2 A2=n1880 B1=n1887
+ B2=FE_OFN765_n2090
XU2743 OR2 $PINS O=n1826 I1=FE_OFN892_FE_DBTN18_n1690 I2=n1955
XU2745 AOI22S $PINS O=n1813 A1=FE_OFN714_FE_DBTN6_div_pos_reg_0 A2=Ux_pad[39]
+ B1=FE_OFN651_div_pos_reg_0 B2=Ux_pad_43
XU2746 AOI22S $PINS O=n1976 A1=FE_OFN714_FE_DBTN6_div_pos_reg_0 A2=Ux_pad[37]
+ B1=FE_OFN651_div_pos_reg_0 B2=Ux_pad[38]
XU2747 AOI22S $PINS O=n1815 A1=FE_OFN636_div_pos_reg_1 A2=n1813 B1=n1976
+ B2=FE_OFN731_FE_DBTN5_div_pos_reg_1
XU2748 AOI22S $PINS O=n1975 A1=FE_OFN714_FE_DBTN6_div_pos_reg_0 A2=Ux_pad[35]
+ B1=FE_OFN651_div_pos_reg_0 B2=Ux_pad[36]
XU2749 AOI22S $PINS O=n1907 A1=FE_OFN712_FE_DBTN6_div_pos_reg_0 A2=Ux_pad[33]
+ B1=FE_OFN649_div_pos_reg_0 B2=Ux_pad[34]
XU2750 AOI22S $PINS O=n1881 A1=FE_OFN637_div_pos_reg_1 A2=n1975 B1=n1907
+ B2=FE_OFN731_FE_DBTN5_div_pos_reg_1
XU2751 AOI22S $PINS O=n1816 A1=FE_OFN618_div_pos_reg_2 A2=n1815 B1=n1881
+ B2=FE_OFN771_n2090
XU2752 OR2 $PINS O=n1825 I1=FE_OFN925_n2102 I2=n1816
XU2753 AOI22S $PINS O=n1901 A1=FE_OFN708_FE_DBTN6_div_pos_reg_0 A2=Ux_pad[23]
+ B1=FE_OFN645_div_pos_reg_0 B2=Ux_pad[24]
XU2754 AOI22S $PINS O=n1904 A1=FE_OFN708_FE_DBTN6_div_pos_reg_0 A2=Ux_pad[21]
+ B1=FE_OFN645_div_pos_reg_0 B2=Ux_pad[22]
XU2755 AOI22S $PINS O=n1877 A1=FE_OFN627_div_pos_reg_1 A2=n1901 B1=n1904
+ B2=FE_DBTN5_div_pos_reg_1
XU2756 AOI22S $PINS O=n1903 A1=FE_OFN646_div_pos_reg_0 A2=Ux_pad[19]
+ B1=div_pos_reg[0] B2=Ux_pad[20]
XU2757 AOI22S $PINS O=n1895 A1=FE_OFN646_div_pos_reg_0 A2=Ux_pad[17]
+ B1=FE_OFN648_div_pos_reg_0 B2=Ux_pad[18]
XU2758 AOI22S $PINS O=n1883 A1=div_pos_reg[1] A2=n1903 B1=n1895
+ B2=FE_OFN724_FE_DBTN5_div_pos_reg_1
XU2759 AOI22S $PINS O=n1954 A1=FE_OFN609_div_pos_reg_2 A2=n1877 B1=n1883
+ B2=FE_OFN765_n2090
XU2761 AOI22S $PINS O=n1898 A1=FE_OFN713_FE_DBTN6_div_pos_reg_0 A2=Ux_pad[11]
+ B1=FE_OFN654_div_pos_reg_0 B2=Ux_pad[12]
XU2762 AOI22S $PINS O=n1910 A1=Ux_pad[9] A2=FE_OFN713_FE_DBTN6_div_pos_reg_0
+ B1=FE_OFN654_div_pos_reg_0 B2=Ux_pad[10]
XU2763 AOI22S $PINS O=n1875 A1=FE_OFN630_div_pos_reg_1 A2=n1898 B1=n1910
+ B2=FE_OFN730_FE_DBTN5_div_pos_reg_1
XU2764 AOI22S $PINS O=n1894 A1=FE_OFN709_FE_DBTN6_div_pos_reg_0 A2=Ux_pad[15]
+ B1=FE_OFN652_div_pos_reg_0 B2=Ux_pad[16]
XU2765 AOI22S $PINS O=n1899 A1=FE_OFN709_FE_DBTN6_div_pos_reg_0 A2=Ux_pad[13]
+ B1=FE_OFN652_div_pos_reg_0 B2=Ux_pad[14]
XU2766 AOI22S $PINS O=n1882 A1=FE_OFN628_div_pos_reg_1 A2=n1894 B1=n1899
+ B2=FE_OFN729_FE_DBTN5_div_pos_reg_1
XU2767 AOI22S $PINS O=n1951 A1=FE_OFN768_n2090 A2=n1875
+ B1=FE_OFN611_div_pos_reg_2 B2=n1882
XU2768 OA22 $PINS O=n1824 A1=FE_OFN889_FE_DBTN34_n2158 A2=n1954
+ B1=FE_OFN745_FE_DBTN4_n1819 B2=n1951
XU2769 ND3 $PINS O=n1990 I1=n1826 I2=n1825 I3=n1824
XU2771 AOI22S $PINS O=n1848 A1=FE_OFN708_FE_DBTN6_div_pos_reg_0 A2=Ux_pad[22]
+ B1=FE_OFN645_div_pos_reg_0 B2=Ux_pad[23]
XU2773 AOI22S $PINS O=n1863 A1=FE_OFN708_FE_DBTN6_div_pos_reg_0 A2=Ux_pad[20]
+ B1=FE_OFN645_div_pos_reg_0 B2=Ux_pad[21]
XU2774 AOI22S $PINS O=n1929 A1=FE_OFN625_div_pos_reg_1 A2=n1848 B1=n1863
+ B2=FE_DBTN5_div_pos_reg_1
XU2776 AOI22S $PINS O=n1862 A1=FE_OFN646_div_pos_reg_0 A2=Ux_pad[18]
+ B1=FE_OFN648_div_pos_reg_0 B2=Ux_pad[19]
XU2777 AOI22S $PINS O=n1858 A1=FE_OFN709_FE_DBTN6_div_pos_reg_0 A2=Ux_pad[16]
+ B1=FE_OFN648_div_pos_reg_0 B2=Ux_pad[17]
XU2778 AOI22S $PINS O=n1925 A1=div_pos_reg[1] A2=n1862 B1=n1858
+ B2=FE_OFN724_FE_DBTN5_div_pos_reg_1
XU2779 AOI22S $PINS O=n1959 A1=div_pos_reg[2] A2=n1929 B1=n1925 B2=n2090
XU2780 AOI22S $PINS O=n1857 A1=FE_OFN709_FE_DBTN6_div_pos_reg_0 A2=Ux_pad[14]
+ B1=FE_OFN652_div_pos_reg_0 B2=Ux_pad[15]
XU2781 AOI22S $PINS O=n1856 A1=FE_OFN709_FE_DBTN6_div_pos_reg_0 A2=Ux_pad[12]
+ B1=FE_OFN652_div_pos_reg_0 B2=Ux_pad[13]
XU2782 AOI22S $PINS O=n1924 A1=FE_OFN626_div_pos_reg_1 A2=n1857 B1=n1856
+ B2=FE_OFN730_FE_DBTN5_div_pos_reg_1
XU2783 MXL2HS $PINS OB=n1937 S=FE_OFN654_div_pos_reg_0 A=Ux_pad[8] B=Ux_pad[9]
XU2784 AOI22S $PINS O=n1855 A1=FE_OFN713_FE_DBTN6_div_pos_reg_0 A2=Ux_pad[10]
+ B1=FE_OFN654_div_pos_reg_0 B2=Ux_pad[11]
XU2785 AOI22S $PINS O=n1926 A1=FE_OFN730_FE_DBTN5_div_pos_reg_1 A2=n1937
+ B1=FE_OFN626_div_pos_reg_1 B2=n1855
XU2786 AOI22S $PINS O=n1962 A1=FE_OFN611_div_pos_reg_2 A2=n1924 B1=n2090
+ B2=n1926
XU2787 OA22 $PINS O=n1847 A1=FE_OFN889_FE_DBTN34_n2158 A2=n1959
+ B1=FE_OFN745_FE_DBTN4_n1819 B2=n1962
XU2790 AOI22S $PINS O=n2002 A1=FE_OFN714_FE_DBTN6_div_pos_reg_0 A2=Ux_pad[38]
+ B1=FE_OFN651_div_pos_reg_0 B2=Ux_pad[39]
XU2791 AOI22S $PINS O=n1851 A1=FE_OFN714_FE_DBTN6_div_pos_reg_0 A2=Ux_pad[36]
+ B1=FE_OFN651_div_pos_reg_0 B2=Ux_pad[37]
XU2792 AOI22S $PINS O=n1837 A1=FE_OFN636_div_pos_reg_1 A2=n2002 B1=n1851
+ B2=FE_OFN731_FE_DBTN5_div_pos_reg_1
XU2793 AOI22S $PINS O=n1850 A1=FE_OFN714_FE_DBTN6_div_pos_reg_0 A2=Ux_pad[34]
+ B1=FE_OFN651_div_pos_reg_0 B2=Ux_pad[35]
XU2794 AOI22S $PINS O=n1853 A1=FE_OFN712_FE_DBTN6_div_pos_reg_0 A2=Ux_pad[32]
+ B1=FE_OFN649_div_pos_reg_0 B2=Ux_pad[33]
XU2795 AOI22S $PINS O=n1918 A1=FE_OFN636_div_pos_reg_1 A2=n1850 B1=n1853
+ B2=FE_OFN728_FE_DBTN5_div_pos_reg_1
XU2796 AOI22S $PINS O=n1838 A1=FE_OFN615_div_pos_reg_2 A2=n1837 B1=n1918
+ B2=FE_OFN771_n2090
XU2797 OR2 $PINS O=n1846 I1=FE_OFN925_n2102 I2=n1838
XU2798 AOI22S $PINS O=n1852 A1=FE_OFN712_FE_DBTN6_div_pos_reg_0 A2=Ux_pad[30]
+ B1=FE_OFN649_div_pos_reg_0 B2=Ux_pad[31]
XU2799 AOI22S $PINS O=n1868 A1=FE_OFN710_FE_DBTN6_div_pos_reg_0 A2=Ux_pad[28]
+ B1=FE_OFN647_div_pos_reg_0 B2=Ux_pad[29]
XU2800 AOI22S $PINS O=n1920 A1=FE_OFN631_div_pos_reg_1 A2=n1852 B1=n1868
+ B2=FE_OFN728_FE_DBTN5_div_pos_reg_1
XU2801 AOI22S $PINS O=n1867 A1=FE_OFN710_FE_DBTN6_div_pos_reg_0 A2=Ux_pad[26]
+ B1=FE_OFN647_div_pos_reg_0 B2=Ux_pad[27]
XU2802 AOI22S $PINS O=n1849 A1=FE_OFN710_FE_DBTN6_div_pos_reg_0 A2=Ux_pad[24]
+ B1=FE_OFN647_div_pos_reg_0 B2=Ux_pad[25]
XU2803 AOI22S $PINS O=n1915 A1=FE_OFN631_div_pos_reg_1 A2=n1867 B1=n1849
+ B2=FE_OFN725_FE_DBTN5_div_pos_reg_1
XU2804 AOI22S $PINS O=n1961 A1=FE_OFN612_div_pos_reg_2 A2=n1920 B1=n1915
+ B2=FE_OFN769_n2090
XU2805 OR2 $PINS O=n1845 I1=FE_OFN892_FE_DBTN18_n1690 I2=n1961
XU2806 ND3 $PINS O=n1995 I1=n1847 I2=n1846 I3=n1845
XU2808 AOI22S $PINS O=n1933 A1=FE_OFN627_div_pos_reg_1 A2=n1849 B1=n1848
+ B2=FE_OFN725_FE_DBTN5_div_pos_reg_1
XU2809 AOI22S $PINS O=n2005 A1=FE_OFN636_div_pos_reg_1 A2=n1851 B1=n1850
+ B2=FE_OFN731_FE_DBTN5_div_pos_reg_1
XU2810 AOI22S $PINS O=n1942 A1=FE_OFN631_div_pos_reg_1 A2=n1853 B1=n1852
+ B2=FE_OFN728_FE_DBTN5_div_pos_reg_1
XU2811 AOI22S $PINS O=n1854 A1=FE_OFN618_div_pos_reg_2 A2=n2005 B1=n1942
+ B2=FE_OFN771_n2090
XU2812 MOAI1S $PINS O=n1872 A1=n2084 A2=n1933 B1=FE_OFN1036_FE_DBTN9_n2102
+ B2=n1854
XU2813 AOI22S $PINS O=n1944 A1=FE_OFN629_div_pos_reg_1 A2=n1856 B1=n1855
+ B2=FE_OFN730_FE_DBTN5_div_pos_reg_1
XU2814 AOI22S $PINS O=n1945 A1=FE_OFN626_div_pos_reg_1 A2=n1858 B1=n1857
+ B2=FE_OFN724_FE_DBTN5_div_pos_reg_1
XU2815 MOAI1S $PINS O=n1860 A1=n1937 A2=n1859 B1=div_pos_reg[3] B2=n1945
XU2816 AOI22S $PINS O=n1865 A1=n1927 A2=n1944 B1=FE_OFN767_n2090 B2=n1860
XU2817 AOI22S $PINS O=n1935 A1=FE_OFN625_div_pos_reg_1 A2=n1863 B1=n1862
+ B2=FE_OFN724_FE_DBTN5_div_pos_reg_1
XU2818 ND3 $PINS O=n1871 I1=n1865 I2=FE_DBTN3_div_pos_reg_4 I3=n1864
XU2819 AOI22S $PINS O=n1940 A1=FE_OFN631_div_pos_reg_1 A2=n1868 B1=n1867
+ B2=FE_OFN728_FE_DBTN5_div_pos_reg_1
XU2820 INV1S $PINS O=n1869 I=n1940
XU2821 INV1S $PINS O=n2019 I=n1873
XU2822 MOAI1S $PINS O=n1878 A1=n1950 A2=n1876 B1=FE_OFN611_div_pos_reg_2
+ B2=n1875
XU2823 OAI22S $PINS O=n1891 A1=FE_OFN745_FE_DBTN4_n1819 A2=n1878 B1=n1877
+ B2=n2084
XU2824 AOI22S $PINS O=n1886 A1=FE_OFN612_div_pos_reg_2 A2=n1881 B1=n1880
+ B2=FE_OFN769_n2090
XU2825 NR2 $PINS O=n1885 I1=div_pos_reg[4] I2=FE_OFN684_FE_DBTN32_div_pos_reg_3
XU2826 AOI22S $PINS O=n1884 A1=FE_OFN610_div_pos_reg_2 A2=n1883 B1=n1882
+ B2=FE_OFN766_n2090
XU2827 AOI22S $PINS O=n1890 A1=FE_OFN1036_FE_DBTN9_n2102 A2=n1886 B1=n1885
+ B2=n1884
XU2828 INV1S $PINS O=n1888 I=n1887
XU2829 INV1S $PINS O=n2021 I=n1892
XU2831 AOI22S $PINS O=n1981 A1=FE_OFN628_div_pos_reg_1 A2=n1895 B1=n1894
+ B2=FE_OFN729_FE_DBTN5_div_pos_reg_1
XU2833 AOI22S $PINS O=n1985 A1=FE_OFN629_div_pos_reg_1 A2=n1899 B1=n1898
+ B2=FE_OFN730_FE_DBTN5_div_pos_reg_1
XU2834 AOI22S $PINS O=n2043 A1=FE_OFN611_div_pos_reg_2 A2=n1981 B1=n1985
+ B2=FE_OFN767_n2090
XU2835 NR2 $PINS O=n1914 I1=FE_OFN890_FE_DBTN34_n2158 I2=n2043
XU2836 AOI22S $PINS O=n1970 A1=FE_OFN627_div_pos_reg_1 A2=n1902 B1=n1901
+ B2=FE_DBTN5_div_pos_reg_1
XU2837 AOI22S $PINS O=n1982 A1=FE_OFN625_div_pos_reg_1 A2=n1904 B1=n1903
+ B2=FE_OFN724_FE_DBTN5_div_pos_reg_1
XU2838 AOI22S $PINS O=n2047 A1=FE_OFN609_div_pos_reg_2 A2=n1970 B1=n1982
+ B2=FE_OFN765_n2090
XU2839 NR2 $PINS O=n1913 I1=FE_OFN892_FE_DBTN18_n1690 I2=n2047
XU2840 AOI22S $PINS O=n1978 A1=FE_OFN637_div_pos_reg_1 A2=n1907 B1=n1906
+ B2=FE_OFN728_FE_DBTN5_div_pos_reg_1
XU2841 AOI22S $PINS O=n1968 A1=FE_OFN627_div_pos_reg_1 A2=n1909 B1=n1908
+ B2=FE_OFN725_FE_DBTN5_div_pos_reg_1
XU2842 AOI22S $PINS O=n2044 A1=FE_OFN612_div_pos_reg_2 A2=n1978 B1=n1968
+ B2=FE_OFN769_n2090
XU2843 AOI22S $PINS O=n1971 A1=FE_OFN630_div_pos_reg_1 A2=n1910 B1=n1950
+ B2=FE_OFN733_FE_DBTN5_div_pos_reg_1
XU2844 MOAI1S $PINS O=n1912 A1=FE_OFN925_n2102 A2=n2044 B1=n1911 B2=n1971
XU2845 NR3 $PINS O=n2032 I1=n1914 I2=n1913 I3=n1912
XU2846 INV1S $PINS O=n1917 I=n1915
XU2847 AOI22S $PINS O=n1921 A1=n1920 A2=FE_OFN769_n2090 B1=n1918
+ B2=FE_OFN615_div_pos_reg_2
XU2848 AOI22S $PINS O=n1928 A1=div_pos_reg[2] A2=n1925 B1=n1924
+ B2=FE_OFN767_n2090
XU2849 MOAI1S $PINS O=n1930 A1=FE_OFN684_FE_DBTN32_div_pos_reg_3 A2=n1928
+ B1=n1927 B2=n1926
XU2850 OAI22S $PINS O=n1931 A1=div_pos_reg[4] A2=n1930 B1=n2084 B2=n1929
XU2851 OR2 $PINS O=n2034 I1=n1932 I2=n1931
XU2852 AOI22S $PINS O=n2001 A1=FE_OFN765_n2090 A2=n1935
+ B1=FE_OFN612_div_pos_reg_2 B2=n1933
XU2853 OR2 $PINS O=n1939 I1=n1938 I2=n1937
XU2854 OAI12HS $PINS O=n1948 A1=n1939 B1=n2001 B2=FE_OFN892_FE_DBTN18_n1690
XU2855 AOI22S $PINS O=n1999 A1=FE_OFN615_div_pos_reg_2 A2=n1942
+ B1=FE_OFN771_n2090 B2=n1940
XU2856 AOI22S $PINS O=n2000 A1=FE_OFN611_div_pos_reg_2 A2=n1945 B1=n1944
+ B2=FE_OFN767_n2090
XU2857 OAI22S $PINS O=n1947 A1=n1999 A2=FE_OFN925_n2102 B1=n2000
+ B2=FE_OFN889_FE_DBTN34_n2158
XU2858 NR2 $PINS O=n2029 I1=n1948 I2=n1947
XU2859 ND3 $PINS O=n1967 I1=n2032 I2=n2034 I3=n2029
XU2860 OA22 $PINS O=n1953 A1=FE_DBTN32_div_pos_reg_3 A2=n1951 B1=n1950 B2=n1949
XU2861 AOI22S $PINS O=n1956 A1=FE_OFN1036_FE_DBTN9_n2102 A2=n1955 B1=n1690
+ B2=n1954
XU2862 INV1S $PINS O=n1966 I=n3834
XU2863 AN2 $PINS O=n1965 I1=n1960 I2=FE_OFN745_FE_DBTN4_n1819
XU2864 OR2 $PINS O=n2035 I1=n1966 I2=n3832
XU2865 OR2 $PINS O=n2020 I1=n1967 I2=n2035
XU2866 OR2 $PINS O=n2024 I1=n2021 I2=n2020
XU2867 NR2 $PINS O=n2025 I1=n2019 I2=n2024
XU2868 NR2 $PINS O=n1973 I1=n2107 I2=n1968
XU2869 OAI22S $PINS O=n1972 A1=n1688 A2=n1971 B1=FE_OFN923_n2084 B2=n1970
XU2870 NR2 $PINS O=n1989 I1=n1973 I2=n1972
XU2871 AOI22S $PINS O=n2040 A1=FE_OFN636_div_pos_reg_1 A2=n1976 B1=n1975
+ B2=FE_OFN731_FE_DBTN5_div_pos_reg_1
XU2872 AOI22S $PINS O=n1987 A1=FE_OFN615_div_pos_reg_2 A2=n2040 B1=n1978
+ B2=FE_OFN769_n2090
XU2873 AOI22S $PINS O=n1984 A1=FE_OFN610_div_pos_reg_2 A2=n1982 B1=n1981
+ B2=FE_OFN766_n2090
XU2874 MOAI1S $PINS O=n1986 A1=n2099 A2=n1985 B1=div_pos_reg[3] B2=n1984
XU2875 AOI22S $PINS O=n1988 A1=n1987 A2=FE_OFN1036_FE_DBTN9_n2102
+ B1=FE_DBTN3_div_pos_reg_4 B2=n1986
XU2876 OR2 $PINS O=n1998 I1=n1995 I2=n1994
XU2877 OR2 $PINS O=n2010 I1=n1990 I2=n1998
XU2878 INV1S $PINS O=n2012 I=n2010
XU2880 INV1S $PINS O=n1991 I=n1998
XU2881 OAI22S $PINS O=n1993 A1=n1992 A2=n1991 B1=n4365 B2=n1990
XU2882 NR2 $PINS O=n3859 I1=n2012 I2=n1993
XU2883 INV1S $PINS O=n2016 I=n3859
XU2884 ND3 $PINS O=n1997 I1=n1994 I2=FE_OFN524_n4365 I3=n1995
XU2885 OR2 $PINS O=n1996 I1=FE_OFN524_n4365 I2=n1995
XU2886 ND3 $PINS O=n3858 I1=n1998 I2=n1997 I3=n1996
XU2887 OA22 $PINS O=n2009 A1=FE_OFN745_FE_DBTN4_n1819 A2=n2000
+ B1=FE_OFN892_FE_DBTN18_n1690 B2=n1999
XU2888 OR2 $PINS O=n2008 I1=FE_OFN889_FE_DBTN34_n2158 I2=n2001
XU2889 INV1S $PINS O=n2003 I=Ux_pad_43
XU2890 MXL2HS $PINS OB=n2004 S=FE_OFN731_FE_DBTN5_div_pos_reg_1 A=n2003 B=n2002
XU2891 MXL2HS $PINS OB=n2006 S=FE_OFN618_div_pos_reg_2 A=n2005 B=n2004
XU2892 OR2 $PINS O=n2007 I1=FE_OFN925_n2102 I2=n2006
XU2893 ND3 $PINS O=n2011 I1=n2009 I2=n2008 I3=n2007
XU2894 NR2 $PINS O=n2048 I1=n2011 I2=n2010
XU2895 OAI22S $PINS O=n2014 A1=n2013 A2=n2012 B1=n4365 B2=n2011
XU2896 NR2 $PINS O=n3863 I1=n2048 I2=n2014
XU2897 INV1S $PINS O=n2015 I=n3863
XU2898 OAI12HS $PINS O=n2052 A1=n2015 B1=n2016 B2=n3858
XU2899 INV1S $PINS O=n2018 I=n2025
XU2900 ND3 $PINS O=n2017 I1=n2024 I2=FE_OFN524_n4365 I3=n2019
XU2901 OAI112HS $PINS O=n2183 A1=n2018 B1=n2017 C1=FE_OFN528_n4365 C2=n2019
XU2902 ND3 $PINS O=n2023 I1=n2020 I2=FE_OFN524_n4365 I3=n2021
XU2903 OR2 $PINS O=n2022 I1=FE_OFN525_n4365 I2=n2021
XU2904 ND3 $PINS O=n3850 I1=n2024 I2=n2023 I3=n2022
XU2906 NR2 $PINS O=n2026 I1=FE_OFN679_FE_DBTN37_n4365 I2=n2025
XU2907 XNR2HS $PINS O=n3855 I1=n2027 I2=n2026
XU2908 ND2S $PINS O=n2028 I1=n2035 I2=FE_OFN528_n4365
XU2909 XOR2HS $PINS O=n3843 I1=n2029 I2=n2028
XU2910 INV1S $PINS O=n2030 I=n2029
XU2911 OAI12HS $PINS O=n2031 A1=FE_OFN528_n4365 B1=n2035 B2=n2030
XU2912 XNR2HS $PINS O=n3845 I1=n2032 I2=n2031
XU2913 OAI12HS $PINS O=n2033 A1=n2031 B1=n2032 B2=FE_DBTN37_n4365
XU2914 XOR2HS $PINS O=n3847 I1=n2034 I2=n2033
XU2915 NR3 $PINS O=n2037 I1=n3855 I2=n3843 I3=n2036
XU2916 AOI13HS $PINS O=n2038 A1=n3858 B1=n2183 B2=n3850 B3=n2037
XU2917 OAI12HS $PINS O=n2051 A1=n3863 B1=n2038 B2=n3859
XU2918 ND2S $PINS O=n2159 I1=FE_OFN743_FE_DBTN5_div_pos_reg_1
+ I2=FE_OFN723_FE_DBTN6_div_pos_reg_0
XU2919 INV1S $PINS O=n2160 I=n2159
XU2920 MXL2HS $PINS OB=n2039 S=n2160 A=Ux_pad_43 B=Ux_pad[39]
XU2921 MOAI1S $PINS O=n2042 A1=FE_OFN618_div_pos_reg_2 A2=n2040
+ B1=FE_OFN618_div_pos_reg_2 B2=n2039
XU2922 OA22 $PINS O=n2046 A1=FE_OFN745_FE_DBTN4_n1819 A2=n2043
+ B1=FE_OFN925_n2102 B2=n2042
XU2923 OR2 $PINS O=n2045 I1=FE_OFN892_FE_DBTN18_n1690 I2=n2044
XU2924 OAI112HS $PINS O=n2050 A1=n2046 B1=n2045 C1=n2047
+ C2=FE_OFN889_FE_DBTN34_n2158
XU2925 NR2 $PINS O=n2049 I1=FE_OFN679_FE_DBTN37_n4365 I2=n2048
XU2926 XNR2HS $PINS O=n3868 I1=n2050 I2=n2049
XU2927 MUXB2P $PINS O=n2054 S=n3868 A=n2052 B=n2051 EB=n2053
XU2928 OA22 $PINS O=n2067 A1=FE_OFN893_FE_DBTN18_n1690 A2=n2056
+ B1=FE_OFN744_FE_DBTN4_n1819 B2=n2055
XU2929 MUX2 $PINS O=n2060 S=FE_OFN723_FE_DBTN6_div_pos_reg_0 A=Uy_pad_43
+ B=Uy_pad[39]
XU2930 AOI22S $PINS O=n2088 A1=FE_OFN723_FE_DBTN6_div_pos_reg_0 A2=Uy_pad[37]
+ B1=FE_OFN665_div_pos_reg_0 B2=Uy_pad[38]
XU2931 MOAI1S $PINS O=n2063 A1=FE_OFN743_FE_DBTN5_div_pos_reg_1 A2=n2060
+ B1=n2088 B2=FE_OFN743_FE_DBTN5_div_pos_reg_1
XU2932 MOAI1S $PINS O=n2065 A1=FE_OFN774_n2090 A2=n2063 B1=n2062
+ B2=FE_OFN774_n2090
XU2933 INV1S $PINS O=n2110 I=n2115
XU2934 OR2 $PINS O=n2081 I1=FE_OFN893_FE_DBTN18_n1690 I2=n2068
XU2935 OA22 $PINS O=n2080 A1=n2070 A2=FE_OFN744_FE_DBTN4_n1819 B1=n2069
+ B2=FE_DBTN34_n2158
XU2936 AOI22S $PINS O=n2119 A1=FE_OFN723_FE_DBTN6_div_pos_reg_0 A2=Uy_pad[38]
+ B1=FE_OFN665_div_pos_reg_0 B2=Uy_pad[39]
XU2937 AOI22S $PINS O=n2077 A1=FE_OFN644_div_pos_reg_1 A2=n2119 B1=n2074
+ B2=FE_OFN742_FE_DBTN5_div_pos_reg_1
XU2938 AOI22S $PINS O=n2078 A1=FE_OFN624_div_pos_reg_2 A2=n2077 B1=n2076
+ B2=FE_OFN774_n2090
XU2939 OR2 $PINS O=n2079 I1=FE_OFN924_n2102 I2=n2078
XU2940 ND3 $PINS O=n2113 I1=n2081 I2=n2080 I3=n2079
XU2941 NR2 $PINS O=n2147 I1=n2082 I2=n2150
XU2942 OA22 $PINS O=n2105 A1=n1688 A2=n2085 B1=FE_OFN923_n2084 B2=n2083
XU2943 AOI22S $PINS O=n2165 A1=FE_OFN644_div_pos_reg_1 A2=n2088 B1=n2087
+ B2=FE_OFN743_FE_DBTN5_div_pos_reg_1
XU2944 AOI22S $PINS O=n2103 A1=FE_OFN623_div_pos_reg_2 A2=n2165 B1=n2091
+ B2=FE_OFN774_n2090
XU2945 AOI22S $PINS O=n2097 A1=FE_OFN619_div_pos_reg_2 A2=n2095 B1=n2094
+ B2=FE_OFN770_n2090
XU2946 MOAI1S $PINS O=n2100 A1=n2099 A2=n2098 B1=FE_OFN608_div_pos_reg_3
+ B2=n2097
XU2947 AOI22S $PINS O=n2104 A1=n2103 A2=FE_OFN1037_FE_DBTN9_n2102
+ B1=FE_OFN746_FE_DBTN3_div_pos_reg_4 B2=n2100
XU2948 OAI112HS $PINS O=n2149 A1=n2105 B1=n2104 C1=n2107 C2=n2106
XU2949 ND3 $PINS O=n2111 I1=n2147 I2=n2152 I3=n2149
XU2950 OR2 $PINS O=n2114 I1=n2113 I2=n2111
XU2951 INV1S $PINS O=n2108 I=n2114
XU2952 NR2 $PINS O=n2109 I1=FE_OFN679_FE_DBTN37_n4365 I2=n2108
XU2953 XNR2HS $PINS O=n3860 I1=n2110 I2=n2109
XU2954 INV1S $PINS O=n2135 I=n3860
XU2955 ND3 $PINS O=n2112 I1=n2111 I2=FE_OFN529_n4365 I3=n2113
XU2956 OAI112HS $PINS O=n3857 A1=n2114 B1=n2112 C1=FE_OFN527_n4365 C2=n2113
XU2957 OR2 $PINS O=n2131 I1=n2115 I2=n2114
XU2958 INV1S $PINS O=n2130 I=n2131
XU2959 OA22 $PINS O=n2127 A1=FE_OFN893_FE_DBTN18_n1690 A2=n2117
+ B1=FE_OFN744_FE_DBTN4_n1819 B2=n2116
XU2960 INV1S $PINS O=n2120 I=Uy_pad_43
XU2961 MXL2HS $PINS OB=n2121 S=FE_OFN743_FE_DBTN5_div_pos_reg_1 A=n2120 B=n2119
XU2962 MXL2HS $PINS OB=n2123 S=FE_OFN624_div_pos_reg_2 A=n2122 B=n2121
XU2963 OR2 $PINS O=n2126 I1=FE_OFN924_n2102 I2=n2123
XU2964 OR2 $PINS O=n2125 I1=FE_OFN890_FE_DBTN34_n2158 I2=n2124
XU2965 ND3 $PINS O=n2132 I1=n2127 I2=n2126 I3=n2125
XU2966 INV1S $PINS O=n2128 I=n2132
XU2967 MOAI1S $PINS O=n2133 A1=n2130 A2=n2129 B1=n2128 B2=FE_DBTN37_n4365
XU2968 NR2 $PINS O=n2171 I1=n2132 I2=n2131
XU2969 NR2 $PINS O=n3865 I1=n2133 I2=n2171
XU2970 INV1S $PINS O=n2134 I=n3865
XU2971 OAI12HS $PINS O=n2175 A1=n2134 B1=n2135 B2=n3857
XU2972 INV1S $PINS O=n2137 I=n2146
XU2973 INV1S $PINS O=n2136 I=n2138
XU2974 ND3 $PINS O=n2140 I1=n2137 I2=FE_OFN529_n4365 I3=n2136
XU2975 ND2S $PINS O=n2139 I1=n2138 I2=FE_OFN679_FE_DBTN37_n4365
XU2976 ND3 $PINS O=n3844 I1=n2142 I2=n2140 I3=n2139
XU2977 ND3 $PINS O=n2143 I1=n2142 I2=FE_OFN529_n4365 I3=n2144
XU2978 OAI112HS $PINS O=n3848 A1=n2150 B1=n2143 C1=FE_OFN529_n4365 C2=n2144
XU2979 AN4B1S $PINS O=n2153 I1=n2146 I2=n3844 I3=n3848 B1=n2145
XU2980 AO12 $PINS O=n2148 A1=FE_OFN679_FE_DBTN37_n4365 B1=n2147 B2=n2152
XU2981 XNR2HS $PINS O=n3853 I1=n2149 I2=n2148
XU2982 XNR2HS $PINS O=n3851 I1=n2152 I2=n2151
XU2983 AOI13HS $PINS O=n2154 A1=n3857 B1=n2153 B2=n3853 B3=n3851
XU2984 OAI12HS $PINS O=n2174 A1=n3865 B1=n2154 B2=n3860
XU2985 OA22 $PINS O=n2170 A1=FE_OFN890_FE_DBTN34_n2158 A2=n2157
+ B1=FE_OFN744_FE_DBTN4_n1819 B2=n2155
XU2986 ND2S $PINS O=n2162 I1=Uy_pad_43 I2=n2159
XU2987 ND2S $PINS O=n2161 I1=Uy_pad[39] I2=n2160
XU2988 ND2S $PINS O=n2164 I1=n2162 I2=n2161
XU2989 MXL2HS $PINS OB=n2166 S=FE_OFN624_div_pos_reg_2 A=n2165 B=n2164
XU2990 OA22 $PINS O=n2169 A1=FE_OFN893_FE_DBTN18_n1690 A2=n2167 B1=n2166
+ B2=FE_OFN924_n2102
XU2991 NR2 $PINS O=n2172 I1=FE_OFN679_FE_DBTN37_n4365 I2=n2171
XU2992 XNR2HS $PINS O=n3866 I1=n2173 I2=n2172
XU2993 MUXB2T $PINS O=n2182 S=n3866 A=n2175 B=n2174 EB=n2176
XU2994 INV1S $PINS O=n2178 I=row_reg[0]
XU2995 OR2 $PINS O=n3931 I1=n2178 I2=n2177
XU2996 NR2 $PINS O=n2179 I1=n3931 I2=n2947
XU2997 ND2F $PINS O=n3867 I1=n2182 I2=n2179
XU2998 INV1S $PINS O=n2181 I=n2179
XU2999 INV1S $PINS O=n2180 I=FE_OFN516_n4245
XU3000 INV1S $PINS O=n2184 I=Vout[6]
XU3001 ND2T $PINS O=n3869 I1=n2182 I2=FE_OFN516_n4245
XU3002 OA222 $PINS O=n2186 A1=n2185 A2=FE_OFN2731_n3867 B1=n3871 B2=n2184
+ C1=n3869 C2=n2183
XU3003 INV1S $PINS O=n1083 I=n2186
XU3004 INV1S $PINS O=n2188 I=IxIy2[3]
XU3005 NR2 $PINS O=n3639 I1=Ix2_Iy2[2] I2=n2187
XU3006 NR2 $PINS O=n2190 I1=n3397 I2=n3639
XU3007 INV1S $PINS O=n3405 I=IxIy2[0]
XU3008 NR2 $PINS O=n3404 I1=Ix2_Iy2[0] I2=n3405
XU3009 ND2 $PINS O=n3400 I1=n3404 I2=n3634
XU3010 ND2 $PINS O=n3640 I1=n2187 I2=Ix2_Iy2[2]
XU3011 ND2S $PINS O=n3398 I1=n2188 I2=Ix2_Iy2[3]
XU3012 OAI12HS $PINS O=n2189 A1=n3398 B1=n3397 B2=n3640
XU3013 AOI12HS $PINS O=n3396 A1=n2189 B1=n2190 B2=n3400
XU3014 INV1S $PINS O=n2191 I=IxIy2[4]
XU3015 NR2 $PINS O=n3651 I1=Ix2_Iy2[4] I2=n2191
XU3016 ND2 $PINS O=n3652 I1=n2191 I2=Ix2_Iy2[4]
XU3017 OAI12HS $PINS O=n3394 A1=n3652 B1=n3396 B2=n3651
XU3018 INV1S $PINS O=n2192 I=IxIy2[5]
XU3019 OR2 $PINS O=n3657 I1=Ix2_Iy2[5] I2=n2192
XU3020 INV1S $PINS O=n2193 I=n3393
XU3021 INV1S $PINS O=n2194 I=IxIy2[6]
XU3022 NR2 $PINS O=n3662 I1=Ix2_Iy2[6] I2=n2194
XU3023 OAI12H $PINS O=n3390 A1=n3663 B1=n3392 B2=n3662
XU3024 INV1S $PINS O=n2195 I=IxIy2[7]
XU3025 OR2 $PINS O=n3668 I1=Ix2_Iy2[7] I2=n2195
XU3026 INV1S $PINS O=n2196 I=n3389
XU3027 AOI12H $PINS O=n3388 A1=n2196 B1=n3390 B2=n3668
XU3028 INV1S $PINS O=n2197 I=IxIy2[8]
XU3029 NR2 $PINS O=n3673 I1=Ix2_Iy2[8] I2=n2197
XU3030 OAI12H $PINS O=n3386 A1=n3674 B1=n3388 B2=n3673
XU3031 INV1S $PINS O=n2198 I=IxIy2[9]
XU3032 OR2 $PINS O=n3679 I1=Ix2_Iy2[9] I2=n2198
XU3033 INV1S $PINS O=n2199 I=n3385
XU3034 INV1S $PINS O=n2200 I=IxIy2[10]
XU3035 NR2 $PINS O=n3685 I1=Ix2_Iy2[10] I2=n2200
XU3036 OAI12H $PINS O=n3382 A1=n3686 B1=n3384 B2=n3685
XU3037 INV1S $PINS O=n2201 I=IxIy2[11]
XU3038 OR2 $PINS O=n3691 I1=Ix2_Iy2[11] I2=n2201
XU3039 INV1S $PINS O=n2202 I=n3381
XU3040 INV1S $PINS O=n2203 I=IxIy2[12]
XU3041 NR2 $PINS O=n3696 I1=Ix2_Iy2[12] I2=n2203
XU3042 INV1S $PINS O=n2204 I=IxIy2[13]
XU3043 OR2 $PINS O=n3702 I1=Ix2_Iy2[13] I2=n2204
XU3044 INV1S $PINS O=n2205 I=n3377
XU3045 AOI12H $PINS O=n3376 A1=n2205 B1=n3378 B2=n3702
XU3046 INV1S $PINS O=n2206 I=IxIy2[14]
XU3047 NR2 $PINS O=n3707 I1=Ix2_Iy2[14] I2=n2206
XU3048 OAI12H $PINS O=n3374 A1=n3708 B1=n3376 B2=n3707
XU3049 INV1S $PINS O=n2207 I=IxIy2[15]
XU3050 OR2 $PINS O=n3713 I1=Ix2_Iy2[15] I2=n2207
XU3051 INV1S $PINS O=n2208 I=n3373
XU3052 AOI12H $PINS O=n3372 A1=n2208 B1=n3374 B2=n3713
XU3053 INV1S $PINS O=n2209 I=IxIy2[16]
XU3054 NR2 $PINS O=n3719 I1=Ix2_Iy2[16] I2=n2209
XU3055 OAI12H $PINS O=n3370 A1=n3720 B1=n3372 B2=n3719
XU3056 INV1S $PINS O=n2210 I=IxIy2[17]
XU3057 OR2 $PINS O=n3725 I1=Ix2_Iy2[17] I2=n2210
XU3058 INV1S $PINS O=n2211 I=n3369
XU3059 AOI12H $PINS O=n3368 A1=n2211 B1=n3370 B2=n3725
XU3060 INV1S $PINS O=n2212 I=IxIy2[18]
XU3061 NR2 $PINS O=n3730 I1=Ix2_Iy2[18] I2=n2212
XU3062 OAI12H $PINS O=n3366 A1=n3731 B1=n3368 B2=n3730
XU3063 INV1S $PINS O=n2213 I=IxIy2[19]
XU3064 OR2 $PINS O=n3736 I1=Ix2_Iy2[19] I2=n2213
XU3065 INV1S $PINS O=n2214 I=n3365
XU3066 INV1S $PINS O=n2215 I=IxIy2[20]
XU3067 NR2 $PINS O=n3741 I1=Ix2_Iy2[20] I2=n2215
XU3068 INV1S $PINS O=n2216 I=IxIy2[21]
XU3069 OR2 $PINS O=n3747 I1=Ix2_Iy2[21] I2=n2216
XU3070 INV1S $PINS O=n2217 I=n3361
XU3071 AOI12H $PINS O=n3360 A1=n2217 B1=n3362 B2=n3747
XU3072 INV1S $PINS O=n2218 I=IxIy2[22]
XU3073 NR2 $PINS O=n3753 I1=Ix2_Iy2[22] I2=n2218
XU3074 OAI12H $PINS O=n3358 A1=n3754 B1=n3360 B2=n3753
XU3075 INV1S $PINS O=n2219 I=IxIy2[23]
XU3076 OR2 $PINS O=n3759 I1=Ix2_Iy2[23] I2=n2219
XU3077 INV1S $PINS O=n2220 I=n3357
XU3078 AOI12H $PINS O=n3356 A1=n2220 B1=n3358 B2=n3759
XU3079 INV1S $PINS O=n2221 I=IxIy2[24]
XU3080 NR2 $PINS O=n3764 I1=Ix2_Iy2[24] I2=n2221
XU3081 OAI12H $PINS O=n3354 A1=n3765 B1=n3356 B2=n3764
XU3082 INV1S $PINS O=n2222 I=IxIy2[25]
XU3083 OR2 $PINS O=n3771 I1=Ix2_Iy2[25] I2=n2222
XU3084 INV1S $PINS O=n2223 I=n3353
XU3085 AOI12H $PINS O=n3352 A1=n2223 B1=n3354 B2=n3771
XU3086 INV1S $PINS O=n2224 I=IxIy2[26]
XU3087 NR2 $PINS O=n3776 I1=Ix2_Iy2[26] I2=n2224
XU3088 OAI12H $PINS O=n3350 A1=n3777 B1=n3352 B2=n3776
XU3089 INV1S $PINS O=n2225 I=IxIy2[27]
XU3090 OR2 $PINS O=n3782 I1=Ix2_Iy2[27] I2=n2225
XU3091 INV1S $PINS O=n2226 I=n3349
XU3092 AOI12H $PINS O=n3348 A1=n2226 B1=n3350 B2=n3782
XU3093 INV1S $PINS O=n2227 I=IxIy2[28]
XU3094 NR2 $PINS O=n3788 I1=Ix2_Iy2[28] I2=n2227
XU3095 INV1S $PINS O=n2228 I=IxIy2[29]
XU3096 OR2 $PINS O=n3794 I1=Ix2_Iy2[29] I2=n2228
XU3097 INV1S $PINS O=n2229 I=n3345
XU3098 AOI12H $PINS O=n3344 A1=n2229 B1=n3346 B2=n3794
XU3099 INV1S $PINS O=n2230 I=IxIy2[30]
XU3100 NR2 $PINS O=n3799 I1=Ix2_Iy2[30] I2=n2230
XU3102 INV1S $PINS O=n2231 I=Ix2_Iy2[31]
XU3103 OR2 $PINS O=n3340 I1=n2231 I2=IxIy2[31]
XU3104 INV1S $PINS O=n2232 I=n3339
XU3105 AOI12H $PINS O=n3751 A1=n2232 B1=n3341 B2=n3340
XU3108 ND2 $PINS O=n2237 I1=FE_OFN530_a_reg_0 I2=img1[12][0]
XU3110 INV1S $PINS O=n3977 I=Ix2[20]
XU3112 AOI13HS $PINS O=n3974 A1=FE_OFN428_intadd_21_SUM_6
+ B1=FE_OFN432_intadd_21_SUM_5 B2=FE_OFN443_intadd_21_n1 B3=n1575
XU3114 NR2 $PINS O=n2234 I1=FE_OFN432_intadd_21_SUM_5 I2=FE_OFN748_n1495
XU3115 MOAI1S $PINS O=n2235 A1=intadd_1/n1 A2=n2234 B1=intadd_1/n1 B2=n2234
XU3117 NR2 $PINS O=n2260 I1=Ix2[13] I2=intadd_1/SUM[8]
XU3118 NR2 $PINS O=n2257 I1=Ix2[11] I2=intadd_1/SUM[6]
XU3119 NR2 $PINS O=n2254 I1=Ix2[9] I2=intadd_1/SUM[4]
XU3120 NR2 $PINS O=n2251 I1=FE_PHN3282_Ix2_7 I2=intadd_1/SUM[2]
XU3121 AN2 $PINS O=n2250 I1=intadd_1/SUM[1] I2=Ix2[6]
XU3122 NR2 $PINS O=n2248 I1=Ix2[5] I2=intadd_1/SUM[0]
XU3124 XOR2HS $PINS O=n2236 I1=img1[12][1] I2=intadd_14/B[0]
XU3125 XNR2HS $PINS O=n2238 I1=img1[12][3] I2=intadd_14/B[2]
XU3126 NR2 $PINS O=n2239 I1=FE_OFN4133_n4336 I2=FE_OFN360_FE_DBTN13_n4339
XU3127 MUX3 $PINS O=n2972 S0=FE_OFN4136_n4336 S1=FE_OFN442_intadd_21_SUM_1
+ A=FE_OFN521_n4337 B=FE_OFN360_FE_DBTN13_n4339 C=n2239
XU3128 INV1S $PINS O=n2240 I=n2972
XU3129 NR2 $PINS O=n2247 I1=n1368 I2=n2240
XU3130 NR2 $PINS O=n2245 I1=Ix2[4] I2=n2972
XU3131 NR2 $PINS O=n2242 I1=FE_OFN520_n4337 I2=FE_OFN4133_n4336
XU3133 INV1S $PINS O=n3615 I=Ix2[2]
XU3134 INV1S $PINS O=n3606 I=Ix2[0]
XU3135 NR2 $PINS O=n2950 I1=FE_OFN823_n4336 I2=n3606
XU3136 INV1S $PINS O=n3951 I=FE_OFN520_n4337
XU3137 AOI22S $PINS O=n2952 A1=n2950 A2=Ix2[1] B1=FE_OFN823_n4336 B2=n3951
XU3138 NR2 $PINS O=n2967 I1=n3615 I2=n2952
XU3139 OA12 $PINS O=n2244 A1=n2967 B1=n2968 B2=FE_OFN547_Ix2_3
XU3140 AN2 $PINS O=n2243 I1=n2968 I2=FE_OFN547_Ix2_3
XU3141 NR2 $PINS O=n2971 I1=n2244 I2=n2243
XU3142 NR2 $PINS O=n2246 I1=n2245 I2=n2971
XU3143 NR2 $PINS O=n2998 I1=n2247 I2=n2246
XU3144 MOAI1S $PINS O=n3010 A1=n2248 A2=n2998 B1=Ix2[5] B2=intadd_1/SUM[0]
XU3145 OA12 $PINS O=n2249 A1=n3010 B1=intadd_1/SUM[1] B2=Ix2[6]
XU3146 NR2 $PINS O=n3017 I1=n2250 I2=n2249
XU3147 MOAI1S $PINS O=n3031 A1=n2251 A2=n3017 B1=FE_PHN3282_Ix2_7
+ B2=intadd_1/SUM[2]
XU3148 OA12 $PINS O=n2253 A1=n3031 B1=intadd_1/SUM[3] B2=Ix2[8]
XU3149 AN2 $PINS O=n2252 I1=intadd_1/SUM[3] I2=Ix2[8]
XU3150 NR2 $PINS O=n3033 I1=n2253 I2=n2252
XU3151 MOAI1S $PINS O=n3053 A1=n2254 A2=n3033 B1=Ix2[9] B2=intadd_1/SUM[4]
XU3152 OA12 $PINS O=n2256 A1=n3053 B1=intadd_1/SUM[5] B2=Ix2[10]
XU3153 AN2 $PINS O=n2255 I1=intadd_1/SUM[5] I2=Ix2[10]
XU3154 NR2 $PINS O=n3056 I1=n2256 I2=n2255
XU3155 MOAI1S $PINS O=n3077 A1=n2257 A2=n3056 B1=Ix2[11] B2=intadd_1/SUM[6]
XU3156 OA12 $PINS O=n2259 A1=n3077 B1=intadd_1/SUM[7] B2=Ix2[12]
XU3157 AN2 $PINS O=n2258 I1=intadd_1/SUM[7] I2=Ix2[12]
XU3158 NR2 $PINS O=n2719 I1=n2259 I2=n2258
XU3159 MOAI1S $PINS O=n2637 A1=n2260 A2=n2719 B1=Ix2[13] B2=intadd_1/SUM[8]
XU3160 AO12 $PINS O=n2261 A1=n2637 B1=intadd_1/SUM[9] B2=FE_OFN536_Ix2_14
XU3161 OAI12HS $PINS O=n2546 A1=n2261 B1=intadd_1/SUM[9] B2=FE_OFN536_Ix2_14
XU3162 AN2 $PINS O=n2262 I1=n2545 I2=n2707
XU3163 NR2P $PINS O=n3618 I1=n2263 I2=n2262
XU3164 NR2 $PINS O=n2846 I1=n2651 I2=n2549
XU3165 ND2S $PINS O=n2264 I1=FE_OFN533_Ix2_21 I2=n3979
XU3166 XOR2HS $PINS O=n2265 I1=n2264 I2=Ix2[22]
XU3170 NR2 $PINS O=n2266 I1=n4337 I2=FE_OFN442_intadd_21_SUM_1
XU3172 ND2S $PINS O=n3950 I1=n3951 I2=n4339
XU3173 MOAI1S $PINS O=intadd_1/B[0] A1=n2266 A2=n3950 B1=n2266 B2=n3950
XU3177 MOAI1S $PINS O=n2268 A1=FE_OFN4317_n A2=IxIy[14] B1=FE_OFN1574_n1710
+ B2=intadd_35/A[0]
XU3180 NR2 $PINS O=n3126 I1=n2268 I2=n2267
XU3183 AOI22S $PINS O=n2270 A1=FE_OFN688_FE_DBTN16_n1710 A2=IxIy[19]
+ B1=FE_OFN753_n1705 B2=FE_OFN580_IxIy_20
XU3184 OAI112HS $PINS O=n2510 A1=n2270 B1=n2269 C1=n2840 C2=FE_OFN472_n1709
XU3186 AOI22S $PINS O=n2275 A1=FE_OFN780_n2278 A2=n3126 B1=n2510
+ B2=FE_OFN1043_FE_DBTN2_n2466
XU3188 NR2 $PINS O=n3113 I1=n1290 I2=FE_OFN952_n4489
XU3189 INV1S $PINS O=n2882 I=n3113
XU3191 OAI22S $PINS O=n2273 A1=IxIy[11] A2=FE_OFN4198_FE_OFN479_n1710
+ B1=FE_OFN4317_n B2=IxIy[10]
XU3192 OAI22S $PINS O=n2272 A1=IxIy[13] A2=FE_OFN757_n1715 B1=IxIy[12]
+ B2=FE_OFN2730_FE_DBTN8_n1705
XU3193 NR2 $PINS O=n3124 I1=n2273 I2=n2272
XU3196 AOI22S $PINS O=n2280 A1=FE_OFN1043_FE_DBTN2_n2466 A2=n3126 B1=n2510
+ B2=n4489
XU3197 OAI22S $PINS O=n2277 A1=FE_OFN585_IxIy_7 A2=FE_OFN4198_FE_OFN479_n1710
+ B1=FE_OFN696_FE_DBTN7_n1709 B2=FE_OFN586_IxIy_6
XU3198 OAI22S $PINS O=n2276 A1=IxIy[9] A2=FE_OFN757_n1715 B1=FE_OFN584_IxIy_8
+ B2=FE_OFN909_FE_DBTN8_n1705
XU3199 NR2 $PINS O=n3125 I1=n2277 I2=n2276
XU3201 INV2 $PINS O=n2619 I=FE_OFN790_n2278
XU3204 AOI22S $PINS O=n2279 A1=n3125 A2=FE_OFN797_n2447 B1=n3124
+ B2=FE_OFN780_n2278
XU3207 NR2P $PINS O=n4231 I1=FE_OFN4268_n4234 I2=n2281
XU3208 NR2P $PINS O=n3330 I1=n4232 I2=n2282
XU3212 NR2 $PINS O=intadd_18/CI I1=FE_OFN330_FE_DBTN59_It_4_4
+ I2=FE_OFN4153_n4337
XU3214 INV1S $PINS O=n2530 I=Iy2_IxIt[17]
XU3215 INV1S $PINS O=n2290 I=Iy2_IxIt[1]
XU3216 NR2 $PINS O=n3486 I1=IxIy_IyIt[1] I2=n2290
XU3218 NR2 $PINS O=n3490 I1=n3491 I2=IxIy_IyIt[0]
XU3219 ND2S $PINS O=n3487 I1=n2290 I2=IxIy_IyIt[1]
XU3220 OAI12HS $PINS O=n3484 A1=n3487 B1=n3486 B2=n3490
XU3221 INV1S $PINS O=n2291 I=Iy2_IxIt[2]
XU3222 OR2 $PINS O=n3483 I1=IxIy_IyIt[2] I2=n2291
XU3223 ND2S $PINS O=n3482 I1=n2291 I2=IxIy_IyIt[2]
XU3224 INV1S $PINS O=n2292 I=n3482
XU3225 AOI12HS $PINS O=n3480 A1=n2292 B1=n3484 B2=n3483
XU3226 INV1S $PINS O=n2293 I=Iy2_IxIt[3]
XU3227 NR2 $PINS O=n3477 I1=IxIy_IyIt[3] I2=n2293
XU3228 OAI12H $PINS O=n3475 A1=n3478 B1=n3480 B2=n3477
XU3229 INV1S $PINS O=n2294 I=Iy2_IxIt[4]
XU3230 OR2 $PINS O=n3474 I1=IxIy_IyIt[4] I2=n2294
XU3231 INV1S $PINS O=n2295 I=n3473
XU3232 AOI12H $PINS O=n3471 A1=n2295 B1=n3475 B2=n3474
XU3233 INV1S $PINS O=n2296 I=Iy2_IxIt[5]
XU3234 NR2 $PINS O=n3468 I1=IxIy_IyIt[5] I2=n2296
XU3235 OAI12H $PINS O=n3466 A1=n3469 B1=n3471 B2=n3468
XU3236 INV1S $PINS O=n2297 I=Iy2_IxIt[6]
XU3237 OR2 $PINS O=n3465 I1=IxIy_IyIt[6] I2=n2297
XU3238 INV1S $PINS O=n2298 I=n3464
XU3239 AOI12H $PINS O=n3462 A1=n2298 B1=n3466 B2=n3465
XU3240 INV1S $PINS O=n2299 I=Iy2_IxIt[7]
XU3241 NR2 $PINS O=n3459 I1=IxIy_IyIt[7] I2=n2299
XU3242 OAI12H $PINS O=n3457 A1=n3460 B1=n3462 B2=n3459
XU3243 INV1S $PINS O=n2300 I=Iy2_IxIt[8]
XU3244 OR2 $PINS O=n3456 I1=IxIy_IyIt[8] I2=n2300
XU3245 INV1S $PINS O=n2301 I=n3455
XU3246 INV1S $PINS O=n2302 I=Iy2_IxIt[9]
XU3247 NR2 $PINS O=n3450 I1=IxIy_IyIt[9] I2=n2302
XU3248 OAI12H $PINS O=n3448 A1=n3451 B1=n3453 B2=n3450
XU3249 INV1S $PINS O=n2303 I=Iy2_IxIt[10]
XU3250 OR2 $PINS O=n3447 I1=IxIy_IyIt[10] I2=n2303
XU3251 INV1S $PINS O=n2304 I=n3446
XU3252 AOI12H $PINS O=n3444 A1=n2304 B1=n3448 B2=n3447
XU3253 INV1S $PINS O=n2305 I=Iy2_IxIt[11]
XU3254 NR2 $PINS O=n3441 I1=IxIy_IyIt[11] I2=n2305
XU3255 OAI12H $PINS O=n3439 A1=n3442 B1=n3444 B2=n3441
XU3256 INV1S $PINS O=n2306 I=Iy2_IxIt[12]
XU3257 OR2 $PINS O=n3438 I1=IxIy_IyIt[12] I2=n2306
XU3258 INV1S $PINS O=n2307 I=n3437
XU3259 INV1S $PINS O=n2308 I=Iy2_IxIt[13]
XU3260 NR2 $PINS O=n3432 I1=IxIy_IyIt[13] I2=n2308
XU3261 OAI12H $PINS O=n3430 A1=n3433 B1=n3435 B2=n3432
XU3262 INV1S $PINS O=n2309 I=Iy2_IxIt[14]
XU3263 OR2 $PINS O=n3429 I1=IxIy_IyIt[14] I2=n2309
XU3264 INV1S $PINS O=n2310 I=n3428
XU3265 AOI12H $PINS O=n3426 A1=n2310 B1=n3430 B2=n3429
XU3266 INV1S $PINS O=n2311 I=Iy2_IxIt[15]
XU3267 NR2 $PINS O=n3423 I1=IxIy_IyIt[15] I2=n2311
XU3268 OAI12HS $PINS O=n3421 A1=n3424 B1=n3426 B2=n3423
XU3269 INV1S $PINS O=n2312 I=Iy2_IxIt[16]
XU3270 OR2 $PINS O=n3420 I1=IxIy_IyIt[16] I2=n2312
XU3271 INV1S $PINS O=n2313 I=n3419
XU3272 AO12 $PINS O=n2529 A1=n2313 B1=n3421 B2=n3420
XU3273 INV1S $PINS O=n2526 I=Ix2_IyIt[17]
XU3274 INV1S $PINS O=n2314 I=Ix2_IyIt[1]
XU3275 NR2 $PINS O=n3577 I1=IxIy_IxIt[1] I2=n2314
XU3276 INV1S $PINS O=n3582 I=Ix2_IyIt[0]
XU3277 NR2 $PINS O=n3581 I1=n3582 I2=IxIy_IxIt[0]
XU3278 ND2S $PINS O=n3578 I1=n2314 I2=IxIy_IxIt[1]
XU3279 OAI12HS $PINS O=n3575 A1=n3578 B1=n3577 B2=n3581
XU3280 INV1S $PINS O=n2315 I=Ix2_IyIt[2]
XU3281 OR2 $PINS O=n3574 I1=IxIy_IxIt[2] I2=n2315
XU3282 ND2S $PINS O=n3573 I1=n2315 I2=IxIy_IxIt[2]
XU3283 INV1S $PINS O=n2316 I=n3573
XU3284 AOI12HS $PINS O=n3571 A1=n2316 B1=n3575 B2=n3574
XU3285 INV1S $PINS O=n2317 I=Ix2_IyIt[3]
XU3286 NR2 $PINS O=n3568 I1=IxIy_IxIt[3] I2=n2317
XU3287 OAI12H $PINS O=n3566 A1=n3569 B1=n3571 B2=n3568
XU3288 INV1S $PINS O=n2318 I=Ix2_IyIt[4]
XU3289 OR2 $PINS O=n3565 I1=IxIy_IxIt[4] I2=n2318
XU3290 INV1S $PINS O=n2319 I=n3564
XU3291 AOI12H $PINS O=n3562 A1=n2319 B1=n3566 B2=n3565
XU3292 INV1S $PINS O=n2320 I=Ix2_IyIt[5]
XU3293 NR2 $PINS O=n3559 I1=IxIy_IxIt[5] I2=n2320
XU3294 OAI12H $PINS O=n3557 A1=n3560 B1=n3562 B2=n3559
XU3295 INV1S $PINS O=n2321 I=Ix2_IyIt[6]
XU3296 OR2 $PINS O=n3556 I1=IxIy_IxIt[6] I2=n2321
XU3297 INV1S $PINS O=n2322 I=n3555
XU3298 AOI12H $PINS O=n3553 A1=n2322 B1=n3557 B2=n3556
XU3299 INV1S $PINS O=n2323 I=Ix2_IyIt[7]
XU3300 NR2 $PINS O=n3550 I1=IxIy_IxIt[7] I2=n2323
XU3301 OAI12H $PINS O=n3548 A1=n3551 B1=n3553 B2=n3550
XU3302 INV1S $PINS O=n2324 I=Ix2_IyIt[8]
XU3303 OR2 $PINS O=n3547 I1=IxIy_IxIt[8] I2=n2324
XU3304 INV1S $PINS O=n2325 I=n3546
XU3305 INV1S $PINS O=n2326 I=Ix2_IyIt[9]
XU3306 NR2 $PINS O=n3541 I1=IxIy_IxIt[9] I2=n2326
XU3307 INV1S $PINS O=n2327 I=Ix2_IyIt[10]
XU3308 OR2 $PINS O=n3538 I1=IxIy_IxIt[10] I2=n2327
XU3309 INV1S $PINS O=n2328 I=n3537
XU3310 AOI12H $PINS O=n3535 A1=n2328 B1=n3539 B2=n3538
XU3311 INV1S $PINS O=n2329 I=Ix2_IyIt[11]
XU3312 NR2 $PINS O=n3532 I1=IxIy_IxIt[11] I2=n2329
XU3313 INV1S $PINS O=n2330 I=Ix2_IyIt[12]
XU3314 OR2 $PINS O=n3529 I1=IxIy_IxIt[12] I2=n2330
XU3315 INV1S $PINS O=n2331 I=n3528
XU3316 AOI12H $PINS O=n3526 A1=n2331 B1=n3530 B2=n3529
XU3317 INV1S $PINS O=n2332 I=Ix2_IyIt[13]
XU3318 NR2 $PINS O=n3523 I1=IxIy_IxIt[13] I2=n2332
XU3319 OAI12H $PINS O=n3521 A1=n3524 B1=n3526 B2=n3523
XU3320 INV1S $PINS O=n2333 I=Ix2_IyIt[14]
XU3321 OR2 $PINS O=n3520 I1=IxIy_IxIt[14] I2=n2333
XU3322 INV1S $PINS O=n2334 I=n3519
XU3323 AOI12H $PINS O=n3517 A1=n2334 B1=n3521 B2=n3520
XU3324 INV1S $PINS O=n2335 I=Ix2_IyIt[15]
XU3325 NR2 $PINS O=n3514 I1=IxIy_IxIt[15] I2=n2335
XU3326 OAI12HS $PINS O=n3512 A1=n3515 B1=n3517 B2=n3514
XU3327 INV1S $PINS O=n2336 I=Ix2_IyIt[16]
XU3328 OR2 $PINS O=n3511 I1=IxIy_IxIt[16] I2=n2336
XU3329 INV1S $PINS O=n2337 I=n3510
XU3330 AO12 $PINS O=n2525 A1=n2337 B1=n3512 B2=n3511
XU3333 AOI22S $PINS O=n2339 A1=FE_OFN4262_n1709 A2=intadd_35/A[0]
+ B1=FE_OFN1574_n1710 B2=intadd_35/A[1]
XU3334 OAI112HS $PINS O=n2647 A1=n2340 B1=n2339 C1=FE_OFN1629_IxIy_17
+ C2=FE_OFN909_FE_DBTN8_n1705
XU3335 ND2 $PINS O=n2348 I1=n2447 I2=FE_DBTN40_shift_amount_reg_1
XU3337 ND2S $PINS O=n2349 I1=n2447 I2=shift_amount_reg[1]
XU3338 NR2 $PINS O=n2902 I1=shift_amount_reg[0] I2=n2349
XU3339 AOI22S $PINS O=n2343 A1=FE_OFN352_FE_DBTN23_n4483 A2=FE_OFN589_IxIy_3
+ B1=n4180 B2=n2902
XU3340 OA12 $PINS O=n2354 A1=n2343 B1=FE_OFN952_n4489 B2=n2647
XU3342 OAI22S $PINS O=n2345 A1=FE_OFN584_IxIy_8 A2=FE_OFN4198_FE_OFN479_n1710
+ B1=FE_OFN4317_n B2=FE_OFN585_IxIy_7
XU3343 OAI22S $PINS O=n2344 A1=IxIy[10] A2=FE_OFN757_n1715 B1=FE_OFN1668_IxIy_9
+ B2=FE_OFN909_FE_DBTN8_n1705
XU3344 NR2 $PINS O=n2642 I1=n2345 I2=n2344
XU3346 OAI22S $PINS O=n2347 A1=IxIy[12] A2=FE_OFN4198_FE_OFN479_n1710
+ B1=FE_OFN4317_n B2=IxIy[11]
XU3347 OAI22S $PINS O=n2346 A1=IxIy[14] A2=FE_OFN757_n1715 B1=IxIy[13]
+ B2=FE_OFN2730_FE_DBTN8_n1705
XU3348 AOI22S $PINS O=n2353 A1=n2642 A2=FE_OFN784_n2278 B1=n2644
+ B2=FE_OFN4345_n
XU3349 NR2 $PINS O=n3611 I1=n2350 I2=n2348
XU3350 AOI22S $PINS O=n2352 A1=n3611 A2=FE_OFN588_IxIy_4 B1=FE_OFN586_IxIy_6
+ B2=FE_OFN351_FE_DBTN24_n2351
XU3351 ND3P $PINS O=IxIy_shift[3] I1=n2354 I2=n2353 I3=n2352
XU3353 INV1S $PINS O=intadd_24/A[4] I=IxIy[14]
XU3354 INV1S $PINS O=intadd_23/A[4] I=IyIt[14]
XU3355 INV1S $PINS O=intadd_24/A[3] I=IxIy[13]
XU3356 INV1S $PINS O=intadd_24/A[2] I=IxIy[12]
XU3357 INV1S $PINS O=intadd_23/A[2] I=IyIt[12]
XU3358 INV1S $PINS O=intadd_24/A[1] I=IxIy[11]
XU3359 INV1S $PINS O=intadd_23/A[0] I=IyIt[10]
XU3360 ND3 $PINS O=n2499 I1=n3873 I2=n4331 I3=n4364
XU3361 NR2 $PINS O=n2357 I1=n3872 I2=n2499
XU3362 AOI22S $PINS O=n2361 A1=Ix2[0] A2=FE_OFN483_n2356 B1=FE_OFN489_n2357
+ B2=IxIt[0]
XU3363 INV1S $PINS O=n2358 I=n4331
XU3364 AOI22S $PINS O=n2360 A1=Iy2[0] A2=FE_OFN348_FE_DBTN35_n1689
+ B1=FE_OFN695_FE_DBTN15_n2359 B2=IxIy[0]
XU3365 INV1S $PINS O=n2427 I=n2356
XU3367 AOI22S $PINS O=n2364 A1=FE_OFN563_Iy2_20 A2=FE_OFN344_FE_DBTN35_n1689
+ B1=FE_OFN694_FE_DBTN15_n2359 B2=FE_OFN580_IxIy_20
XU3368 AOI22S $PINS O=n2363 A1=FE_OFN358_FE_DBTN19_n2355 A2=IyIt[20]
+ B1=FE_OFN488_n2357 B2=FE_OFN550_IxIt_20
XU3369 OA112 $PINS O=n3925 A1=n2364 B1=n2363 C1=n3977 C2=n2427
XU3370 AOI22S $PINS O=n2366 A1=FE_OFN358_FE_DBTN19_n2355 A2=IyIt[19]
+ B1=FE_OFN488_n2357 B2=FE_OFN551_IxIt_19
XU3371 AOI22S $PINS O=n2365 A1=FE_OFN564_Iy2_19 A2=FE_OFN344_FE_DBTN35_n1689
+ B1=FE_OFN694_FE_DBTN15_n2359 B2=IxIy[19]
XU3372 ND3 $PINS O=n3142 I1=n2367 I2=n2366 I3=n2365
XU3373 AOI22S $PINS O=n2369 A1=Iy2[18] A2=FE_OFN344_FE_DBTN35_n1689
+ B1=FE_OFN694_FE_DBTN15_n2359 B2=FE_OFN581_IxIy_18
XU3374 AOI22S $PINS O=n2368 A1=FE_OFN358_FE_DBTN19_n2355 A2=FE_OFN593_IyIt_18
+ B1=FE_OFN488_n2357 B2=FE_OFN553_IxIt_18
XU3375 OA112 $PINS O=n3918 A1=n2369 B1=n2368 C1=n2651 C2=n2427
XU3376 AOI22S $PINS O=n2371 A1=FE_OFN358_FE_DBTN19_n2355 A2=FE_OFN1665_IyIt_17
+ B1=FE_OFN486_n2357 B2=FE_OFN554_IxIt_17
XU3377 AOI22S $PINS O=n2370 A1=Iy2[17] A2=FE_OFN344_FE_DBTN35_n1689
+ B1=FE_OFN694_FE_DBTN15_n2359 B2=FE_OFN1629_IxIy_17
XU3378 ND3 $PINS O=n2641 I1=n2372 I2=n2371 I3=n2370
XU3381 NR2 $PINS O=n2373 I1=intadd_34/A[1] I2=n2355
XU3382 AN4B1S $PINS O=n2377 I1=n2376 I2=n2375 I3=n2374 B1=n2373
XU3383 OA12 $PINS O=n3915 A1=n2377 B1=FE_OFN490_n2359 B2=intadd_35/A[1]
XU3385 AOI22S $PINS O=n2379 A1=n2356 A2=Ix2[15] B1=FE_DBTN35_n1689
+ B2=FE_OFN1762_Iy2_15
XU3386 AOI22S $PINS O=n2378 A1=FE_OFN356_FE_DBTN19_n2355 A2=IyIt[15]
+ B1=FE_OFN486_n2357 B2=IxIt[15]
XU3387 OAI112HS $PINS O=n3132 A1=n2379 B1=n2378 C1=FE_OFN490_n2359
+ C2=intadd_35/A[0]
XU3388 NR2 $PINS O=n2380 I1=intadd_23/A[4] I2=n2355
XU3389 AN4B1S $PINS O=n2384 I1=n2383 I2=n2382 I3=n2381 B1=n2380
XU3390 OA12 $PINS O=n3912 A1=n2384 B1=FE_OFN490_n2359 B2=intadd_24/A[4]
XU3391 AOI22S $PINS O=n2386 A1=n2356 A2=FE_OFN537_Ix2_13
+ B1=FE_OFN345_FE_DBTN35_n1689 B2=FE_OFN567_Iy2_13
XU3392 AOI22S $PINS O=n2385 A1=FE_DBTN19_n2355 A2=IyIt[13] B1=n2357 B2=IxIt[13]
XU3393 OAI112HS $PINS O=n2663 A1=n2386 B1=n2385 C1=FE_OFN490_n2359
+ C2=intadd_24/A[3]
XU3394 NR2 $PINS O=n2387 I1=intadd_23/A[2] I2=n2355
XU3395 AN4B1S $PINS O=n2391 I1=n2390 I2=n2389 I3=n2388 B1=n2387
XU3396 OA12 $PINS O=n3909 A1=n2391 B1=n2359 B2=intadd_24/A[2]
XU3397 AOI22S $PINS O=n2393 A1=n2356 A2=FE_OFN539_Ix2_11
+ B1=FE_OFN345_FE_DBTN35_n1689 B2=FE_OFN569_Iy2_11
XU3398 AOI22S $PINS O=n2392 A1=FE_DBTN19_n2355 A2=IyIt[11] B1=n2357 B2=IxIt[11]
XU3399 OAI112HS $PINS O=n2749 A1=n2393 B1=n2392 C1=n2359 C2=intadd_24/A[1]
XU3400 NR2 $PINS O=n2395 I1=n2355 I2=intadd_23/A[0]
XU3401 AO12 $PINS O=n2396 A1=n2395 B1=FE_OFN540_Ix2_10 B2=FE_OFN483_n2356
XU3402 AN4B1S $PINS O=n3906 I1=n2399 I2=n2398 I3=n2397 B1=n2396
XU3403 AOI22S $PINS O=n2400 A1=FE_OFN356_FE_DBTN19_n2355 A2=FE_OFN595_IyIt_9
+ B1=FE_OFN487_n2357 B2=IxIt[9]
XU3404 ND3 $PINS O=n2403 I1=n2402 I2=n2401 I3=n2400
XU3405 AO12 $PINS O=n3903 A1=n2403 B1=FE_DBTN15_n2359 B2=FE_OFN1668_IxIy_9
XU3406 INV1S $PINS O=n2406 I=FE_OFN584_IxIy_8
XU3407 AOI22S $PINS O=n2405 A1=FE_OFN483_n2356 A2=FE_OFN542_Ix2_8
+ B1=FE_OFN347_FE_DBTN35_n1689 B2=FE_OFN572_Iy2_8
XU3408 AOI22S $PINS O=n2404 A1=FE_OFN356_FE_DBTN19_n2355 A2=FE_OFN596_IyIt_8
+ B1=FE_OFN487_n2357 B2=FE_OFN556_IxIt_8
XU3409 OA112 $PINS O=n3900 A1=n2405 B1=n2404 C1=n2359 C2=n2406
XU3410 AOI22S $PINS O=n2407 A1=FE_OFN356_FE_DBTN19_n2355 A2=FE_OFN597_IyIt_7
+ B1=FE_OFN489_n2357 B2=FE_OFN557_IxIt_7
XU3411 ND3 $PINS O=n2410 I1=n2409 I2=n2408 I3=n2407
XU3412 AO12 $PINS O=n3897 A1=n2410 B1=FE_OFN695_FE_DBTN15_n2359 B2=IxIy[7]
XU3413 INV1S $PINS O=n4188 I=FE_OFN586_IxIy_6
XU3414 AOI22S $PINS O=n2412 A1=FE_OFN483_n2356 A2=FE_OFN544_Ix2_6
+ B1=FE_OFN348_FE_DBTN35_n1689 B2=FE_OFN574_Iy2_6
XU3415 AOI22S $PINS O=n2411 A1=FE_DBTN19_n2355 A2=FE_OFN598_IyIt_6 B1=n2357
+ B2=FE_OFN558_IxIt_6
XU3416 OA112 $PINS O=n3894 A1=n2412 B1=n2411 C1=n2359 C2=n4188
XU3417 AOI22S $PINS O=n2413 A1=FE_OFN357_FE_DBTN19_n2355 A2=n4265
+ B1=FE_OFN489_n2357 B2=FE_OFN1669_IxIt_5
XU3418 ND3 $PINS O=n2416 I1=n2415 I2=n2414 I3=n2413
XU3419 AO12 $PINS O=n3891 A1=n2416 B1=FE_OFN695_FE_DBTN15_n2359 B2=n4180
XU3420 INV1S $PINS O=n4171 I=FE_OFN588_IxIy_4
XU3421 AOI22S $PINS O=n2419 A1=FE_OFN483_n2356 A2=FE_OFN546_Ix2_4
+ B1=FE_OFN348_FE_DBTN35_n1689 B2=Iy2[4]
XU3422 AOI22S $PINS O=n2418 A1=FE_OFN357_FE_DBTN19_n2355 A2=FE_OFN600_IyIt_4
+ B1=n2357 B2=FE_OFN559_IxIt_4
XU3423 OA112 $PINS O=n3888 A1=n2419 B1=n2418 C1=n2359 C2=n4171
XU3424 AOI22S $PINS O=n2421 A1=FE_OFN357_FE_DBTN19_n2355 A2=FE_OFN601_IyIt_3
+ B1=FE_OFN489_n2357 B2=FE_OFN560_IxIt_3
XU3425 ND3 $PINS O=n2424 I1=n2423 I2=n2422 I3=n2421
XU3426 AO12 $PINS O=n3885 A1=n2424 B1=FE_OFN695_FE_DBTN15_n2359
+ B2=FE_OFN589_IxIy_3
XU3427 AOI22S $PINS O=n2426 A1=Iy2[2] A2=FE_OFN348_FE_DBTN35_n1689
+ B1=FE_OFN695_FE_DBTN15_n2359 B2=FE_OFN1707_IxIy_2
XU3428 AOI22S $PINS O=n2425 A1=FE_OFN357_FE_DBTN19_n2355 A2=IyIt[2]
+ B1=FE_OFN489_n2357 B2=IxIt[2]
XU3429 OA112 $PINS O=n3882 A1=n2426 B1=n2425 C1=n3615 C2=n2427
XU3430 AOI22S $PINS O=n2429 A1=Ix2[1] A2=FE_OFN483_n2356 B1=FE_OFN489_n2357
+ B2=IxIt[1]
XU3431 AOI22S $PINS O=n2428 A1=Iy2[1] A2=FE_OFN348_FE_DBTN35_n1689
+ B1=FE_OFN695_FE_DBTN15_n2359 B2=IxIy[1]
XU3432 NR2 $PINS O=n3880 I1=mul_src[0] I2=n3879
XU3433 ND2S $PINS O=n3883 I1=n3882 I2=n3880
XU3434 NR2 $PINS O=n3886 I1=n3885 I2=n3883
XU3435 ND2S $PINS O=n3889 I1=n3888 I2=n3886
XU3436 NR2 $PINS O=n3892 I1=n3891 I2=n3889
XU3437 ND2S $PINS O=n3895 I1=n3894 I2=n3892
XU3438 NR2 $PINS O=n3898 I1=n3897 I2=n3895
XU3439 ND2S $PINS O=n3901 I1=n3900 I2=n3898
XU3440 ND2S $PINS O=n2747 I1=n3906 I2=n3904
XU3441 NR2 $PINS O=n3916 I1=n2641 I2=n2639
XU3442 AOI22S $PINS O=n2432 A1=n1356 A2=FE_OFN482_n2356 B1=FE_OFN488_n2357
+ B2=FE_OFN548_IxIt_22
XU3443 AOI22S $PINS O=n2431 A1=FE_OFN1735_Iy2_22 A2=FE_OFN344_FE_DBTN35_n1689
+ B1=FE_OFN694_FE_DBTN15_n2359 B2=FE_OFN578_IxIy_22
XU3444 ND3 $PINS O=n3926 I1=n2433 I2=n2432 I3=n2431
XU3445 INV1S $PINS O=n3930 I=FE_OFN934_n3926
XU3446 MOAI1S $PINS O=mul_src_abs[20] A1=n3925 A2=n2434 B1=n3925 B2=n2434
XU3448 AOI22S $PINS O=n2436 A1=FE_OFN4234_FE_OFN899_FE_DBTN17_n1715 A2=IxIt[12]
+ B1=FE_OFN4195_FE_OFN910_FE_DBTN8_n1705 B2=IxIt[11]
XU3449 AOI22S $PINS O=n2435 A1=FE_DBTN7_n1709 A2=IxIt[9]
+ B1=FE_OFN693_FE_DBTN16_n1710 B2=IxIt[10]
XU3450 ND2 $PINS O=n2507 I1=n2436 I2=n2435
XU3453 OAI22S $PINS O=n2438 A1=IxIt[14] A2=FE_OFN481_n1710
+ B1=FE_OFN2734_FE_DBTN7_n1709 B2=IxIt[13]
XU3454 OAI22S $PINS O=n2437 A1=IxIt[16] A2=FE_OFN760_n1715 B1=IxIt[15]
+ B2=FE_OFN4187_FE_OFN906_FE_DBTN8_n1705
XU3455 NR2 $PINS O=n3305 I1=n2438 I2=n2437
XU3456 MUX2 $PINS O=n3200 S=FE_OFN605_shift_amount_reg_2 A=n2507 B=n3305
XU3458 NR2 $PINS O=n2603 I1=n1293 I2=FE_OFN952_n4489
XU3461 AOI22S $PINS O=n2443 A1=n2603 A2=FE_OFN472_n1709 B1=n3806
+ B2=FE_OFN549_IxIt_21
XU3463 OAI22S $PINS O=n2441 A1=FE_OFN553_IxIt_18 A2=FE_OFN4197_FE_OFN479_n1710
+ B1=FE_OFN472_n1709 B2=FE_OFN554_IxIt_17
XU3464 OAI22S $PINS O=n2440 A1=FE_OFN550_IxIt_20 A2=FE_OFN764_n1715
+ B1=FE_OFN551_IxIt_19 B2=FE_OFN4188_FE_OFN906_FE_DBTN8_n1705
XU3465 NR2 $PINS O=n3303 I1=n2441 I2=n2440
XU3467 OAI22S $PINS O=n2446 A1=IxIt[16] A2=FE_OFN479_n1710 B1=FE_OFN464_n1709
+ B2=IxIt[15]
XU3468 OAI22S $PINS O=n2445 A1=FE_OFN553_IxIt_18 A2=FE_OFN764_n1715
+ B1=FE_OFN554_IxIt_17 B2=FE_OFN4188_FE_OFN906_FE_DBTN8_n1705
XU3471 AOI22S $PINS O=n2451 A1=FE_OFN897_FE_DBTN17_n1715 A2=FE_OFN548_IxIt_22
+ B1=FE_OFN753_n1705 B2=FE_OFN549_IxIt_21
XU3472 AOI22S $PINS O=n2450 A1=FE_OFN466_n1709 A2=FE_OFN551_IxIt_19
+ B1=FE_OFN688_FE_DBTN16_n1710 B2=FE_OFN550_IxIt_20
XU3475 ND3 $PINS O=IxIt_shift[15] I1=n2453 I2=n2452 I3=n2501
XU3476 OAI22S $PINS O=n2455 A1=IxIt[11] A2=FE_OFN481_n1710
+ B1=FE_OFN2740_FE_DBTN7_n1709 B2=IxIt[10]
XU3477 OAI22S $PINS O=n2454 A1=IxIt[13] A2=FE_OFN760_n1715 B1=IxIt[12]
+ B2=FE_OFN4186_FE_OFN906_FE_DBTN8_n1705
XU3478 NR2 $PINS O=n3203 I1=n2455 I2=n2454
XU3480 OAI22S $PINS O=n2457 A1=IxIt[15] A2=FE_OFN479_n1710 B1=FE_OFN464_n1709
+ B2=IxIt[14]
XU3481 OAI22S $PINS O=n2456 A1=FE_OFN554_IxIt_17 A2=FE_OFN760_n1715 B1=IxIt[16]
+ B2=FE_OFN4187_FE_OFN906_FE_DBTN8_n1705
XU3483 AOI22S $PINS O=n2463 A1=n3203 A2=FE_OFN784_n2278 B1=n3205
+ B2=FE_OFN1039_FE_DBTN2_n2466
XU3485 OAI22S $PINS O=n2459 A1=FE_OFN557_IxIt_7 A2=FE_DBTN16_n1710
+ B1=FE_OFN4359_n B2=FE_OFN558_IxIt_6
XU3486 OAI22S $PINS O=n2458 A1=IxIt[9] A2=FE_OFN4310_n B1=FE_OFN556_IxIt_8
+ B2=FE_OFN4186_FE_OFN906_FE_DBTN8_n1705
XU3487 NR2P $PINS O=n3204 I1=n2459 I2=n2458
XU3488 AOI22S $PINS O=n2461 A1=FE_OFN897_FE_DBTN17_n1715 A2=FE_OFN549_IxIt_21
+ B1=FE_OFN753_n1705 B2=FE_OFN550_IxIt_20
XU3489 AOI22S $PINS O=n2460 A1=FE_OFN697_FE_DBTN7_n1709 A2=FE_OFN553_IxIt_18
+ B1=FE_OFN692_FE_DBTN16_n1710 B2=FE_OFN551_IxIt_19
XU3490 AOI22S $PINS O=n2462 A1=n3204 A2=FE_OFN792_n2447 B1=n2602
+ B2=FE_OFN4266_FE_OFN1030_FE_DBTN41_n4489
XU3493 AOI22S $PINS O=n2464 A1=FE_DBTN7_n1709 A2=intadd_34/A[0]
+ B1=FE_OFN2729_n1710 B2=intadd_34/A[1]
XU3494 OAI112HS $PINS O=n3251 A1=n2465 B1=n2464 C1=FE_OFN1665_IyIt_17
+ C2=FE_OFN4320_n
XU3496 OAI22S $PINS O=n2468 A1=FE_OFN596_IyIt_8 A2=FE_OFN4313_n B1=FE_OFN4358_n
+ B2=FE_OFN597_IyIt_7
XU3497 OAI22S $PINS O=n2467 A1=IyIt[10] A2=FE_OFN4310_n B1=FE_OFN4114_n
+ B2=FE_OFN595_IyIt_9
XU3498 NR2 $PINS O=n3255 I1=n2468 I2=n2467
XU3499 AOI22S $PINS O=n2471 A1=FE_OFN895_FE_DBTN17_n1715 A2=IyIt[22]
+ B1=FE_DBTN8_n1705 B2=IyIt[21]
XU3501 AOI22S $PINS O=n2470 A1=FE_OFN470_n1709 A2=IyIt[19]
+ B1=FE_OFN686_FE_DBTN16_n1710 B2=FE_OFN592_IyIt_20
XU3502 AOI22S $PINS O=n2475 A1=FE_OFN801_n2447 A2=n3255 B1=n2676
+ B2=FE_OFN955_n4489
XU3503 OAI22S $PINS O=n2473 A1=IyIt[12] A2=FE_OFN4313_n B1=FE_OFN4358_n
+ B2=IyIt[11]
XU3504 OAI22S $PINS O=n2472 A1=IyIt[14] A2=FE_OFN4310_n B1=FE_OFN4320_n
+ B2=IyIt[13]
XU3507 AOI22S $PINS O=n2476 A1=FE_OFN470_n1709 A2=FE_OFN594_IyIt_17
+ B1=FE_DBTN8_n1705 B2=FE_OFN518_n4316
XU3508 OAI112HS $PINS O=n3826 A1=n2477 B1=n2476 C1=FE_OFN592_IyIt_20
+ C2=FE_OFN763_n1715
XU3509 AOI22S $PINS O=n2479 A1=FE_OFN4233_FE_OFN899_FE_DBTN17_n1715 A2=IyIt[12]
+ B1=FE_OFN4196_FE_OFN910_FE_DBTN8_n1705 B2=IyIt[11]
XU3510 AOI22S $PINS O=n2478 A1=FE_OFN469_n1709 A2=FE_OFN595_IyIt_9
+ B1=FE_OFN4119_n B2=IyIt[10]
XU3511 ND2 $PINS O=n3233 I1=n2479 I2=n2478
XU3512 AOI22S $PINS O=n2481 A1=FE_OFN4233_FE_OFN899_FE_DBTN17_n1715
+ A2=FE_OFN596_IyIt_8 B1=FE_OFN4196_FE_OFN910_FE_DBTN8_n1705 B2=FE_OFN597_IyIt_7
XU3513 AOI22S $PINS O=n2480 A1=FE_OFN469_n1709 A2=n4265 B1=FE_OFN4119_n
+ B2=FE_OFN598_IyIt_6
XU3515 AOI22S $PINS O=n2485 A1=n3233 A2=FE_OFN4213_FE_OFN778_n2278
+ B1=FE_OFN796_n2447 B2=n3234
XU3516 OAI22S $PINS O=n2482 A1=IyIt[14] A2=FE_OFN481_n1710
+ B1=FE_OFN2740_FE_DBTN7_n1709 B2=IyIt[13]
XU3517 OAI112H $PINS O=IyIt_shift[5] A1=n2485 B1=n2484 C1=n3826
+ C2=FE_OFN1027_FE_DBTN41_n4489
XU3518 AOI22S $PINS O=n2488 A1=FE_OFN2742_FE_DBTN17_n1715 A2=FE_OFN538_Ix2_12
+ B1=FE_OFN4253_FE_DBTN8_n1705 B2=FE_OFN539_Ix2_11
XU3519 AOI22S $PINS O=n2487 A1=FE_OFN467_n1709 A2=FE_OFN541_Ix2_9
+ B1=FE_OFN2744_FE_DBTN16_n1710 B2=FE_OFN540_Ix2_10
XU3520 AOI22S $PINS O=n2490 A1=FE_OFN2727_FE_DBTN17_n1715 A2=FE_OFN542_Ix2_8
+ B1=FE_OFN4253_FE_DBTN8_n1705 B2=FE_OFN543_Ix2_7
XU3521 AOI22S $PINS O=n2489 A1=FE_OFN2736_n1709 A2=FE_OFN545_Ix2_5
+ B1=FE_OFN2744_FE_DBTN16_n1710 B2=FE_OFN544_Ix2_6
XU3522 AOI22S $PINS O=n2496 A1=n2750 A2=FE_OFN786_n2278 B1=FE_OFN796_n2447
+ B2=n2751
XU3523 OAI22S $PINS O=n2491 A1=Ix2[20] A2=FE_OFN763_n1715 B1=Ix2[19]
+ B2=FE_OFN751_n1705
XU3524 OAI22S $PINS O=n2494 A1=Ix2[14] A2=FE_OFN689_FE_DBTN16_n1710
+ B1=FE_OCPN0_n1709 B2=FE_OFN537_Ix2_13
XU3525 OAI22S $PINS O=n2493 A1=FE_OFN535_Ix2_16 A2=FE_OFN894_FE_DBTN17_n1715
+ B1=Ix2[15] B2=FE_OFN908_FE_DBTN8_n1705
XU3526 NR2 $PINS O=n3269 I1=n2494 I2=n2493
XU3528 AOI22S $PINS O=n2495 A1=n3271 A2=FE_OFN955_n4489 B1=n3269
+ B2=FE_OFN4344_n
XU3529 XNR2HS $PINS O=n2497 I1=Ix2[16] I2=n3618
XU3532 MOAI1S $PINS O=n1193 A1=n2497 A2=n1703 B1=FE_OFN939_n4099 B2=Ix2[16]
XU3533 INV1S $PINS O=n2500 I=n2498
XU3534 OAI112HS $PINS O=n2900 A1=n2499 B1=n1689 C1=n2500 C2=n2948
XU3535 INV1S $PINS O=n4329 I=n2900
XU3536 MOAI1S $PINS O=n1090 A1=n4329 A2=n3312 B1=FE_PHN3189_mul_pos_buffer_4
+ B2=n3931
XU3537 ND3 $PINS O=IxIt_shift[14] I1=n2503 I2=n2502 I3=n2501
XU3538 AOI22S $PINS O=n2509 A1=n3305 A2=FE_OFN4308_n
+ B1=FE_OFN4266_FE_OFN1030_FE_DBTN41_n4489 B2=n3303
XU3540 AOI22S $PINS O=n2506 A1=FE_OFN4233_FE_OFN899_FE_DBTN17_n1715
+ A2=FE_OFN556_IxIt_8 B1=FE_OFN4196_FE_OFN910_FE_DBTN8_n1705 B2=FE_OFN557_IxIt_7
XU3541 AOI22S $PINS O=n2505 A1=FE_OFN469_n1709 A2=FE_OFN1669_IxIt_5
+ B1=FE_OFN4119_n B2=FE_OFN558_IxIt_6
XU3543 AOI22S $PINS O=n2508 A1=n2507 A2=FE_OFN4214_FE_OFN778_n2278
+ B1=FE_OFN795_n2447 B2=n3195
XU3546 ND3 $PINS O=IxIy_shift[14] I1=n2512 I2=n2554 I3=n2511
XU3547 AOI22S $PINS O=n2514 A1=FE_OFN761_n1715 A2=FE_OFN568_Iy2_12
+ B1=FE_OFN910_FE_DBTN8_n1705 B2=FE_OFN569_Iy2_11
XU3548 AOI22S $PINS O=n2513 A1=FE_OCPN4373_n1709 A2=FE_OFN571_Iy2_9
+ B1=FE_OFN2728_FE_DBTN16_n1710 B2=FE_OFN570_Iy2_10
XU3549 AOI22S $PINS O=n2517 A1=FE_OFN761_n1715 A2=FE_OFN572_Iy2_8
+ B1=FE_OFN910_FE_DBTN8_n1705 B2=FE_OFN573_Iy2_7
XU3550 AOI22S $PINS O=n2516 A1=FE_OFN2738_FE_DBTN7_n1709 A2=FE_OFN575_Iy2_5
+ B1=FE_OFN693_FE_DBTN16_n1710 B2=FE_OFN574_Iy2_6
XU3551 AOI22S $PINS O=n2524 A1=n2860 A2=FE_OFN4214_FE_OFN778_n2278
+ B1=FE_OFN795_n2447 B2=n2861
XU3553 OAI22S $PINS O=n2518 A1=FE_OFN563_Iy2_20 A2=FE_OFN764_n1715
+ B1=FE_OFN564_Iy2_19 B2=FE_OFN4188_FE_OFN906_FE_DBTN8_n1705
XU3555 OAI22S $PINS O=n2522 A1=FE_OFN566_Iy2_14 A2=FE_OFN475_n1710
+ B1=FE_OFN2734_FE_DBTN7_n1709 B2=FE_OFN567_Iy2_13
XU3556 OAI22S $PINS O=n2521 A1=Iy2[16] A2=FE_DBTN17_n1715 B1=FE_OFN1762_Iy2_15
+ B2=FE_OFN907_FE_DBTN8_n1705
XU3558 AOI22S $PINS O=n2523 A1=n2868 A2=FE_DBTN41_n4489 B1=n2859
+ B2=FE_OFN4347_n
XU3559 INV1S $PINS O=n2534 I=Ix2_IyIt[19]
XU3560 FA1 $PINS S=Uy[17] CO=n3508 A=IxIy_IxIt[17] B=n2526 CI=n2525
XU3561 INV1S $PINS O=n2527 I=Ix2_IyIt[18]
XU3562 OR2 $PINS O=n3507 I1=IxIy_IxIt[18] I2=n2527
XU3563 INV1S $PINS O=n2528 I=n3506
XU3564 AO12 $PINS O=n2533 A1=n2528 B1=n3508 B2=n3507
XU3565 INV1S $PINS O=n2536 I=Iy2_IxIt[19]
XU3566 FA1 $PINS S=Ux[17] CO=n3417 A=IxIy_IyIt[17] B=n2530 CI=n2529
XU3567 INV1S $PINS O=n2531 I=Iy2_IxIt[18]
XU3568 OR2 $PINS O=n3416 I1=IxIy_IyIt[18] I2=n2531
XU3569 INV1S $PINS O=n2532 I=n3415
XU3570 AO12 $PINS O=n2535 A1=n2532 B1=n3417 B2=n3416
XU3571 INV1S $PINS O=n2538 I=Ix2_IyIt[20]
XU3572 FA1 $PINS S=Uy[19] CO=n2537 A=IxIy_IxIt[19] B=n2534 CI=n2533
XU3573 INV1S $PINS O=n2540 I=Iy2_IxIt[20]
XU3574 FA1 $PINS S=Ux[19] CO=n2539 A=IxIy_IyIt[19] B=n2536 CI=n2535
XU3575 INV1S $PINS O=n2544 I=Ix2_IyIt[21]
XU3576 FA1S $PINS S=Uy[20] CO=n2543 A=IxIy_IxIt[20] B=n2538 CI=n2537
XU3577 INV1S $PINS O=n2542 I=Iy2_IxIt[21]
XU3578 FA1S $PINS S=FE_PHN3261_Ux_20 CO=n2541 A=IxIy_IyIt[20] B=n2540 CI=n2539
XU3579 INV1S $PINS O=n2622 I=Iy2_IxIt[22]
XU3580 FA1S $PINS S=Ux[21] CO=n2621 A=IxIy_IyIt[21] B=n2542 CI=n2541
XU3581 INV1S $PINS O=n2626 I=Ix2_IyIt[22]
XU3582 FA1S $PINS S=Uy[21] CO=n2625 A=IxIy_IxIt[21] B=n2544 CI=n2543
XU3583 XNR3 $PINS O=n2547 I1=Ix2[15] I2=n2546 I3=n2545
XU3584 MOAI1S $PINS O=n1194 A1=n2547 A2=FE_OFN459_n1703 B1=FE_OFN939_n4099
+ B2=Ix2[15]
XU3585 MOAI1S $PINS O=n1191 A1=n2549 A2=n2548 B1=n3619 B2=FE_PHN3253_Ix2_18
XU3586 AOI22S $PINS O=n2552 A1=FE_OFN466_n1709 A2=IxIy[19]
+ B1=FE_OFN688_FE_DBTN16_n1710 B2=FE_OFN580_IxIy_20
XU3588 OAI112HS $PINS O=n2643 A1=n2552 B1=n2551
+ C1=FE_OFN4188_FE_OFN906_FE_DBTN8_n1705 C2=n1320
XU3589 OAI112HS $PINS O=n2620 A1=n2554 B1=n2553 C1=n2647 C2=FE_OFN930_n2924
XU3591 AOI13HS $PINS O=n4146 A1=FE_OFN392_intadd_14_SUM_6
+ B1=FE_OFN397_intadd_14_SUM_5 B2=FE_OFN421_intadd_14_n1
+ B3=FE_OFN1690_intadd_14_SUM_4
XU3593 NR2 $PINS O=n2555 I1=FE_OFN397_intadd_14_SUM_5 I2=n1439
XU3594 NR2 $PINS O=n2576 I1=Iy2[13] I2=intadd_0/SUM[8]
XU3595 NR2 $PINS O=n2573 I1=Iy2[11] I2=intadd_0/SUM[6]
XU3596 NR2 $PINS O=n2570 I1=Iy2[9] I2=intadd_0/SUM[4]
XU3597 NR2 $PINS O=n2567 I1=Iy2[7] I2=intadd_0/SUM[2]
XU3598 AN2 $PINS O=n2566 I1=intadd_0/SUM[1] I2=Iy2[6]
XU3599 NR2 $PINS O=n2564 I1=Iy2[5] I2=intadd_0/SUM[0]
XU3601 NR2 $PINS O=n2558 I1=FE_OFN414_intadd_14_SUM_1 I2=FE_OFN813_n4113
XU3603 ND2S $PINS O=n2557 I1=FE_OFN1749_n4113 I2=n4257
XU3604 MOAI1S $PINS O=n2959 A1=n2558 A2=n2557 B1=n2558 B2=n2557
XU3605 INV1S $PINS O=n3603 I=Iy2[2]
XU3606 AN2 $PINS O=n2995 I1=FE_OFN1749_n4113 I2=Iy2[0]
XU3607 AOI22S $PINS O=n2956 A1=FE_OFN814_n4113 A2=n4257 B1=Iy2[1] B2=n2995
XU3608 NR2 $PINS O=n2958 I1=n3603 I2=n2956
XU3609 OA12 $PINS O=n2560 A1=n2958 B1=n2959 B2=Iy2[3]
XU3610 AN2 $PINS O=n2559 I1=n2959 I2=Iy2[3]
XU3611 NR2 $PINS O=n2962 I1=n2560 I2=n2559
XU3615 NR2 $PINS O=n2561 I1=FE_OFN948_n4268 I2=FE_OFN409_intadd_14_SUM_2
XU3617 MUX3 $PINS O=n2963 S0=FE_OFN950_n4268 S1=FE_OFN414_intadd_14_SUM_1
+ A=FE_OFN420_intadd_14_SUM_0 B=FE_OFN410_intadd_14_SUM_2 C=n2561
XU3618 NR2 $PINS O=n2563 I1=FE_OFN576_Iy2_4 I2=n2963
XU3619 ND2S $PINS O=n2562 I1=n2963 I2=FE_OFN576_Iy2_4
XU3620 OA12 $PINS O=n2982 A1=n2562 B1=n2962 B2=n2563
XU3621 MOAI1S $PINS O=n3002 A1=n2564 A2=n2982 B1=Iy2[5] B2=intadd_0/SUM[0]
XU3622 OA12 $PINS O=n2565 A1=n3002 B1=intadd_0/SUM[1] B2=Iy2[6]
XU3623 NR2 $PINS O=n3008 I1=n2566 I2=n2565
XU3624 MOAI1S $PINS O=n3020 A1=n2567 A2=n3008 B1=Iy2[7] B2=intadd_0/SUM[2]
XU3625 OA12 $PINS O=n2569 A1=n3020 B1=intadd_0/SUM[3] B2=Iy2[8]
XU3626 AN2 $PINS O=n2568 I1=intadd_0/SUM[3] I2=Iy2[8]
XU3627 NR2 $PINS O=n3024 I1=n2569 I2=n2568
XU3628 MOAI1S $PINS O=n3035 A1=n2570 A2=n3024 B1=Iy2[9] B2=intadd_0/SUM[4]
XU3629 OA12 $PINS O=n2572 A1=n3035 B1=intadd_0/SUM[5] B2=Iy2[10]
XU3630 AN2 $PINS O=n2571 I1=intadd_0/SUM[5] I2=Iy2[10]
XU3631 NR2 $PINS O=n3051 I1=n2572 I2=n2571
XU3632 MOAI1 $PINS O=n3058 A1=n2573 A2=n3051 B1=Iy2[11] B2=intadd_0/SUM[6]
XU3633 OA12 $PINS O=n2575 A1=n3058 B1=intadd_0/SUM[7] B2=Iy2[12]
XU3634 AN2 $PINS O=n2574 I1=intadd_0/SUM[7] I2=Iy2[12]
XU3635 NR2 $PINS O=n3075 I1=n2575 I2=n2574
XU3636 MOAI1S $PINS O=n3088 A1=n2576 A2=n3075 B1=Iy2[13] B2=intadd_0/SUM[8]
XU3637 AO12 $PINS O=n2577 A1=n3088 B1=intadd_0/SUM[9] B2=Iy2[14]
XU3638 OAI12HS $PINS O=n2782 A1=n2577 B1=intadd_0/SUM[9] B2=FE_OFN566_Iy2_14
XU3639 OA12 $PINS O=n2579 A1=n2782 B1=n2781 B2=n2911
XU3640 AN2 $PINS O=n2578 I1=n2781 I2=n2911
XU3641 ND3 $PINS O=n2890 I1=n3093 I2=n2908 I3=Iy2[17]
XU3642 NR2P $PINS O=n2733 I1=n2888 I2=n2890
XU3644 AN2B1S $PINS O=n2784 I1=FE_OFN563_Iy2_20 B1=n2735
XU3645 XNR2HS $PINS O=n2580 I1=n2784 I2=Iy2[21]
XU3647 MOAI1S $PINS O=n1142 A1=n2580 A2=FE_OFN451_n1693 B1=Iy2[21]
+ B2=FE_OFN944_n4229
XU3648 NR2 $PINS O=n3314 I1=FE_OFN948_n4268 I2=FE_DBTN70_It_0_8
XU3649 MOAI1S $PINS O=intadd_2/B[0] A1=IyIt[8] A2=n3314 B1=IyIt[8] B2=n3314
XU3651 NR2 $PINS O=n3808 I1=FE_OFN590_IyIt_22 I2=FE_OFN1027_FE_DBTN41_n4489
XU3652 INV1S $PINS O=n2582 I=n3253
XU3653 NR2 $PINS O=n2583 I1=FE_OFN930_n2924 I2=n2582
XU3654 NR2 $PINS O=n2586 I1=n3808 I2=n2583
XU3656 OAI112HS $PINS O=IyIt_shift[11] A1=n2586 B1=n2585 C1=n3251
+ C2=FE_OFN927_n2619
XU3657 INV1S $PINS O=n2587 I=n2644
XU3658 NR2 $PINS O=n2588 I1=FE_OFN930_n2924 I2=n2587
XU3659 NR2 $PINS O=n2590 I1=n3113 I2=n2588
XU3661 AOI22S $PINS O=n2592 A1=FE_OFN899_FE_DBTN17_n1715 A2=IxIt[11]
+ B1=FE_OFN4195_FE_OFN910_FE_DBTN8_n1705 B2=IxIt[10]
XU3662 AOI22S $PINS O=n2591 A1=FE_DBTN7_n1709 A2=FE_OFN556_IxIt_8
+ B1=FE_OFN693_FE_DBTN16_n1710 B2=IxIt[9]
XU3664 OAI22S $PINS O=n2595 A1=IxIt[13] A2=FE_OFN481_n1710
+ B1=FE_OFN700_FE_DBTN7_n1709 B2=IxIt[12]
XU3665 OAI22S $PINS O=n2594 A1=IxIt[15] A2=FE_OFN760_n1715 B1=IxIt[14]
+ B2=FE_OFN4187_FE_OFN906_FE_DBTN8_n1705
XU3666 NR2 $PINS O=n2681 I1=n2595 I2=n2594
XU3667 MUX2 $PINS O=n3194 S=FE_OFN605_shift_amount_reg_2 A=n2684 B=n2681
XU3668 NR2 $PINS O=n2597 I1=FE_OFN550_IxIt_20 I2=FE_OFN472_n1709
XU3669 OAI22S $PINS O=n2596 A1=FE_OFN549_IxIt_21 A2=FE_OFN4197_FE_OFN479_n1710
+ B1=FE_OFN548_IxIt_22 B2=FE_OFN343_FE_DBTN40_shift_amount_reg_1
XU3670 NR2 $PINS O=n2606 I1=n2597 I2=n2596
XU3671 OAI22S $PINS O=n2599 A1=FE_OFN554_IxIt_17 A2=FE_OFN479_n1710
+ B1=FE_OFN464_n1709 B2=IxIt[16]
XU3672 OAI22S $PINS O=n2598 A1=FE_OFN551_IxIt_19 A2=FE_OFN764_n1715
+ B1=FE_OFN553_IxIt_18 B2=FE_OFN4188_FE_OFN906_FE_DBTN8_n1705
XU3673 NR2 $PINS O=n2680 I1=n2599 I2=n2598
XU3674 AOI22S $PINS O=n2600 A1=n2606 A2=FE_OFN1030_FE_DBTN41_n4489 B1=n2680
+ B2=FE_OFN4308_n
XU3676 AOI22S $PINS O=n2605 A1=n2602 A2=FE_OFN4345_n B1=FE_OFN784_n2278
+ B2=n3205
XU3677 INV1S $PINS O=n2811 I=n2603
XU3679 AOI22S $PINS O=n2608 A1=n2681 A2=n2447 B1=FE_OFN775_n2278 B2=n2680
XU3680 AOI22S $PINS O=n2610 A1=n2868 A2=n2278 B1=n2859 B2=FE_OFN791_n2447
XU3681 NR2 $PINS O=n3820 I1=FE_OCPN1_n1709 I2=FE_OFN4244_n2466
XU3682 OAI12HS $PINS O=n3819 A1=FE_OFN953_n4489 B1=FE_OFN4243_n2466
+ B2=FE_OFN470_n1709
XU3683 AOI22S $PINS O=n2609 A1=FE_OFN562_Iy2_21 A2=n3820 B1=n3819
+ B2=FE_OFN1735_Iy2_22
XU3686 AOI22S $PINS O=n2612 A1=FE_OFN699_FE_DBTN7_n1709 A2=FE_OFN582_IxIy_17
+ B1=FE_OFN749_n1705 B2=FE_OFN4268_n4234
XU3687 OAI112HS $PINS O=n3116 A1=n2613 B1=n2612 C1=IxIy[20] C2=FE_OFN757_n1715
XU3688 AOI22S $PINS O=n2618 A1=FE_OFN579_IxIy_21 A2=n3820 B1=n3819
+ B2=FE_OFN578_IxIy_22
XU3690 OAI22S $PINS O=n2615 A1=IxIy[14] A2=FE_OFN4198_FE_OFN479_n1710
+ B1=FE_OFN4317_n B2=IxIy[13]
XU3691 NR2 $PINS O=n2856 I1=n2616 I2=n2615
XU3692 OAI112H $PINS O=IxIy_shift[13] A1=n2618 B1=n2617 C1=n3116
+ C2=FE_OFN927_n2619
XU3693 INV1S $PINS O=n2632 I=Iy2_IxIt[24]
XU3694 FA1 $PINS S=Ux[22] CO=n3413 A=IxIy_IyIt[22] B=n2622 CI=n2621
XU3695 INV1S $PINS O=n2624 I=n3413
XU3696 INV1S $PINS O=n2623 I=Iy2_IxIt[23]
XU3697 NR2 $PINS O=n3410 I1=IxIy_IyIt[23] I2=n2623
XU3698 OAI12HS $PINS O=n2631 A1=n3411 B1=n2624 B2=n3410
XU3699 INV1S $PINS O=n2630 I=Ix2_IyIt[24]
XU3700 FA1 $PINS S=Uy[22] CO=n3504 A=IxIy_IxIt[22] B=n2626 CI=n2625
XU3701 INV1S $PINS O=n2628 I=n3504
XU3702 INV1S $PINS O=n2627 I=Ix2_IyIt[23]
XU3703 NR2 $PINS O=n3501 I1=IxIy_IxIt[23] I2=n2627
XU3704 OAI12HS $PINS O=n2629 A1=n3502 B1=n2628 B2=n3501
XU3705 INV1S $PINS O=n2634 I=Ix2_IyIt[25]
XU3706 FA1S $PINS S=Uy[24] CO=n2633 A=IxIy_IxIt[24] B=n2630 CI=n2629
XU3707 INV1S $PINS O=n2636 I=Iy2_IxIt[25]
XU3708 FA1S $PINS S=Ux[24] CO=n2635 A=IxIy_IyIt[24] B=n2632 CI=n2631
XU3709 INV1S $PINS O=n3290 I=Ix2_IyIt[26]
XU3710 FA1 $PINS S=Uy[25] CO=n3289 A=IxIy_IxIt[25] B=n2634 CI=n2633
XU3711 INV1S $PINS O=n3282 I=Iy2_IxIt[26]
XU3712 FA1 $PINS S=Ux[25] CO=n3281 A=IxIy_IyIt[25] B=n2636 CI=n2635
XU3713 XNR3 $PINS O=n2638 I1=FE_OFN536_Ix2_14 I2=intadd_1/SUM[9] I3=n2637
XU3714 MOAI1S $PINS O=n1195 A1=n2638 A2=FE_OFN462_n1703 B1=FE_OFN942_n4099
+ B2=FE_OFN536_Ix2_14
XU3715 MOAI1S $PINS O=n1169 A1=intadd_36/SUM[2] A2=FE_OFN461_n1703 B1=n4099
+ B2=FE_PHN3271_IxIt_17
XU3716 MOAI1S $PINS O=mul_src_abs[17] A1=n2641 A2=n2640 B1=n2641 B2=n2640
XU3717 AOI22S $PINS O=n2646 A1=n4489 A2=n2643 B1=n2642 B2=FE_OFN797_n2447
XU3718 OAI112HS $PINS O=IxIy_shift[7] A1=n2646 B1=n2645 C1=n2647
+ C2=FE_OFN4242_n2466
XU3719 OAI22S $PINS O=n2650 A1=Ix2[12] A2=FE_OFN2737_FE_DBTN16_n1710
+ B1=FE_OFN468_n1709 B2=FE_OFN539_Ix2_11
XU3720 OAI22S $PINS O=n2649 A1=Ix2[14] A2=FE_OFN894_FE_DBTN17_n1715 B1=Ix2[13]
+ B2=FE_OFN908_FE_DBTN8_n1705
XU3721 NR2 $PINS O=n3133 I1=n2650 I2=n2649
XU3722 INV1S $PINS O=n2705 I=Ix2[17]
XU3723 AOI22S $PINS O=n2653 A1=FE_OFN2727_FE_DBTN17_n1715 A2=n2651
+ B1=FE_OFN4253_FE_DBTN8_n1705 B2=n2705
XU3725 AOI22S $PINS O=n2652 A1=FE_OFN467_n1709 A2=n2707
+ B1=FE_OFN2732_FE_DBTN16_n1710 B2=n2703
XU3726 INV1S $PINS O=n2654 I=n3136
XU3727 AOI22S $PINS O=n2660 A1=FE_OFN789_n2278 A2=n3133 B1=n2654
+ B2=FE_OFN1041_FE_DBTN2_n2466
XU3728 OAI22S $PINS O=n2656 A1=FE_OFN542_Ix2_8 A2=FE_OFN2737_FE_DBTN16_n1710
+ B1=FE_OFN468_n1709 B2=FE_OFN543_Ix2_7
XU3729 OAI22S $PINS O=n2655 A1=Ix2[10] A2=FE_OFN894_FE_DBTN17_n1715 B1=Ix2[9]
+ B2=FE_OFN908_FE_DBTN8_n1705
XU3730 NR2 $PINS O=n3134 I1=n2656 I2=n2655
XU3731 AOI22S $PINS O=n2658 A1=FE_OFN895_FE_DBTN17_n1715 A2=Ix2[22]
+ B1=FE_DBTN8_n1705 B2=FE_OFN533_Ix2_21
XU3732 AOI22S $PINS O=n2657 A1=FE_OFN467_n1709 A2=Ix2[19]
+ B1=FE_OFN686_FE_DBTN16_n1710 B2=Ix2[20]
XU3734 AOI22S $PINS O=n2659 A1=n3134 A2=FE_OFN800_n2447 B1=n3118
+ B2=FE_OFN955_n4489
XU3736 MOAI1S $PINS O=mul_src_abs[13] A1=n2663 A2=n2662 B1=n2663 B2=n2662
XU3738 AOI22S $PINS O=n2667 A1=FE_OFN686_FE_DBTN16_n1710 A2=IyIt[19]
+ B1=FE_DBTN8_n1705 B2=FE_OFN592_IyIt_20
XU3739 OAI112HS $PINS O=n3143 A1=n2667 B1=n2666 C1=n2845 C2=FE_OFN4149_n
XU3743 AOI22S $PINS O=n2686 A1=n2681 A2=FE_OFN4308_n
+ B1=FE_OFN4266_FE_OFN1030_FE_DBTN41_n4489 B2=n2680
XU3744 AOI22S $PINS O=n2683 A1=FE_OFN4233_FE_OFN899_FE_DBTN17_n1715
+ A2=FE_OFN557_IxIt_7 B1=FE_OFN4196_FE_OFN910_FE_DBTN8_n1705 B2=FE_OFN558_IxIt_6
XU3745 AOI22S $PINS O=n2682 A1=FE_OFN469_n1709 A2=FE_OFN559_IxIt_4
+ B1=FE_OFN4119_n B2=FE_OFN1669_IxIt_5
XU3746 AOI22S $PINS O=n2685 A1=n2684 A2=FE_OFN4214_FE_OFN778_n2278
+ B1=FE_OFN795_n2447 B2=n3190
XU3747 INV1S $PINS O=n2910 I=Iy2[17]
XU3748 AOI22S $PINS O=n2688 A1=FE_OFN758_n1715 A2=n2888
+ B1=FE_OFN905_FE_DBTN8_n1705 B2=n2910
XU3750 AOI22S $PINS O=n2687 A1=FE_OFN697_FE_DBTN7_n1709 A2=n2911
+ B1=FE_OFN692_FE_DBTN16_n1710 B2=FE_OFN565_Iy2_16
XU3752 AOI22S $PINS O=n2690 A1=FE_OFN897_FE_DBTN17_n1715 A2=FE_OFN1735_Iy2_22
+ B1=FE_OFN905_FE_DBTN8_n1705 B2=FE_OFN562_Iy2_21
XU3753 AOI22S $PINS O=n2689 A1=FE_OFN470_n1709 A2=Iy2[19]
+ B1=FE_OFN688_FE_DBTN16_n1710 B2=FE_OFN563_Iy2_20
XU3754 ND2 $PINS O=n3184 I1=n2690 I2=n2689
XU3755 AOI22S $PINS O=n2693 A1=FE_OFN2742_FE_DBTN17_n1715 A2=FE_OFN539_Ix2_11
+ B1=FE_OFN4253_FE_DBTN8_n1705 B2=FE_OFN540_Ix2_10
XU3756 AOI22S $PINS O=n2692 A1=FE_OFN2736_n1709 A2=FE_OFN542_Ix2_8
+ B1=FE_OFN2744_FE_DBTN16_n1710 B2=FE_OFN541_Ix2_9
XU3757 OAI22S $PINS O=n2694 A1=FE_OFN537_Ix2_13 A2=FE_OFN689_FE_DBTN16_n1710
+ B1=FE_OCPN0_n1709 B2=FE_OFN538_Ix2_12
XU3758 MUX2 $PINS O=n3617 S=FE_OFN606_shift_amount_reg_2 A=n2832 B=n3261
XU3759 NR2 $PINS O=n2697 I1=Ix2[20] I2=FE_OFN4149_n
XU3760 OAI22S $PINS O=n2696 A1=FE_OFN533_Ix2_21 A2=FE_OFN687_FE_DBTN16_n1710
+ B1=n1356 B2=FE_OFN343_FE_DBTN40_shift_amount_reg_1
XU3761 NR2 $PINS O=n3264 I1=n2697 I2=n2696
XU3762 OAI22S $PINS O=n2700 A1=Ix2[17] A2=FE_OFN689_FE_DBTN16_n1710
+ B1=FE_OCPN0_n1709 B2=FE_OFN535_Ix2_16
XU3763 OAI22S $PINS O=n2699 A1=Ix2[19] A2=FE_OFN894_FE_DBTN17_n1715 B1=Ix2[18]
+ B2=FE_OFN751_n1705
XU3764 NR2 $PINS O=n3260 I1=n2700 I2=n2699
XU3765 AOI22S $PINS O=n2701 A1=n3264 A2=FE_OFN955_n4489 B1=n3260
+ B2=FE_OFN4344_n
XU3767 AOI22S $PINS O=n2710 A1=FE_OFN2727_FE_DBTN17_n1715 A2=n2705
+ B1=FE_OFN4253_FE_DBTN8_n1705 B2=n2703
XU3769 AOI22S $PINS O=n2709 A1=FE_OFN467_n1709 A2=n2708
+ B1=FE_OFN2732_FE_DBTN16_n1710 B2=n2707
XU3770 AOI22S $PINS O=n2713 A1=FE_OFN895_FE_DBTN17_n1715 A2=FE_OFN533_Ix2_21
+ B1=FE_DBTN8_n1705 B2=Ix2[20]
XU3771 AOI22S $PINS O=n2712 A1=FE_OFN467_n1709 A2=Ix2[18]
+ B1=FE_OFN2732_FE_DBTN16_n1710 B2=Ix2[19]
XU3772 ND2 $PINS O=n3628 I1=n2713 I2=n2712
XU3773 XOR3 $PINS O=n2720 I1=Ix2[13] I2=n2719 I3=intadd_1/SUM[8]
XU3774 MOAI1S $PINS O=n1196 A1=n2720 A2=FE_OFN458_n1703 B1=FE_OFN942_n4099
+ B2=Ix2[13]
XU3778 NR2 $PINS O=n3004 I1=FE_OFN400_intadd_14_SUM_4
+ I2=FE_OFN324_FE_DBTN63_It_0_0
XU3780 NR2 $PINS O=n2987 I1=FE_OFN403_intadd_14_SUM_3
+ I2=FE_OFN324_FE_DBTN63_It_0_0
XU3782 NR2 $PINS O=n2974 I1=FE_OFN407_intadd_14_SUM_2
+ I2=FE_OFN324_FE_DBTN63_It_0_0
XU3783 NR2 $PINS O=n4249 I1=FE_OFN1636_intadd_14_SUM_1
+ I2=FE_OFN324_FE_DBTN63_It_0_0
XU3784 ND2S $PINS O=n2721 I1=It[0][0] I2=FE_OFN951_n4268
XU3785 AN2B1S $PINS O=n2980 I1=IyIt[0] B1=n2721
XU3786 ND2S $PINS O=n4246 I1=It[0][1] I2=FE_OFN951_n4268
XU3787 MOAI1S $PINS O=n2979 A1=IyIt[1] A2=n4246 B1=IyIt[1] B2=n4246
XU3789 NR2 $PINS O=n2978 I1=FE_OFN418_intadd_14_SUM_0 I2=FE_DBTN63_It_0_0
XU3790 MAO222 $PINS O=n2976 A1=n4249 B1=intadd_7/SUM[0] C1=n4251
XU3791 MAO222 $PINS O=n2989 A1=n2974 B1=intadd_7/SUM[1] C1=n2976
XU3792 MAO222 $PINS O=n3006 A1=n2987 B1=intadd_7/SUM[2] C1=n2989
XU3793 MAO222 $PINS O=n3015 A1=n3004 B1=intadd_7/SUM[3] C1=n3006
XU3794 OR2 $PINS O=n3013 I1=intadd_28/SUM[3] I2=intadd_7/SUM[4]
XU3795 AOI22S $PINS O=n3029 A1=intadd_28/SUM[3] A2=intadd_7/SUM[4] B1=n3015
+ B2=n3013
XU3796 NR2 $PINS O=n3027 I1=intadd_7/SUM[5] I2=intadd_28/SUM[4]
XU3797 NR2 $PINS O=n2722 I1=n4276 I2=intadd_7/SUM[6]
XU3798 INV1S $PINS O=n2725 I=intadd_5/SUM[3]
XU3799 NR2 $PINS O=n2724 I1=FE_OFN422_intadd_14_n1 I2=FE_DBTN63_It_0_0
XU3800 MOAI1H $PINS O=n3045 A1=n2722 A2=n4275 B1=n4276 B2=intadd_7/SUM[6]
XU3801 NR2 $PINS O=n2726 I1=n3045 I2=intadd_7/n1
XU3802 INV1S $PINS O=n2728 I=intadd_5/SUM[4]
XU3803 FA1S $PINS S=n4275 CO=n2727 A=n2725 B=n2724 CI=n2723
XU3804 MOAI1 $PINS O=n4286 A1=n2726 A2=n3046 B1=n3045 B2=intadd_7/n1
XU3805 FA1S $PINS S=n3046 CO=n4288 A=n2729 B=n2728 CI=n2727
XU3806 INV1S $PINS O=n2730 I=n4288
XU3807 MAO222P $PINS O=n3060 A1=n4286 B1=intadd_6/SUM[6] C1=n2730
XU3808 MAO222 $PINS O=n3072 A1=intadd_5/SUM[6] B1=intadd_6/n1 C1=n3060
XU3809 MAO222 $PINS O=n3084 A1=n3072 B1=intadd_5/n1 C1=intadd_4/SUM[6]
XU3810 MAO222P $PINS O=n4305 A1=n3084 B1=intadd_4/n1 C1=intadd_3/SUM[6]
XU3811 MOAI1S $PINS O=n2731 A1=intadd_2/SUM[6] A2=n4305 B1=intadd_2/SUM[6]
+ B2=n4305
XU3812 MOAI1S $PINS O=n2732 A1=intadd_3/n1 A2=n2731 B1=intadd_3/n1 B2=n2731
XU3813 MOAI1S $PINS O=n1103 A1=FE_OFN1054_FE_DBTN0_n4229 A2=intadd_23/A[4]
+ B1=FE_OFN817_n4217 B2=n2732
XU3814 MOAI1S $PINS O=n1100 A1=intadd_34/SUM[2] A2=FE_OFN454_n1693
+ B1=FE_OFN947_n4229 B2=n1302
XU3815 XNR2HS $PINS O=n2734 I1=n2733 I2=FE_OFN564_Iy2_19
XU3816 MOAI1S $PINS O=n1144 A1=n2734 A2=FE_OFN449_n1693 B1=FE_PHN3220_Iy2_19
+ B2=FE_OFN944_n4229
XU3817 XOR2HS $PINS O=n2736 I1=n2735 I2=Iy2[20]
XU3819 MOAI1S $PINS O=n1143 A1=n2736 A2=FE_OFN449_n1693 B1=FE_OFN944_n4229
+ B2=Iy2[20]
XU3820 AOI22S $PINS O=n2738 A1=FE_OFN4248_FE_OFN758_n1715 A2=IxIy[12]
+ B1=FE_OFN749_n1705 B2=IxIy[11]
XU3821 AOI22S $PINS O=n2737 A1=FE_OFN4262_n1709 A2=IxIy[9] B1=FE_OFN1574_n1710
+ B2=IxIy[10]
XU3823 MUX2 $PINS O=n3112 S=shift_amount_reg[2] A=n2855 B=n2856
XU3824 AOI22S $PINS O=n2742 A1=FE_OFN761_n1715 A2=FE_OFN584_IxIy_8
+ B1=FE_OFN910_FE_DBTN8_n1705 B2=FE_OFN585_IxIy_7
XU3825 AOI22S $PINS O=n2741 A1=FE_OCPN4373_n1709 A2=n4180
+ B1=FE_OFN2728_FE_DBTN16_n1710 B2=FE_OFN586_IxIy_6
XU3827 AOI22S $PINS O=n2745 A1=FE_OFN588_IxIy_4 A2=FE_OFN351_FE_DBTN24_n2351
+ B1=n2854 B2=FE_OFN4214_FE_OFN778_n2278
XU3828 AOI22S $PINS O=n2744 A1=FE_OCPN2_n3611 A2=FE_OFN1707_IxIy_2
+ B1=FE_OFN1639_FE_DBTN23_n4483 B2=IxIy[1]
XU3829 ND3 $PINS O=n2746 I1=n2745 I2=n2744 I3=n2743
XU3830 AO12P $PINS O=IxIy_shift[1] A1=n2746 B1=shift_amount_reg[3] B2=n3112
XU3831 MOAI1S $PINS O=mul_src_abs[11] A1=n2749 A2=n2748 B1=n2749 B2=n2748
XU3832 NR2 $PINS O=n3316 I1=FE_OFN1751_n4113 I2=FE_DBTN54_Ix_0_8
XU3833 MOAI1S $PINS O=intadd_8/B[0] A1=IxIy[8] A2=n3316 B1=IxIy[8] B2=n3316
XU3834 MUX2 $PINS O=n2925 S=FE_OFN606_shift_amount_reg_2 A=n2750 B=n3269
XU3836 AOI22S $PINS O=n2753 A1=FE_OFN1661_n3611 A2=Ix2[2] B1=Ix2[1]
+ B2=FE_DBTN23_n4483
XU3837 ND3P $PINS O=n2755 I1=n2754 I2=n2753 I3=n2752
XU3838 AO12T $PINS O=Ix2_shift[1] A1=n2755 B1=n2925
+ B2=FE_OFN604_shift_amount_reg_3
XU3839 AOI22S $PINS O=n2758 A1=FE_OFN4233_FE_OFN899_FE_DBTN17_n1715 A2=IyIt[11]
+ B1=FE_OFN4196_FE_OFN910_FE_DBTN8_n1705 B2=IyIt[10]
XU3840 AOI22S $PINS O=n2757 A1=FE_OFN469_n1709 A2=FE_OFN596_IyIt_8
+ B1=FE_OFN4119_n B2=FE_OFN595_IyIt_9
XU3841 OAI22S $PINS O=n2760 A1=IyIt[13] A2=FE_OFN4313_n B1=FE_OFN4358_n
+ B2=IyIt[12]
XU3842 MUX2 $PINS O=n3232 S=FE_OFN606_shift_amount_reg_2 A=n3277 B=n3814
XU3843 OAI22S $PINS O=n2762 A1=IyIt[21] A2=FE_OFN687_FE_DBTN16_n1710
+ B1=IyIt[22] B2=FE_OFN343_FE_DBTN40_shift_amount_reg_1
XU3844 AO12 $PINS O=n3813 A1=n2762 B1=FE_OFN470_n1709 B2=n3337
XU3845 AOI22S $PINS O=n2766 A1=FE_OFN470_n1709 A2=intadd_34/A[1]
+ B1=FE_OFN2729_n1710 B2=FE_OFN594_IyIt_17
XU3846 OAI112HS $PINS O=n3818 A1=n2767 B1=n2766 C1=IyIt[19] C2=FE_OFN763_n1715
XU3847 OAI22S $PINS O=n2769 A1=FE_OFN1027_FE_DBTN41_n4489 A2=n3813 B1=n3818
+ B2=FE_OFN4244_n2466
XU3848 AO12 $PINS O=IyIt_shift[8] A1=n2769 B1=n3232
+ B2=FE_OFN681_FE_DBTN33_shift_amount_reg_3
XU3849 OAI22S $PINS O=n2773 A1=IxIt[12] A2=FE_OFN481_n1710
+ B1=FE_OFN700_FE_DBTN7_n1709 B2=IxIt[11]
XU3850 OAI22S $PINS O=n2772 A1=IxIt[14] A2=FE_OFN760_n1715 B1=IxIt[13]
+ B2=FE_OFN4186_FE_OFN906_FE_DBTN8_n1705
XU3851 NR2 $PINS O=n3211 I1=n2773 I2=n2772
XU3852 AOI22S $PINS O=n2780 A1=n3211 A2=FE_OFN784_n2278 B1=n3214
+ B2=FE_OFN4345_n
XU3853 OAI22S $PINS O=n2778 A1=FE_OFN556_IxIt_8 A2=FE_DBTN16_n1710
+ B1=FE_OFN4359_n B2=FE_OFN557_IxIt_7
XU3854 OAI22S $PINS O=n2777 A1=IxIt[10] A2=FE_OFN4310_n B1=IxIt[9]
+ B2=FE_OFN4186_FE_OFN906_FE_DBTN8_n1705
XU3855 NR2 $PINS O=n3213 I1=n2778 I2=n2777
XU3856 AOI22S $PINS O=n2779 A1=n3213 A2=FE_OFN792_n2447 B1=n2809
+ B2=FE_OFN4266_FE_OFN1030_FE_DBTN41_n4489
XU3857 XNR3 $PINS O=n2783 I1=Iy2[15] I2=n2782 I3=n2781
XU3859 MOAI1S $PINS O=n1148 A1=n2783 A2=FE_OFN448_n1693 B1=FE_OFN945_n4229
+ B2=FE_PHN3230_Iy2_15
XU3860 XOR2HS $PINS O=n2786 I1=n2785 I2=FE_OFN1735_Iy2_22
XU3861 MOAI1 $PINS O=n1141 A1=n2786 A2=FE_OFN451_n1693 B1=FE_OFN944_n4229
+ B2=FE_PHN3156_Iy2_22
XU3862 AOI22S $PINS O=n2791 A1=FE_OFN4262_n1709 A2=intadd_35/A[1]
+ B1=FE_OFN1574_n1710 B2=FE_OFN582_IxIy_17
XU3863 OAI112HS $PINS O=n2879 A1=n2792 B1=n2791 C1=FE_OFN514_n4234
+ C2=FE_OFN757_n1715
XU3864 AOI22S $PINS O=n2796 A1=FE_OFN4248_FE_OFN758_n1715 A2=IxIy[11]
+ B1=FE_OFN749_n1705 B2=IxIy[10]
XU3865 AOI22S $PINS O=n2795 A1=FE_OFN4262_n1709 A2=FE_OFN584_IxIy_8
+ B1=FE_OFN1574_n1710 B2=IxIy[9]
XU3866 AOI22S $PINS O=n2801 A1=FE_OFN761_n1715 A2=IxIy[7]
+ B1=FE_OFN910_FE_DBTN8_n1705 B2=FE_OFN586_IxIy_6
XU3867 AOI22S $PINS O=n2800 A1=FE_OCPN4373_n1709 A2=FE_OFN588_IxIy_4
+ B1=FE_OFN693_FE_DBTN16_n1710 B2=n4180
XU3868 AOI22S $PINS O=n2808 A1=n2872 A2=FE_OFN775_n2278 B1=FE_OFN792_n2447
+ B2=n2903
XU3869 OAI22S $PINS O=n2805 A1=IxIy[13] A2=FE_OFN4198_FE_OFN479_n1710
+ B1=FE_OFN4317_n B2=IxIy[12]
XU3870 AOI22S $PINS O=n2812 A1=n2809 A2=FE_OFN4308_n B1=FE_OFN775_n2278
+ B2=n3214
XU3871 ND3 $PINS O=IxIt_shift[11] I1=n2812 I2=n2811 I3=n2810
XU3872 MUX2 $PINS O=n3605 S=FE_OFN606_shift_amount_reg_2 A=n2813 B=n3219
XU3873 ND2 $PINS O=n2817 I1=n3605 I2=FE_OFN682_FE_DBTN33_shift_amount_reg_3
XU3874 NR2 $PINS O=n2815 I1=FE_OFN563_Iy2_20 I2=FE_OCPN1_n1709
XU3875 OAI22S $PINS O=n2814 A1=FE_OFN562_Iy2_21 A2=FE_OFN687_FE_DBTN16_n1710
+ B1=FE_OFN1735_Iy2_22 B2=FE_OFN343_FE_DBTN40_shift_amount_reg_1
XU3876 NR2 $PINS O=n3221 I1=n2815 I2=n2814
XU3877 AOI22S $PINS O=n2816 A1=n3221 A2=FE_DBTN41_n4489 B1=n3218
+ B2=FE_DBTN2_n2466
XU3878 AOI22S $PINS O=n2827 A1=FE_OFN4324_n A2=n3244 B1=n3143
+ B2=FE_OFN955_n4489
XU3879 OAI22S $PINS O=n2819 A1=FE_OFN597_IyIt_7 A2=FE_OFN4313_n B1=FE_OFN4358_n
+ B2=FE_OFN598_IyIt_6
XU3880 OAI22S $PINS O=n2818 A1=FE_OFN595_IyIt_9 A2=FE_OFN4310_n
+ B1=FE_OFN596_IyIt_8 B2=FE_OFN4114_n
XU3881 NR2 $PINS O=n3242 I1=n2819 I2=n2818
XU3882 OAI22S $PINS O=n2825 A1=IyIt[11] A2=FE_OFN4313_n B1=FE_OFN4358_n
+ B2=IyIt[10]
XU3883 OAI22S $PINS O=n2824 A1=IyIt[13] A2=FE_OFN4310_n B1=IyIt[12]
+ B2=FE_OFN4114_n
XU3884 NR2 $PINS O=n3241 I1=n2825 I2=n2824
XU3885 AOI22S $PINS O=n2826 A1=n3242 A2=FE_OFN799_n2447 B1=n3241
+ B2=FE_OFN790_n2278
XU3886 AOI22S $PINS O=n2829 A1=FE_OFN2736_n1709 A2=FE_OFN546_Ix2_4
+ B1=FE_OFN2744_FE_DBTN16_n1710 B2=FE_OFN545_Ix2_5
XU3887 AOI22S $PINS O=n2835 A1=n2832 A2=FE_OFN786_n2278 B1=FE_OFN796_n2447
+ B2=n3610
XU3888 AOI22S $PINS O=n2834 A1=n3261 A2=FE_OFN4344_n B1=n3260
+ B2=FE_OFN954_n4489
XU3891 OR2 $PINS O=n2836 I1=FE_OFN581_IxIy_18 I2=intadd_35/n1
XU3892 MOAI1S $PINS O=n2839 A1=IxIy[17] A2=n2838 B1=IxIy[17] B2=n2838
XU3894 OR2 $PINS O=n2841 I1=IyIt[18] I2=intadd_34/n1
XU3896 MOAI1S $PINS O=n2844 A1=FE_OFN1665_IyIt_17 A2=n2843
+ B1=FE_OFN1665_IyIt_17 B2=n2843
XU3897 XNR2HS $PINS O=n2847 I1=n2846 I2=FE_OFN534_Ix2_19
XU3899 INV1S $PINS O=n3311 I=mul_pos_buffer[4]
XU3900 ND2S $PINS O=n2848 I1=mul_pos_buffer[0] I2=mul_pos_buffer[1]
XU3901 MOAI1S $PINS O=n2849 A1=mul_pos_buffer[0] A2=mul_pos_buffer[1]
+ B1=mul_pos[1] B2=n2848
XU3902 INV1S $PINS O=n2898 I=mul_pos_buffer[2]
XU3903 MAO222 $PINS O=n2850 A1=mul_pos[2] B1=n2849 C1=n2898
XU3904 INV1S $PINS O=n4328 I=FE_PHN3279_mul_pos_buffer_3
XU3905 MAO222 $PINS O=n2851 A1=n2850 B1=mul_pos[3] C1=n4328
XU3906 MAO222 $PINS O=n2852 A1=mul_pos[4] B1=n3311 C1=n2851
XU3907 MXL2HS $PINS OB=n3597 S=n3589 A=mul_pos[0] B=mul_pos_buffer[0]
XU3908 INV1S $PINS O=n2853 I=n4327
XU3909 AOI22S $PINS O=n2858 A1=n2855 A2=FE_OFN775_n2278 B1=FE_OFN792_n2447
+ B2=n2854
XU3910 MUX2 $PINS O=n2866 S=FE_OFN606_shift_amount_reg_2 A=n2860 B=n2859
XU3911 AOI22S $PINS O=n2864 A1=Iy2[4] A2=FE_DBTN24_n2351 B1=n2861
+ B2=FE_OFN787_n2278
XU3912 AOI22S $PINS O=n2863 A1=FE_OFN932_n3611 A2=Iy2[2]
+ B1=FE_OFN1639_FE_DBTN23_n4483 B2=Iy2[1]
XU3913 ND3P $PINS O=n2865 I1=n2864 I2=n2863 I3=n2862
XU3914 AO12T $PINS O=Iy2_shift[1] A1=n2865 B1=n2866
+ B2=FE_OFN602_shift_amount_reg_3
XU3916 NR2 $PINS O=n3105 I1=FE_OFN561_Iy2_22 I2=FE_OFN953_n4489
XU3917 AOI22S $PINS O=n2870 A1=n3105 A2=FE_OCPN1_n1709 B1=n3806
+ B2=FE_OFN562_Iy2_21
XU3919 ND3 $PINS O=Iy2_shift[9] I1=n2871 I2=n2870 I3=n2869
XU3920 MUX2 $PINS O=n2907 S=shift_amount_reg[2] A=n2872 B=n2880
XU3921 NR2 $PINS O=n2877 I1=FE_OFN580_IxIy_20 I2=FE_OFN472_n1709
XU3922 OAI22S $PINS O=n2876 A1=FE_OFN579_IxIy_21 A2=FE_OFN4197_FE_OFN479_n1710
+ B1=FE_OFN578_IxIy_22 B2=FE_OFN343_FE_DBTN40_shift_amount_reg_1
XU3923 NR2 $PINS O=n2881 I1=n2877 I2=n2876
XU3924 MOAI1S $PINS O=n2878 A1=n2879 A2=FE_OFN4242_n2466
+ B1=FE_OFN1030_FE_DBTN41_n4489 B2=n2881
XU3925 AO12P $PINS O=IxIy_shift[8] A1=n2878 B1=n2907
+ B2=FE_DBTN33_shift_amount_reg_3
XU3926 INV1S $PINS O=n2886 I=n2879
XU3928 ND3 $PINS O=n2885 I1=n2884 I2=n2883 I3=n2882
XU3929 AO12 $PINS O=IxIy_shift[12] A1=n2885 B1=FE_OFN781_n2278 B2=n2886
XU3932 MOAI1S $PINS O=n1145 A1=n2890 A2=n2889 B1=n3094 B2=Iy2[18]
XU3933 OR2 $PINS O=n2893 I1=IxIt[18] I2=intadd_36/n1
XU3934 MOAI1S $PINS O=n2896 A1=FE_OFN554_IxIt_17 A2=n2895 B1=IxIt[17] B2=n2895
XU3935 INV1S $PINS O=n2897 I=mul_pos[2]
XU3936 MXL2HS $PINS OB=n3313 S=n3589 A=n2897 B=n2898
XU3937 INV1S $PINS O=n2901 I=mul_pos_buffer[1]
XU3938 INV1S $PINS O=n2899 I=mul_pos[1]
XU3939 MXL2HS $PINS OB=n3591 S=n3589 A=n2899 B=n2901
XU3941 AOI22S $PINS O=n2905 A1=FE_OFN589_IxIy_3 A2=FE_OFN351_FE_DBTN24_n2351
+ B1=n2903 B2=FE_OFN4214_FE_OFN778_n2278
XU3942 AOI22S $PINS O=n2904 A1=n3600 A2=IxIy[1] B1=FE_OFN1639_FE_DBTN23_n4483
+ B2=IxIy[0]
XU3944 AOI22S $PINS O=n2915 A1=FE_OFN758_n1715 A2=n2910 B1=FE_OFN750_n1705
+ B2=FE_OFN565_Iy2_16
XU3945 INV1S $PINS O=n2913 I=FE_OFN566_Iy2_14
XU3946 AOI22S $PINS O=n2914 A1=FE_OFN697_FE_DBTN7_n1709 A2=n2913
+ B1=FE_OFN692_FE_DBTN16_n1710 B2=n2911
XU3947 AOI22S $PINS O=n2920 A1=FE_OFN897_FE_DBTN17_n1715 A2=FE_OFN562_Iy2_21
+ B1=FE_OFN753_n1705 B2=FE_OFN563_Iy2_20
XU3948 AOI22S $PINS O=n2919 A1=FE_OFN466_n1709 A2=Iy2[18]
+ B1=FE_OFN692_FE_DBTN16_n1710 B2=FE_OFN564_Iy2_19
XU3949 ND2 $PINS O=n3323 I1=n2920 I2=n2919
XU3951 NR2 $PINS O=n3262 I1=FE_OFN532_Ix2_22 I2=FE_OFN1027_FE_DBTN41_n4489
XU3952 AOI22S $PINS O=n2928 A1=n3262 A2=FE_OFN4149_n B1=n3806 B2=Ix2[21]
XU3953 ND3 $PINS O=Ix2_shift[9] I1=n2929 I2=n2928 I3=n2927
XU4050 INV1S $PINS O=n4348 I=FE_OFN491_n2949
XU4052 MOAI1S $PINS O=n1031 A1=FE_OFN825_n4348 A2=FE_DBTN54_Ix_0_8
+ B1=FE_OFN825_n4348 B2=Ix[1][8]
XU4055 MOAI1S $PINS O=n1038 A1=FE_OFN826_n4348 A2=FE_DBTN48_Ix_0_1
+ B1=FE_OFN826_n4348 B2=Ix[1][1]
XU4057 MOAI1S $PINS O=n1037 A1=FE_OFN826_n4348 A2=FE_DBTN49_Ix_0_2
+ B1=FE_OFN826_n4348 B2=FE_PHN3184_Ix_1_2
XU4059 MOAI1S $PINS O=n1036 A1=FE_OFN826_n4348 A2=FE_DBTN50_Ix_0_3
+ B1=FE_OFN826_n4348 B2=FE_PHN3211_Ix_1_3
XU4063 MOAI1S $PINS O=n1071 A1=FE_OFN506_n2949 A2=FE_OFN439_intadd_21_SUM_3
+ B1=FE_OFN506_n2949 B2=Ix[4][4]
XU4064 MOAI1S $PINS O=n1070 A1=FE_OFN505_n2949 A2=FE_OFN436_intadd_21_SUM_4
+ B1=FE_OFN505_n2949 B2=Ix[4][5]
XU4066 XNR2HS $PINS O=n2951 I1=n2950 I2=Ix2[1]
XU4067 MOAI1S $PINS O=n1208 A1=FE_OFN461_n1703 A2=n2951 B1=FE_OFN937_n4099
+ B2=Ix2[1]
XU4068 XOR2HS $PINS O=n2954 I1=Ix2[2] I2=n2952
XU4070 MOAI1S $PINS O=n1207 A1=n2954 A2=FE_OFN459_n1703 B1=FE_OFN939_n4099
+ B2=Ix2[2]
XU4072 NR2 $PINS O=n3982 I1=FE_OFN4137_n4336 I2=FE_DBTN55_It_4_0
XU4073 XNR2HS $PINS O=n2955 I1=n3982 I2=IxIt[0]
XU4074 MOAI1S $PINS O=n1186 A1=n2955 A2=FE_OFN463_n1703 B1=IxIt[0] B2=n4099
XU4075 XOR2HS $PINS O=n2957 I1=Iy2[2] I2=n2956
XU4077 MOAI1S $PINS O=n1161 A1=n2957 A2=FE_OFN454_n1693 B1=FE_OFN947_n4229
+ B2=Iy2[2]
XU4078 MOAI1S $PINS O=n2960 A1=n2959 A2=n2958 B1=n2959 B2=n2958
XU4079 XOR2HS $PINS O=n2961 I1=n2960 I2=FE_PHN3268_Iy2_3
XU4080 MOAI1S $PINS O=n1160 A1=n2961 A2=FE_OFN454_n1693 B1=FE_OFN947_n4229
+ B2=Iy2[3]
XU4081 XOR3 $PINS O=n2965 I1=n2963 I2=FE_OFN576_Iy2_4 I3=n2962
XU4082 MOAI1S $PINS O=n1159 A1=n2965 A2=FE_OFN452_n1693 B1=FE_OFN947_n4229
+ B2=FE_OFN576_Iy2_4
XU4084 INV1S $PINS O=n4333 I=n2966
XU4085 NR2 $PINS O=n3943 I1=n2949 I2=n4333
XU4089 MOAI1S $PINS O=n1211 A1=FE_OFN804_n3943 A2=n1362 B1=FE_OFN804_n3943
+ B2=It[1][7]
XU4090 MOAI1S $PINS O=n2969 A1=n2968 A2=n2967 B1=n2968 B2=n2967
XU4091 XOR2HS $PINS O=n2970 I1=n2969 I2=FE_OFN547_Ix2_3
XU4092 MOAI1S $PINS O=n1206 A1=n2970 A2=FE_OFN460_n1703 B1=FE_OFN937_n4099
+ B2=FE_OFN547_Ix2_3
XU4093 XOR3 $PINS O=n2973 I1=n2972 I2=Ix2[4] I3=n2971
XU4094 MOAI1S $PINS O=n1205 A1=n2973 A2=FE_OFN460_n1703 B1=FE_OFN937_n4099
+ B2=FE_OFN546_Ix2_4
XU4096 MOAI1S $PINS O=n2975 A1=n2974 A2=intadd_7/SUM[1] B1=n2974
+ B2=intadd_7/SUM[1]
XU4097 MOAI1S $PINS O=n2977 A1=n2976 A2=n2975 B1=n2976 B2=n2975
XU4098 MOAI1S $PINS O=n1114 A1=FE_OFN1052_FE_DBTN0_n4229 A2=n1317
+ B1=FE_OFN820_n4217 B2=n2977
XU4099 INV1S $PINS O=n4247 I=IyIt[1]
XU4100 FA1S $PINS S=n2981 CO=n4251 A=n2980 B=n2979 CI=n2978
XU4101 MOAI1S $PINS O=n1116 A1=FE_OFN1052_FE_DBTN0_n4229 A2=n4247
+ B1=FE_OFN820_n4217 B2=n2981
XU4102 XOR3 $PINS O=n2983 I1=n2982 I2=FE_OFN575_Iy2_5 I3=intadd_0/SUM[0]
XU4104 MOAI1S $PINS O=n1158 A1=n2983 A2=FE_OFN453_n1693 B1=FE_OFN946_n4229
+ B2=FE_PHN3228_Iy2_5
XU4107 MOAI1S $PINS O=n1246 A1=FE_OFN808_n3943 A2=FE_DBTN62_It_4_8
+ B1=FE_OFN808_n3943 B2=intadd_22/n1
XU4109 NR2 $PINS O=n4163 I1=FE_OFN407_intadd_14_SUM_2
+ I2=FE_OFN342_FE_DBTN47_Ix_0_0
XU4110 NR2 $PINS O=n4157 I1=FE_OFN413_intadd_14_SUM_1 I2=FE_DBTN47_Ix_0_0
XU4111 ND2S $PINS O=n2984 I1=Ix[0][0] I2=FE_OFN949_n4268
XU4112 AN2B1S $PINS O=n4153 I1=IxIy[0] B1=n2984
XU4113 ND2S $PINS O=n4155 I1=Ix[0][1] I2=FE_OFN949_n4268
XU4114 MOAI1S $PINS O=n4152 A1=IxIy[1] A2=n4155 B1=IxIy[1] B2=n4155
XU4115 NR2 $PINS O=n4151 I1=FE_OFN418_intadd_14_SUM_0 I2=FE_DBTN47_Ix_0_0
XU4116 MAO222 $PINS O=n4165 A1=n4157 B1=intadd_13/SUM[0] C1=n4159
XU4117 MAO222 $PINS O=n3037 A1=n4163 B1=intadd_13/SUM[1] C1=n4165
XU4119 NR2 $PINS O=n3038 I1=FE_OFN406_intadd_14_SUM_3
+ I2=FE_OFN342_FE_DBTN47_Ix_0_0
XU4120 MOAI1S $PINS O=n2985 A1=n3038 A2=intadd_13/SUM[2] B1=n3038
+ B2=intadd_13/SUM[2]
XU4121 MOAI1S $PINS O=n2986 A1=n3037 A2=n2985 B1=n3037 B2=n2985
XU4122 MOAI1S $PINS O=n1136 A1=FE_OFN1050_FE_DBTN0_n4229 A2=n4171 B1=n4217
+ B2=n2986
XU4124 MOAI1S $PINS O=n1213 A1=FE_OFN807_n3943 A2=FE_DBTN68_It_0_5
+ B1=FE_OFN807_n3943 B2=It[1][5]
XU4127 MOAI1S $PINS O=n2988 A1=n2987 A2=intadd_7/SUM[2] B1=n2987
+ B2=intadd_7/SUM[2]
XU4128 MOAI1S $PINS O=n2990 A1=n2989 A2=n2988 B1=n2989 B2=n2988
XU4129 MOAI1S $PINS O=n1113 A1=FE_OFN1052_FE_DBTN0_n4229 A2=n1314
+ B1=FE_OFN820_n4217 B2=n2990
XU4130 INV1S $PINS O=n2991 I=Iy2[0]
XU4131 ND2S $PINS O=n2993 I1=FE_OFN1749_n4113 I2=n2991
XU4133 OAI12HS $PINS O=n2992 A1=FE_OFN1055_FE_DBTN0_n4229 B1=FE_OFN517_n4245
+ B2=FE_OFN1749_n4113
XU4134 MOAI1S $PINS O=n1163 A1=FE_OFN452_n1693 A2=n2993 B1=n2992
+ B2=FE_PHN3262_Iy2_0
XU4135 INV1S $PINS O=n2994 I=Iy2[1]
XU4136 ND2S $PINS O=n2997 I1=n2994 I2=n2995
XU4137 OAI12HS $PINS O=n2996 A1=FE_OFN1055_FE_DBTN0_n4229 B1=FE_OFN517_n4245
+ B2=n2995
XU4138 MOAI1S $PINS O=n1162 A1=FE_OFN454_n1693 A2=n2997 B1=n2996 B2=Iy2[1]
XU4139 XOR3 $PINS O=n3000 I1=Ix2[5] I2=n2998 I3=intadd_1/SUM[0]
XU4140 MOAI1S $PINS O=n1204 A1=n3000 A2=FE_OFN460_n1703 B1=FE_OFN937_n4099
+ B2=FE_PHN3251_Ix2_5
XU4143 MOAI1S $PINS O=n1245 A1=FE_OFN914_FE_DBTN1_n3943
+ A2=FE_OFN334_FE_DBTN55_It_4_0 B1=FE_OFN914_FE_DBTN1_n3943 B2=FE_PHN3177_It_3_0
XU4145 MOAI1S $PINS O=n1244 A1=FE_DBTN1_n3943 A2=FE_OFN333_FE_DBTN56_It_4_1
+ B1=FE_DBTN1_n3943 B2=It[3][1]
XU4146 XNR3 $PINS O=n3003 I1=Iy2[6] I2=n3002 I3=intadd_0/SUM[1]
XU4147 MOAI1S $PINS O=n1157 A1=n3003 A2=FE_OFN452_n1693 B1=FE_OFN946_n4229
+ B2=FE_PHN3243_Iy2_6
XU4149 MOAI1S $PINS O=n3005 A1=n3004 A2=intadd_7/SUM[3] B1=n3004
+ B2=intadd_7/SUM[3]
XU4150 MOAI1S $PINS O=n3007 A1=n3006 A2=n3005 B1=n3006 B2=n3005
XU4151 MOAI1S $PINS O=n1112 A1=FE_OFN1052_FE_DBTN0_n4229 A2=FE_OFN599_IyIt_5
+ B1=FE_OFN820_n4217 B2=n3007
XU4152 XOR3 $PINS O=n3009 I1=Iy2[7] I2=n3008 I3=intadd_0/SUM[2]
XU4154 MOAI1S $PINS O=n1156 A1=n3009 A2=FE_OFN450_n1693 B1=FE_OFN946_n4229
+ B2=FE_PHN3246_Iy2_7
XU4155 XNR3 $PINS O=n3011 I1=Ix2[6] I2=n3010 I3=intadd_1/SUM[1]
XU4156 MOAI1S $PINS O=n1203 A1=n3011 A2=FE_OFN462_n1703 B1=FE_OFN937_n4099
+ B2=FE_PHN3248_Ix2_6
XU4158 ND2S $PINS O=n3012 I1=intadd_7/SUM[4] I2=intadd_28/SUM[3]
XU4159 MOAI1S $PINS O=n3016 A1=n3015 A2=n3014 B1=n3015 B2=n3014
XU4160 MOAI1S $PINS O=n1111 A1=FE_OFN1052_FE_DBTN0_n4229 A2=n1311
+ B1=FE_OFN820_n4217 B2=n3016
XU4161 XOR3 $PINS O=n3019 I1=FE_PHN3282_Ix2_7 I2=n3017 I3=intadd_1/SUM[2]
XU4162 MOAI1S $PINS O=n1202 A1=n3019 A2=FE_OFN462_n1703 B1=FE_OFN941_n4099
+ B2=FE_PHN3282_Ix2_7
XU4163 XNR3 $PINS O=n3023 I1=Iy2[8] I2=n3020 I3=intadd_0/SUM[3]
XU4164 MOAI1S $PINS O=n1155 A1=n3023 A2=FE_OFN450_n1693 B1=FE_OFN946_n4229
+ B2=FE_PHN3244_Iy2_8
XU4165 XOR3 $PINS O=n3025 I1=Iy2[9] I2=n3024 I3=intadd_0/SUM[4]
XU4166 MOAI1S $PINS O=n1154 A1=n3025 A2=FE_OFN450_n1693 B1=FE_OFN946_n4229
+ B2=FE_PHN3255_Iy2_9
XU4167 ND2S $PINS O=n3026 I1=intadd_7/SUM[5] I2=intadd_28/SUM[4]
XU4168 OR2B1S $PINS O=n3028 I1=n3027 B1=n3026
XU4169 MOAI1S $PINS O=n3030 A1=n3029 A2=n3028 B1=n3029 B2=n3028
XU4170 MOAI1S $PINS O=n1110 A1=FE_OFN453_n1693 A2=n3030 B1=FE_OFN947_n4229
+ B2=FE_PHN3272_IyIt_7
XU4171 XNR3 $PINS O=n3032 I1=Ix2[8] I2=intadd_1/SUM[3] I3=n3031
XU4172 MOAI1S $PINS O=n1201 A1=n3032 A2=FE_OFN462_n1703 B1=FE_OFN941_n4099
+ B2=FE_PHN3267_Ix2_8
XU4173 XOR3 $PINS O=n3034 I1=Ix2[9] I2=intadd_1/SUM[4] I3=n3033
XU4174 MOAI1S $PINS O=n1200 A1=n3034 A2=FE_OFN462_n1703 B1=FE_OFN941_n4099
+ B2=Ix2[9]
XU4175 XNR3 $PINS O=n3036 I1=Iy2[10] I2=n3035 I3=intadd_0/SUM[5]
XU4176 MOAI1S $PINS O=n1153 A1=n3036 A2=FE_OFN450_n1693 B1=FE_OFN945_n4229
+ B2=FE_PHN3260_Iy2_10
XU4177 INV1S $PINS O=n3067 I=intadd_11/SUM[4]
XU4178 INV1S $PINS O=n3041 I=intadd_11/SUM[3]
XU4179 NR2 $PINS O=n3040 I1=n1439 I2=FE_OFN342_FE_DBTN47_Ix_0_0
XU4181 NR2 $PINS O=n4172 I1=FE_OFN1691_intadd_14_SUM_4
+ I2=FE_OFN342_FE_DBTN47_Ix_0_0
XU4182 MAO222 $PINS O=n4174 A1=n3038 B1=intadd_13/SUM[2] C1=n3037
XU4183 MAO222 $PINS O=n4184 A1=n4172 B1=intadd_13/SUM[3] C1=n4174
XU4184 OR2 $PINS O=n4182 I1=intadd_13/SUM[4] I2=intadd_27/SUM[3]
XU4185 AOI22S $PINS O=n4194 A1=intadd_27/SUM[3] A2=intadd_13/SUM[4] B1=n4184
+ B2=n4182
XU4186 NR2 $PINS O=n4192 I1=intadd_13/SUM[5] I2=intadd_27/SUM[4]
XU4187 MOAI1 $PINS O=n4200 A1=n4194 A2=n4192 B1=intadd_27/SUM[4]
+ B2=intadd_13/SUM[5]
XU4188 NR2 $PINS O=n3042 I1=n4200 I2=intadd_13/SUM[6]
XU4189 FA1S $PINS S=n4199 CO=n3066 A=n3041 B=n3040 CI=n3039
XU4190 MOAI1H $PINS O=n3063 A1=n3042 A2=n4199 B1=n4200 B2=intadd_13/SUM[6]
XU4191 MOAI1S $PINS O=n3043 A1=n3064 A2=n3063 B1=n3064 B2=n3063
XU4192 MOAI1S $PINS O=n3044 A1=intadd_13/n1 A2=n3043 B1=intadd_13/n1 B2=n3043
XU4193 MOAI1S $PINS O=n1131 A1=n1693 A2=n3044 B1=n4229 B2=IxIy[9]
XU4194 MOAI1S $PINS O=n3047 A1=n3046 A2=n3045 B1=n3046 B2=n3045
XU4195 MOAI1S $PINS O=n3049 A1=intadd_7/n1 A2=n3047 B1=intadd_7/n1 B2=n3047
XU4196 MOAI1S $PINS O=n1108 A1=FE_OFN453_n1693 A2=n3049 B1=FE_OFN947_n4229
+ B2=IyIt[9]
XU4197 XOR3 $PINS O=n3052 I1=Iy2[11] I2=n3051 I3=intadd_0/SUM[6]
XU4198 MOAI1S $PINS O=n1152 A1=n3052 A2=FE_OFN448_n1693 B1=FE_OFN945_n4229
+ B2=FE_PHN3249_Iy2_11
XU4199 XNR3 $PINS O=n3055 I1=Ix2[10] I2=intadd_1/SUM[5] I3=n3053
XU4200 MOAI1S $PINS O=n1199 A1=n3055 A2=FE_OFN462_n1703 B1=FE_OFN941_n4099
+ B2=Ix2[10]
XU4201 XOR3 $PINS O=n3057 I1=Ix2[11] I2=n3056 I3=intadd_1/SUM[6]
XU4202 MOAI1S $PINS O=n1198 A1=n3057 A2=FE_OFN458_n1703 B1=FE_OFN942_n4099
+ B2=FE_OFN539_Ix2_11
XU4203 XNR3 $PINS O=n3059 I1=Iy2[12] I2=n3058 I3=intadd_0/SUM[7]
XU4204 MOAI1S $PINS O=n1151 A1=n3059 A2=FE_OFN448_n1693 B1=FE_OFN945_n4229
+ B2=FE_PHN3239_Iy2_12
XU4205 INV1S $PINS O=intadd_23/A[1] I=IyIt[11]
XU4206 MOAI1S $PINS O=n3061 A1=intadd_5/SUM[6] A2=n3060 B1=intadd_5/SUM[6]
+ B2=n3060
XU4207 MOAI1S $PINS O=n3062 A1=intadd_6/n1 A2=n3061 B1=intadd_6/n1 B2=n3061
XU4208 MOAI1S $PINS O=n1106 A1=FE_OFN1054_FE_DBTN0_n4229 A2=intadd_23/A[1]
+ B1=FE_OFN817_n4217 B2=n3062
XU4209 NR2 $PINS O=n3065 I1=n3063 I2=intadd_13/n1
XU4211 FA1 $PINS S=n3064 CO=n4207 A=n3068 B=n3067 CI=n3066
XU4212 INV1S $PINS O=n3069 I=n4207
XU4213 MAO222P $PINS O=n4209 A1=n4205 B1=intadd_12/SUM[6] C1=n3069
XU4214 MAO222 $PINS O=n3080 A1=intadd_11/SUM[6] B1=intadd_12/n1 C1=n4209
XU4215 MOAI1S $PINS O=n3070 A1=intadd_10/SUM[6] A2=n3080 B1=intadd_10/SUM[6]
+ B2=n3080
XU4216 MOAI1S $PINS O=n3071 A1=intadd_11/n1 A2=n3070 B1=intadd_11/n1 B2=n3070
XU4217 MOAI1S $PINS O=n1128 A1=FE_OFN1049_FE_DBTN0_n4229 A2=intadd_24/A[2]
+ B1=FE_OFN819_n4217 B2=n3071
XU4218 MOAI1S $PINS O=n3073 A1=intadd_4/SUM[6] A2=n3072 B1=intadd_4/SUM[6]
+ B2=n3072
XU4219 MOAI1S $PINS O=n3074 A1=intadd_5/n1 A2=n3073 B1=intadd_5/n1 B2=n3073
XU4220 MOAI1S $PINS O=n1105 A1=FE_OFN1054_FE_DBTN0_n4229 A2=intadd_23/A[2]
+ B1=FE_OFN817_n4217 B2=n3074
XU4221 XOR3 $PINS O=n3076 I1=Iy2[13] I2=n3075 I3=intadd_0/SUM[8]
XU4222 MOAI1S $PINS O=n1150 A1=n3076 A2=FE_OFN448_n1693 B1=FE_OFN945_n4229
+ B2=FE_OFN567_Iy2_13
XU4223 XNR3 $PINS O=n3079 I1=Ix2[12] I2=intadd_1/SUM[7] I3=n3077
XU4224 MOAI1S $PINS O=n1197 A1=n3079 A2=FE_OFN458_n1703 B1=FE_OFN942_n4099
+ B2=Ix2[12]
XU4225 MAO222 $PINS O=n4214 A1=intadd_10/SUM[6] B1=intadd_11/n1 C1=n3080
XU4226 MOAI1S $PINS O=n3081 A1=n4214 A2=intadd_9/SUM[6] B1=intadd_9/SUM[6]
+ B2=n4214
XU4227 MOAI1S $PINS O=n3082 A1=intadd_10/n1 A2=n3081 B1=intadd_10/n1 B2=n3081
XU4228 MOAI1S $PINS O=n1127 A1=FE_OFN1049_FE_DBTN0_n4229 A2=intadd_24/A[3]
+ B1=FE_OFN819_n4217 B2=n3082
XU4229 INV1S $PINS O=intadd_23/A[3] I=IyIt[13]
XU4230 MOAI1S $PINS O=n3085 A1=intadd_3/SUM[6] A2=n3084 B1=intadd_3/SUM[6]
+ B2=n3084
XU4231 MOAI1S $PINS O=n3086 A1=intadd_4/n1 A2=n3085 B1=intadd_4/n1 B2=n3085
XU4232 MOAI1S $PINS O=n1104 A1=FE_OFN1054_FE_DBTN0_n4229 A2=intadd_23/A[3]
+ B1=FE_OFN817_n4217 B2=n3086
XU4233 XNR3 $PINS O=n3090 I1=Iy2[14] I2=n3088 I3=intadd_0/SUM[9]
XU4234 MOAI1S $PINS O=n1149 A1=n3090 A2=FE_OFN448_n1693 B1=FE_OFN943_n4229
+ B2=FE_PHN3225_Iy2_14
XU4235 XNR2HS $PINS O=n3092 I1=Iy2[16] I2=n3093
XU4236 MOAI1S $PINS O=n1147 A1=n3092 A2=FE_OFN447_n1693 B1=FE_OFN943_n4229
+ B2=Iy2[16]
XU4237 MOAI1S $PINS O=n1146 A1=n3096 A2=n3095 B1=n3094 B2=Iy2[17]
XU4238 NR2 $PINS O=n3099 I1=FE_OFN429_intadd_21_SUM_5 I2=intadd_21/SUM[1]
XU4239 NR2 $PINS O=n3098 I1=intadd_21/SUM[4] I2=FE_OFN4240_intadd_21_SUM_3
XU4240 AO12 $PINS O=n3097 A1=FE_DBTN13_n4339 B1=intadd_21/SUM[4]
+ B2=intadd_21/SUM[3]
XU4241 NR2 $PINS O=n3308 I1=n3098 I2=n3097
XU4242 MOAI1S $PINS O=n3100 A1=n3099 A2=n3308 B1=n3099 B2=n3308
XU4243 NR2 $PINS O=n3121 I1=intadd_21/SUM[1] I2=FE_OFN4240_intadd_21_SUM_3
XU4244 ND2S $PINS O=n3956 I1=n3121 I2=n1575
XU4245 MOAI1S $PINS O=intadd_1/A[4] A1=n3100 A2=n3956 B1=n3100 B2=n3956
XU4246 NR2 $PINS O=n3959 I1=FE_OFN429_intadd_21_SUM_5
+ I2=FE_OFN359_FE_DBTN13_n4339
XU4248 OAI22S $PINS O=n3958 A1=intadd_21/SUM[4] A2=n3101 B1=intadd_21/SUM[3]
+ B2=FE_OFN359_FE_DBTN13_n4339
XU4249 NR2 $PINS O=n3957 I1=FE_OFN426_intadd_21_SUM_6 I2=intadd_21/SUM[1]
XU4250 NR2 $PINS O=n3962 I1=FE_OFN426_intadd_21_SUM_6
+ I2=FE_OFN359_FE_DBTN13_n4339
XU4251 NR2 $PINS O=n3961 I1=intadd_21/SUM[5] I2=intadd_21/SUM[3]
XU4252 OAI22S $PINS O=n3960 A1=FE_OFN359_FE_DBTN13_n4339 A2=intadd_21/SUM[4]
+ B1=FE_OFN4239_intadd_21_SUM_3 B2=intadd_21/SUM[4]
XU4253 FA1S $PINS S=intadd_1/B[6] CO=intadd_1/A[7] A=n3104 B=n3103 CI=n3102
XU4254 NR2 $PINS O=n3318 I1=FE_OFN4133_n4336 I2=FE_DBTN62_It_4_8
XU4255 MOAI1S $PINS O=intadd_15/B[0] A1=IxIt[8] A2=n3318 B1=IxIt[8] B2=n3318
XU4256 INV1S $PINS O=n3183 I=n3173
XU4257 AOI22S $PINS O=n3111 A1=FE_OFN4319_FE_DBTN2_n2466 A2=n3184 B1=n3183
+ B2=FE_OFN4141_n2278
XU4258 INV1S $PINS O=n3328 I=n3105
XU4259 OAI22S $PINS O=n3109 A1=FE_OFN568_Iy2_12 A2=FE_DBTN16_n1710
+ B1=FE_OFN2734_FE_DBTN7_n1709 B2=FE_OFN569_Iy2_11
XU4260 OAI22S $PINS O=n3108 A1=FE_OFN566_Iy2_14 A2=FE_DBTN17_n1715
+ B1=FE_OFN567_Iy2_13 B2=FE_OFN907_FE_DBTN8_n1705
XU4261 ND3 $PINS O=Iy2_shift[11] I1=n3111 I2=n3328 I3=n3110
XU4275 INV1S $PINS O=intadd_36/A[1] I=IxIt[16]
XU4276 INV1S $PINS O=intadd_36/A[0] I=IxIt[15]
XU4277 INV1S $PINS O=intadd_25/A[4] I=IxIt[14]
XU4278 ND2 $PINS O=n3115 I1=n3112 I2=FE_DBTN33_shift_amount_reg_3
XU4279 AOI22S $PINS O=n3114 A1=n3113 A2=FE_OFN472_n1709 B1=n3806 B2=IxIy[21]
XU4280 OAI112HS $PINS O=n3310 A1=n3115 B1=n3114 C1=FE_OFN4242_n2466 C2=n3116
XU4281 INV1S $PINS O=intadd_25/A[2] I=IxIt[12]
XU4282 INV1S $PINS O=intadd_25/A[3] I=IxIt[13]
XU4283 INV1S $PINS O=intadd_25/A[0] I=IxIt[10]
XU4284 INV1S $PINS O=intadd_25/A[1] I=IxIt[11]
XU4285 MOAI1S $PINS O=n3119 A1=n3136 A2=n2619 B1=FE_OFN4344_n B2=n3118
XU4286 AO112 $PINS O=n3259 A1=n3119 B1=n3262 C1=FE_OFN800_n2447 C2=n3133
XU4289 MOAI1S $PINS O=n3123 A1=n2351 A2=FE_OFN587_IxIy_5 B1=FE_OFN589_IxIy_3
+ B2=FE_OCPN2_n3611
XU4290 MOAI1S $PINS O=n3122 A1=n4483 A2=n4162 B1=FE_OFN588_IxIy_4
+ B2=FE_OFN928_n2902
XU4291 NR2 $PINS O=n3129 I1=n3123 I2=n3122
XU4292 AOI22S $PINS O=n3128 A1=n3125 A2=FE_OFN780_n2278 B1=n3124
+ B2=FE_OFN1043_FE_DBTN2_n2466
XU4293 ND2 $PINS O=n3127 I1=n3126 I2=n4489
XU4294 AOI22S $PINS O=n3135 A1=n3134 A2=FE_OFN786_n2278 B1=n3133
+ B2=FE_OFN1041_FE_DBTN2_n2466
XU4295 OA12 $PINS O=n3139 A1=n3135 B1=FE_OFN1027_FE_DBTN41_n4489 B2=n3136
XU4296 AOI22S $PINS O=n3138 A1=FE_OFN1661_n3611 A2=FE_OFN546_Ix2_4
+ B1=FE_OFN544_Ix2_6 B2=FE_OFN349_FE_DBTN24_n2351
XU4297 AOI22S $PINS O=n3137 A1=FE_DBTN23_n4483 A2=Ix2[3] B1=FE_OFN545_Ix2_5
+ B2=FE_OFN4209_FE_OFN928_n2902
XU4298 AOI22S $PINS O=n3145 A1=FE_OFN790_n2278 A2=n3244 B1=n3143
+ B2=FE_OFN4324_n
XU4299 INV1S $PINS O=n3811 I=n3808
XU4300 OAI22S $PINS O=n3148 A1=FE_OFN543_Ix2_7 A2=FE_OFN2737_FE_DBTN16_n1710
+ B1=FE_OFN468_n1709 B2=FE_OFN544_Ix2_6
XU4301 OAI22S $PINS O=n3147 A1=FE_OFN541_Ix2_9 A2=FE_OFN894_FE_DBTN17_n1715
+ B1=FE_OFN542_Ix2_8 B2=FE_OFN908_FE_DBTN8_n1705
XU4302 NR2 $PINS O=n3630 I1=n3148 I2=n3147
XU4303 OAI22S $PINS O=n3151 A1=FE_OFN539_Ix2_11 A2=FE_OFN689_FE_DBTN16_n1710
+ B1=FE_OFN468_n1709 B2=FE_OFN540_Ix2_10
XU4304 OAI22S $PINS O=n3150 A1=FE_OFN537_Ix2_13 A2=FE_OFN894_FE_DBTN17_n1715
+ B1=FE_OFN538_Ix2_12 B2=FE_OFN908_FE_DBTN8_n1705
XU4305 NR2 $PINS O=n3625 I1=n3151 I2=n3150
XU4306 AOI22S $PINS O=n3152 A1=n3630 A2=FE_OFN789_n2278 B1=n3625
+ B2=FE_OFN1041_FE_DBTN2_n2466
XU4307 OA12 $PINS O=n3156 A1=n3152 B1=FE_OFN1027_FE_DBTN41_n4489 B2=n3622
XU4308 AOI22S $PINS O=n3155 A1=FE_OFN1661_n3611 A2=Ix2[3] B1=FE_OFN545_Ix2_5
+ B2=FE_OFN349_FE_DBTN24_n2351
XU4309 AOI22S $PINS O=n3154 A1=FE_DBTN23_n4483 A2=Ix2[2] B1=FE_OFN546_Ix2_4
+ B2=FE_OFN4209_FE_OFN928_n2902
XU4310 OAI22S $PINS O=n3158 A1=FE_OFN573_Iy2_7 A2=FE_DBTN16_n1710
+ B1=FE_OFN700_FE_DBTN7_n1709 B2=FE_OFN574_Iy2_6
XU4311 OAI22S $PINS O=n3157 A1=FE_OFN571_Iy2_9 A2=FE_DBTN17_n1715
+ B1=FE_OFN572_Iy2_8 B2=FE_OFN906_FE_DBTN8_n1705
XU4312 NR2 $PINS O=n3179 I1=n3158 I2=n3157
XU4313 OAI22S $PINS O=n3161 A1=FE_OFN569_Iy2_11 A2=FE_DBTN16_n1710
+ B1=FE_OFN2734_FE_DBTN7_n1709 B2=FE_OFN570_Iy2_10
XU4314 OAI22S $PINS O=n3160 A1=FE_OFN567_Iy2_13 A2=FE_DBTN17_n1715
+ B1=FE_OFN568_Iy2_12 B2=FE_OFN906_FE_DBTN8_n1705
XU4315 NR2 $PINS O=n3326 I1=n3161 I2=n3160
XU4316 AOI22S $PINS O=n3162 A1=n3179 A2=FE_OFN4213_FE_OFN778_n2278 B1=n3326
+ B2=FE_OFN1040_FE_DBTN2_n2466
XU4317 OA12 $PINS O=n3165 A1=n3162 B1=FE_OFN953_n4489 B2=n3177
XU4318 AOI22S $PINS O=n3164 A1=FE_OFN1661_n3611 A2=FE_OFN577_Iy2_3
+ B1=FE_OFN575_Iy2_5 B2=FE_DBTN24_n2351
XU4319 AOI22S $PINS O=n3163 A1=FE_OFN352_FE_DBTN23_n4483 A2=Iy2[2] B1=Iy2[4]
+ B2=FE_OFN928_n2902
XU4320 OAI22S $PINS O=n3171 A1=FE_OFN572_Iy2_8 A2=FE_DBTN16_n1710
+ B1=FE_OFN700_FE_DBTN7_n1709 B2=FE_OFN573_Iy2_7
XU4321 OAI22S $PINS O=n3170 A1=FE_OFN570_Iy2_10 A2=FE_DBTN17_n1715
+ B1=FE_OFN571_Iy2_9 B2=FE_OFN906_FE_DBTN8_n1705
XU4322 NR2 $PINS O=n3187 I1=n3171 I2=n3170
XU4323 AOI22S $PINS O=n3172 A1=n3187 A2=FE_OFN778_n2278 B1=n3186
+ B2=FE_OFN1040_FE_DBTN2_n2466
XU4324 OA12 $PINS O=n3176 A1=n3172 B1=FE_OFN953_n4489 B2=n3173
XU4325 AOI22S $PINS O=n3175 A1=FE_OCPN2_n3611 A2=Iy2[4] B1=FE_OFN574_Iy2_6
+ B2=FE_DBTN24_n2351
XU4326 AOI22S $PINS O=n3174 A1=FE_OFN352_FE_DBTN23_n4483 A2=FE_OFN577_Iy2_3
+ B1=FE_OFN575_Iy2_5 B2=FE_OFN928_n2902
XU4328 AOI22S $PINS O=n3181 A1=FE_DBTN41_n4489 A2=n3323 B1=n3322
+ B2=FE_OFN1040_FE_DBTN2_n2466
XU4329 AOI22S $PINS O=n3180 A1=n3179 A2=FE_OFN795_n2447 B1=n3326
+ B2=FE_OFN4213_FE_OFN778_n2278
XU4330 AOI22S $PINS O=n3189 A1=FE_OFN954_n4489 A2=n3184 B1=n3183
+ B2=FE_OFN4319_FE_DBTN2_n2466
XU4331 AOI22S $PINS O=n3188 A1=n3187 A2=FE_OFN796_n2447 B1=n3186
+ B2=FE_OFN778_n2278
XU4333 AOI22S $PINS O=n3192 A1=FE_OFN350_FE_DBTN24_n2351 A2=FE_OFN560_IxIt_3
+ B1=n3190 B2=FE_OFN787_n2278
XU4334 AOI22S $PINS O=n3191 A1=FE_OFN1660_n3611 A2=IxIt[1]
+ B1=FE_OFN354_FE_DBTN23_n4483 B2=IxIt[0]
XU4335 OAI112H $PINS O=n3193 A1=n3192 B1=n3191 C1=FE_OFN1712_IxIt_2 C2=n3614
XU4336 AO12 $PINS O=IxIt_shift[0] A1=n3193 B1=n3194
+ B2=FE_OFN602_shift_amount_reg_3
XU4337 AOI22S $PINS O=n3198 A1=FE_OFN559_IxIt_4 A2=FE_OFN350_FE_DBTN24_n2351
+ B1=n3195 B2=FE_OFN787_n2278
XU4338 AOI22S $PINS O=n3197 A1=FE_OFN1660_n3611 A2=IxIt[2] B1=IxIt[1]
+ B2=FE_OFN354_FE_DBTN23_n4483
XU4339 ND3P $PINS O=n3199 I1=n3198 I2=n3197 I3=n3196
XU4340 AO12 $PINS O=IxIt_shift[1] A1=n3199 B1=n3200 B2=shift_amount_reg[3]
XU4342 MOAI1S $PINS O=n3202 A1=n2351 A2=n4011 B1=FE_OFN1660_n3611 B2=IxIt[3]
XU4343 MOAI1S $PINS O=n3201 A1=n4483 A2=FE_OFN1712_IxIt_2 B1=IxIt[4]
+ B2=FE_OFN4205_FE_OFN928_n2902
XU4344 NR2 $PINS O=n3208 I1=n3202 I2=n3201
XU4345 AOI22S $PINS O=n3207 A1=n3204 A2=FE_OFN784_n2278 B1=n3203
+ B2=FE_OFN1039_FE_DBTN2_n2466
XU4347 AOI22S $PINS O=n3216 A1=n3213 A2=FE_OFN784_n2278 B1=n3211
+ B2=FE_OFN4345_n
XU4348 AOI22S $PINS O=n3223 A1=n3219 A2=FE_OFN791_n2447 B1=n3218
+ B2=FE_OFN4141_n2278
XU4351 AOI22S $PINS O=n3228 A1=FE_OFN4233_FE_OFN899_FE_DBTN17_n1715
+ A2=FE_OFN597_IyIt_7 B1=FE_OFN4196_FE_OFN910_FE_DBTN8_n1705 B2=FE_OFN598_IyIt_6
XU4352 AOI22S $PINS O=n3227 A1=FE_OFN469_n1709 A2=FE_OFN600_IyIt_4
+ B1=FE_OFN4119_n B2=n4265
XU4353 AOI22S $PINS O=n3230 A1=FE_OFN350_FE_DBTN24_n2351 A2=FE_OFN601_IyIt_3
+ B1=n3274 B2=FE_OFN787_n2278
XU4354 AOI22S $PINS O=n3229 A1=FE_OFN1659_n3611 A2=IyIt[1]
+ B1=FE_OFN354_FE_DBTN23_n4483 B2=IyIt[0]
XU4355 OAI112HS $PINS O=n3231 A1=n3230 B1=n3229 C1=n4256 C2=n3614
XU4356 AO12 $PINS O=IyIt_shift[0] A1=n3231 B1=n3232
+ B2=FE_OFN604_shift_amount_reg_3
XU4357 MUX2 $PINS O=n3805 S=FE_OFN606_shift_amount_reg_2 A=n3233 B=n3822
XU4358 AOI22S $PINS O=n3237 A1=FE_OFN600_IyIt_4 A2=FE_OFN349_FE_DBTN24_n2351
+ B1=n3234 B2=FE_OFN787_n2278
XU4359 AOI22S $PINS O=n3236 A1=FE_OFN1660_n3611 A2=IyIt[2]
+ B1=FE_OFN354_FE_DBTN23_n4483 B2=IyIt[1]
XU4360 AO12 $PINS O=IyIt_shift[1] A1=n3238 B1=FE_OFN604_shift_amount_reg_3
+ B2=n3805
XU4361 MOAI1S $PINS O=n3240 A1=n2351 A2=FE_OFN599_IyIt_5 B1=FE_OFN1659_n3611
+ B2=IyIt[3]
XU4362 MOAI1S $PINS O=n3239 A1=n4483 A2=n4256 B1=IyIt[4]
+ B2=FE_OFN4205_FE_OFN928_n2902
XU4363 NR2 $PINS O=n3247 I1=n3240 I2=n3239
XU4364 AOI22S $PINS O=n3246 A1=n3242 A2=FE_OFN4141_n2278 B1=n3241
+ B2=FE_OFN4319_FE_DBTN2_n2466
XU4366 MOAI1S $PINS O=n3248 A1=n3622 A2=n2619 B1=FE_OFN4344_n B2=n3628
XU4367 AOI22S $PINS O=n3250 A1=FE_DBTN23_n4483 A2=FE_OFN601_IyIt_3
+ B1=FE_OFN4209_FE_OFN928_n2902 B2=n4265
XU4368 OA12 $PINS O=n3258 A1=n3250 B1=FE_OFN953_n4489 B2=n3251
XU4369 AOI22S $PINS O=n3257 A1=n3255 A2=FE_OFN4141_n2278 B1=n3253
+ B2=FE_OFN4319_FE_DBTN2_n2466
XU4370 AOI22S $PINS O=n3256 A1=FE_OFN1661_n3611 A2=FE_OFN600_IyIt_4
+ B1=FE_OFN598_IyIt_6 B2=FE_OFN349_FE_DBTN24_n2351
XU4371 AOI22S $PINS O=n3267 A1=n3261 A2=FE_OFN799_n2447 B1=n3260
+ B2=FE_OFN788_n2278
XU4372 INV1S $PINS O=n3266 I=n3262
XU4373 AOI22S $PINS O=n3273 A1=n3271 A2=FE_OFN788_n2278 B1=n3269
+ B2=FE_OFN799_n2447
XU4374 AOI22S $PINS O=n3272 A1=Ix2[21] A2=n3820 B1=n3819 B2=n1356
XU4375 ND2 $PINS O=Ix2_shift[13] I1=n3273 I2=n3272
XU4376 AOI22S $PINS O=n3280 A1=n3277 A2=FE_OFN4213_FE_OFN778_n2278
+ B1=FE_OFN796_n2447 B2=n3274
XU4378 MUX3T $PINS O=n1254 S0=b_reg[0] S1=FE_OFN922_FE_DBTN1_n3943 A=n3934
+ B=FE_OFN4157_a_reg_0 C=It[4][0]
XU4379 INV1S $PINS O=n3284 I=Iy2_IxIt[27]
XU4380 FA1S $PINS S=Ux[26] CO=n3283 A=IxIy_IyIt[26] B=n3282 CI=n3281
XU4381 INV1S $PINS O=n3493 I=Iy2_IxIt[30]
XU4382 INV1S $PINS O=n3288 I=Iy2_IxIt[29]
XU4383 FA1 $PINS S=Ux[27] CO=n3408 A=FE_PHN3280_IxIy_IyIt_27 B=n3284 CI=n3283
XU4384 INV1S $PINS O=n3285 I=Iy2_IxIt[28]
XU4385 OR2 $PINS O=n3407 I1=IxIy_IyIt[28] I2=n3285
XU4386 INV1S $PINS O=n3286 I=n3406
XU4387 AO12 $PINS O=n3287 A1=n3286 B1=n3408 B2=n3407
XU4388 FA1S $PINS S=Ux[29] CO=n3492 A=FE_PHN3276_IxIy_IyIt_29 B=n3288 CI=n3287
XU4389 INV1S $PINS O=n3292 I=Ix2_IyIt[27]
XU4390 FA1S $PINS S=Uy[26] CO=n3291 A=IxIy_IxIt[26] B=n3290 CI=n3289
XU4391 INV1S $PINS O=n3584 I=Ix2_IyIt[30]
XU4392 INV1S $PINS O=n3296 I=Ix2_IyIt[29]
XU4393 FA1 $PINS S=Uy[27] CO=n3499 A=IxIy_IxIt[27] B=n3292 CI=n3291
XU4394 INV1S $PINS O=n3293 I=Ix2_IyIt[28]
XU4395 OR2 $PINS O=n3498 I1=IxIy_IxIt[28] I2=n3293
XU4396 INV1S $PINS O=n3294 I=n3497
XU4397 AO12 $PINS O=n3295 A1=n3294 B1=n3499 B2=n3498
XU4398 FA1S $PINS S=Uy[29] CO=n3583 A=IxIy_IxIt[29] B=n3296 CI=n3295
XU4401 INV1S $PINS O=n3297 I=n4106
XU4402 MUX3 $PINS O=intadd_0/A[1] S0=n4257 S1=n4134 A=FE_OFN414_intadd_14_SUM_1
+ B=FE_OFN404_intadd_14_SUM_3 C=n3297
XU4404 NR2 $PINS O=n4118 I1=FE_OFN396_intadd_14_SUM_5
+ I2=FE_OFN413_intadd_14_SUM_1
XU4405 NR2 $PINS O=n3299 I1=FE_OFN677_FE_DBTN46_intadd_14_SUM_4 I2=n4120
XU4406 NR2 $PINS O=n3300 I1=FE_OFN412_intadd_14_SUM_2 I2=n3299
XU4407 ND2 $PINS O=n3301 I1=FE_OFN677_FE_DBTN46_intadd_14_SUM_4 I2=n4120
XU4408 NR2 $PINS O=n4112 I1=n3301 I2=FE_OFN413_intadd_14_SUM_1
XU4409 INV1S $PINS O=n4116 I=n4112
XU4410 AOI22S $PINS O=n3307 A1=n3305 A2=n2447 B1=FE_OFN775_n2278 B2=n3303
XU4411 AOI22S $PINS O=n3306 A1=FE_OFN549_IxIt_21 A2=n3820 B1=n3819
+ B2=FE_OFN548_IxIt_22
XU4412 OR3B2S $PINS O=n3309 I1=n3308 B1=FE_OFN431_intadd_21_SUM_5
+ B2=FE_OFN678_FE_DBTN45_intadd_21_SUM_1
XU4415 NR2 $PINS O=n3315 I1=n3314 I2=n1308
XU4416 NR2 $PINS O=intadd_23/CI I1=FE_OFN595_IyIt_9 I2=n3315
XU4417 OAI22S $PINS O=intadd_29/B[0] A1=n3315 A2=intadd_23/CI B1=IyIt[9]
+ B2=intadd_23/CI
XU4418 AN2B1S $PINS O=n3317 I1=IxIy[8] B1=n3316
XU4419 NR2P $PINS O=intadd_24/CI I1=FE_OFN1668_IxIy_9 I2=n3317
XU4420 OAI22S $PINS O=intadd_30/B[0] A1=n3317 A2=intadd_24/CI
+ B1=FE_OFN1668_IxIy_9 B2=intadd_24/CI
XU4421 AN2B1S $PINS O=n3319 I1=IxIt[8] B1=n3318
XU4422 NR2 $PINS O=intadd_25/CI I1=FE_OFN555_IxIt_9 I2=n3319
XU4423 OAI22S $PINS O=intadd_31/B[0] A1=n3319 A2=intadd_25/CI
+ B1=FE_OFN555_IxIt_9 B2=intadd_25/CI
XU4425 NR2 $PINS O=intadd_8/B[1] I1=FE_OFN4121_intadd_14_SUM_2
+ I2=FE_OFN336_FE_DBTN53_Ix_0_6
XU4426 ND2 $PINS O=n4102 I1=FE_OFN4139_intadd_14_SUM_1
+ I2=FE_OFN4120_intadd_14_SUM_2
XU4428 NR2 $PINS O=n3320 I1=FE_OFN414_intadd_14_SUM_1
+ I2=FE_OFN404_intadd_14_SUM_3
XU4429 AOI22S $PINS O=n3329 A1=FE_OFN1040_FE_DBTN2_n2466 A2=n3323 B1=n3322
+ B2=FE_OCPN2940_n2278
XU4430 AN2 $PINS O=intadd_14/CI I1=FE_OFN530_a_reg_0 I2=img1[0][0]
XU4433 MOAI1 $PINS O=n3334 A1=FE_PHN3252_IxIy_20 A2=n3331 B1=IxIy[20] B2=n3331
XU4435 OAI22S $PINS O=n1120 A1=FE_OFN449_n1693 A2=n3334
+ B1=FE_OFN1053_FE_DBTN0_n4229 B2=n1410
XU4436 ND2S $PINS O=n4179 I1=Ix[0][5] I2=FE_OFN1747_n4113
XU4438 MOAI1S $PINS O=n3336 A1=n3335 A2=n4316 B1=n3335 B2=n4316
XU4439 MOAI1 $PINS O=n3338 A1=FE_OFN592_IyIt_20 A2=n3336 B1=FE_OFN592_IyIt_20
+ B2=n3336
XU4440 OAI22H $PINS O=n1097 A1=FE_OFN451_n1693 A2=n3338
+ B1=FE_OFN1053_FE_DBTN0_n4229 B2=n3337
XU4441 XNR2HS $PINS O=det[31] I1=n3342 I2=n3341
XU4442 INV1S $PINS O=n3343 I=n3799
XU4443 XOR2HS $PINS O=det[30] I1=n3797 I2=n3344
XU4444 XNR2HS $PINS O=det[29] I1=n3791 I2=n3346
XU4445 INV1S $PINS O=n3347 I=n3788
XU4446 XOR2HS $PINS O=det[28] I1=n3785 I2=n3348
XU4447 XNR2HS $PINS O=det[27] I1=n3779 I2=n3350
XU4448 INV1S $PINS O=n3351 I=n3776
XU4449 XOR2HS $PINS O=det[26] I1=n3774 I2=n3352
XU4450 XNR2HS $PINS O=det[25] I1=n3767 I2=n3354
XU4451 INV1S $PINS O=n3355 I=n3764
XU4452 XOR2HS $PINS O=det[24] I1=n3762 I2=n3356
XU4453 XNR2HS $PINS O=det[23] I1=n3756 I2=n3358
XU4454 INV1S $PINS O=n3359 I=n3753
XU4455 XOR2HS $PINS O=det[22] I1=n3750 I2=n3360
XU4456 XNR2HS $PINS O=det[21] I1=n3744 I2=n3362
XU4457 INV1S $PINS O=n3363 I=n3741
XU4458 XOR2HS $PINS O=det[20] I1=n3739 I2=n3364
XU4459 XNR2HS $PINS O=det[19] I1=n3733 I2=n3366
XU4460 INV1S $PINS O=n3367 I=n3730
XU4461 XOR2HS $PINS O=det[18] I1=n3728 I2=n3368
XU4462 XNR2HS $PINS O=det[17] I1=n3722 I2=n3370
XU4463 INV1S $PINS O=n3371 I=n3719
XU4464 XOR2HS $PINS O=det[16] I1=n3716 I2=n3372
XU4465 XNR2HS $PINS O=det[15] I1=n3710 I2=n3374
XU4466 INV1S $PINS O=n3375 I=n3707
XU4467 XOR2HS $PINS O=det[14] I1=n3705 I2=n3376
XU4468 XNR2HS $PINS O=det[13] I1=n3699 I2=n3378
XU4469 INV1S $PINS O=n3379 I=n3696
XU4470 XOR2HS $PINS O=det[12] I1=n3694 I2=n3380
XU4471 XNR2HS $PINS O=det[11] I1=n3688 I2=n3382
XU4472 INV1S $PINS O=n3383 I=n3685
XU4473 XOR2HS $PINS O=det[10] I1=n3682 I2=n3384
XU4474 XNR2HS $PINS O=det[9] I1=n3676 I2=n3386
XU4475 INV1S $PINS O=n3387 I=n3673
XU4476 XOR2HS $PINS O=det[8] I1=n3671 I2=n3388
XU4477 XNR2HS $PINS O=det[7] I1=n3665 I2=n3390
XU4478 INV1S $PINS O=n3391 I=n3662
XU4479 XOR2HS $PINS O=det[6] I1=n3660 I2=n3392
XU4480 ND2S $PINS O=n3654 I1=n3657 I2=n3393
XU4481 XNR2HS $PINS O=det[5] I1=n3654 I2=n3394
XU4482 INV1S $PINS O=n3395 I=n3651
XU4483 ND2S $PINS O=n3648 I1=n3395 I2=n3652
XU4484 XOR2HS $PINS O=det[4] I1=n3648 I2=n3396
XU4485 INV1S $PINS O=n3399 I=n3397
XU4486 ND2S $PINS O=n3642 I1=n3399 I2=n3398
XU4487 INV1S $PINS O=n3403 I=n3400
XU4488 OAI12HS $PINS O=n3401 A1=n3640 B1=n3403 B2=n3639
XU4489 XNR2HS $PINS O=det[3] I1=n3642 I2=n3401
XU4490 INV1S $PINS O=n3402 I=n3639
XU4491 ND2S $PINS O=n3637 I1=n3402 I2=n3640
XU4492 XOR2HS $PINS O=det[2] I1=n3637 I2=n3403
XU4493 XOR2HS $PINS O=det[1] I1=n3404 I2=Ix2_Iy2[1]
XU4494 XNR2HS $PINS O=det[0] I1=Ix2_Iy2[0] I2=n3405
XU4495 XNR2HS $PINS O=Ux[28] I1=n3409 I2=n3408
XU4496 INV1S $PINS O=n3412 I=n3410
XU4497 ND2S $PINS O=n3414 I1=n3412 I2=n3411
XU4498 XNR2HS $PINS O=Ux[23] I1=n3414 I2=n3413
XU4499 ND2S $PINS O=n3418 I1=n3416 I2=n3415
XU4500 XNR2H $PINS O=Ux[18] I1=n3418 I2=n3417
XU4501 ND2S $PINS O=n3422 I1=n3420 I2=n3419
XU4502 XNR2HS $PINS O=Ux[16] I1=n3422 I2=n3421
XU4503 INV1S $PINS O=n3425 I=n3423
XU4504 ND2S $PINS O=n3427 I1=n3425 I2=n3424
XU4505 XOR2HS $PINS O=Ux[15] I1=n3427 I2=n3426
XU4506 ND2S $PINS O=n3431 I1=n3429 I2=n3428
XU4507 XNR2HS $PINS O=Ux[14] I1=n3431 I2=n3430
XU4508 INV1S $PINS O=n3434 I=n3432
XU4509 ND2S $PINS O=n3436 I1=n3434 I2=n3433
XU4510 XOR2HS $PINS O=Ux[13] I1=n3436 I2=n3435
XU4511 ND2S $PINS O=n3440 I1=n3438 I2=n3437
XU4512 XNR2HS $PINS O=Ux[12] I1=n3440 I2=n3439
XU4513 INV1S $PINS O=n3443 I=n3441
XU4514 ND2S $PINS O=n3445 I1=n3443 I2=n3442
XU4515 XOR2HS $PINS O=Ux[11] I1=n3445 I2=n3444
XU4516 ND2S $PINS O=n3449 I1=n3447 I2=n3446
XU4517 XNR2HS $PINS O=Ux[10] I1=n3449 I2=n3448
XU4518 INV1S $PINS O=n3452 I=n3450
XU4519 ND2S $PINS O=n3454 I1=n3452 I2=n3451
XU4520 XOR2HS $PINS O=Ux[9] I1=n3454 I2=n3453
XU4521 ND2S $PINS O=n3458 I1=n3456 I2=n3455
XU4522 XNR2HS $PINS O=Ux[8] I1=n3458 I2=n3457
XU4523 INV1S $PINS O=n3461 I=n3459
XU4524 ND2S $PINS O=n3463 I1=n3461 I2=n3460
XU4525 XOR2HS $PINS O=Ux[7] I1=n3463 I2=n3462
XU4526 ND2S $PINS O=n3467 I1=n3465 I2=n3464
XU4527 XNR2HS $PINS O=Ux[6] I1=n3467 I2=n3466
XU4528 INV1S $PINS O=n3470 I=n3468
XU4529 ND2S $PINS O=n3472 I1=n3470 I2=n3469
XU4530 XOR2HS $PINS O=Ux[5] I1=n3472 I2=n3471
XU4531 ND2S $PINS O=n3476 I1=n3474 I2=n3473
XU4532 XNR2HS $PINS O=Ux[4] I1=n3476 I2=n3475
XU4533 INV1S $PINS O=n3479 I=n3477
XU4534 ND2S $PINS O=n3481 I1=n3479 I2=n3478
XU4535 XOR2HS $PINS O=Ux[3] I1=n3481 I2=n3480
XU4536 ND2S $PINS O=n3485 I1=n3483 I2=n3482
XU4537 XNR2HS $PINS O=Ux[2] I1=n3485 I2=n3484
XU4538 INV1S $PINS O=n3488 I=n3486
XU4539 ND2S $PINS O=n3489 I1=n3488 I2=n3487
XU4540 XOR2HS $PINS O=Ux[1] I1=n3490 I2=n3489
XU4541 XNR2HS $PINS O=Ux[0] I1=n3491 I2=IxIy_IyIt[0]
XU4542 INV1S $PINS O=n3495 I=IxIy_IyIt[31]
XU4543 FA1S $PINS S=Ux[30] CO=n3494 A=FE_PHN3275_IxIy_IyIt_30 B=n3493 CI=n3492
XU4544 FA1S $PINS S=Ux[31] CO=n3496 A=n3495 B=Iy2_IxIt[31] CI=n3494
XU4545 INV1S $PINS O=Ux[32] I=n3496
XU4546 XNR2HS $PINS O=Uy[28] I1=n3500 I2=n3499
XU4547 INV1S $PINS O=n3503 I=n3501
XU4548 ND2S $PINS O=n3505 I1=n3503 I2=n3502
XU4549 XNR2H $PINS O=Uy[23] I1=n3505 I2=n3504
XU4550 ND2S $PINS O=n3509 I1=n3507 I2=n3506
XU4551 XNR2HS $PINS O=Uy[18] I1=n3509 I2=n3508
XU4552 ND2S $PINS O=n3513 I1=n3511 I2=n3510
XU4553 XNR2HS $PINS O=Uy[16] I1=n3513 I2=n3512
XU4554 INV1S $PINS O=n3516 I=n3514
XU4555 ND2S $PINS O=n3518 I1=n3516 I2=n3515
XU4556 XOR2HS $PINS O=Uy[15] I1=n3518 I2=n3517
XU4557 ND2S $PINS O=n3522 I1=n3520 I2=n3519
XU4558 XNR2HS $PINS O=Uy[14] I1=n3522 I2=n3521
XU4559 INV1S $PINS O=n3525 I=n3523
XU4560 ND2S $PINS O=n3527 I1=n3525 I2=n3524
XU4561 XOR2HS $PINS O=Uy[13] I1=n3527 I2=n3526
XU4562 ND2S $PINS O=n3531 I1=n3529 I2=n3528
XU4563 XNR2HS $PINS O=Uy[12] I1=n3531 I2=n3530
XU4564 INV1S $PINS O=n3534 I=n3532
XU4565 ND2S $PINS O=n3536 I1=n3534 I2=n3533
XU4566 XOR2HS $PINS O=Uy[11] I1=n3536 I2=n3535
XU4567 ND2S $PINS O=n3540 I1=n3538 I2=n3537
XU4568 XNR2HS $PINS O=Uy[10] I1=n3540 I2=n3539
XU4569 INV1S $PINS O=n3543 I=n3541
XU4570 ND2S $PINS O=n3545 I1=n3543 I2=n3542
XU4571 XOR2HS $PINS O=Uy[9] I1=n3545 I2=n3544
XU4572 ND2S $PINS O=n3549 I1=n3547 I2=n3546
XU4573 XNR2HS $PINS O=Uy[8] I1=n3549 I2=n3548
XU4574 INV1S $PINS O=n3552 I=n3550
XU4575 ND2S $PINS O=n3554 I1=n3552 I2=n3551
XU4576 XOR2HS $PINS O=Uy[7] I1=n3554 I2=n3553
XU4577 ND2S $PINS O=n3558 I1=n3556 I2=n3555
XU4578 XNR2HS $PINS O=Uy[6] I1=n3558 I2=n3557
XU4579 INV1S $PINS O=n3561 I=n3559
XU4580 ND2S $PINS O=n3563 I1=n3561 I2=n3560
XU4581 XOR2HS $PINS O=Uy[5] I1=n3563 I2=n3562
XU4582 ND2S $PINS O=n3567 I1=n3565 I2=n3564
XU4583 XNR2HS $PINS O=Uy[4] I1=n3567 I2=n3566
XU4584 INV1S $PINS O=n3570 I=n3568
XU4585 ND2S $PINS O=n3572 I1=n3570 I2=n3569
XU4586 XOR2HS $PINS O=Uy[3] I1=n3572 I2=n3571
XU4587 ND2S $PINS O=n3576 I1=n3574 I2=n3573
XU4588 XNR2HS $PINS O=Uy[2] I1=n3576 I2=n3575
XU4589 INV1S $PINS O=n3579 I=n3577
XU4590 ND2S $PINS O=n3580 I1=n3579 I2=n3578
XU4591 XOR2HS $PINS O=Uy[1] I1=n3581 I2=n3580
XU4592 XNR2HS $PINS O=Uy[0] I1=n3582 I2=IxIy_IxIt[0]
XU4593 INV1S $PINS O=n3586 I=IxIy_IxIt[31]
XU4594 FA1S $PINS S=Uy[30] CO=n3585 A=IxIy_IxIt[30] B=n3584 CI=n3583
XU4595 FA1S $PINS S=Uy[31] CO=n3587 A=n3586 B=Ix2_IyIt[31] CI=n3585
XU4596 INV1S $PINS O=Uy[32] I=n3587
XU4597 INV1S $PINS O=n3592 I=n3595
XU4598 INV1S $PINS O=n3588 I=n3589
XU4599 OAI22S $PINS O=n4330 A1=n3589 A2=mul_pos[3] B1=n3588
+ B2=FE_PHN3279_mul_pos_buffer_3
XU4600 XNR2HS $PINS O=n3590 I1=n3593 I2=n4330
XU4601 NR2 $PINS O=shift_amount[3] I1=n3592 I2=n3590
XU4602 NR2 $PINS O=shift_amount[1] I1=n3592 I2=n3591
XU4603 NR2 $PINS O=n3594 I1=n4330 I2=n3593
XU4604 NR2 $PINS O=n3596 I1=n3595 I2=n3594
XU4605 NR2 $PINS O=shift_amount[0] I1=n3597 I2=n3596
XU4606 AOI22S $PINS O=n3602 A1=FE_OFN577_Iy2_3 A2=FE_OFN350_FE_DBTN24_n2351
+ B1=n3599 B2=FE_OFN787_n2278
XU4607 AOI22S $PINS O=n3601 A1=FE_OFN1660_n3611 A2=Iy2[1] B1=Iy2[0]
+ B2=FE_OFN1639_FE_DBTN23_n4483
XU4608 OAI112H $PINS O=n3604 A1=n3602 B1=n3601 C1=n3603 C2=n3614
XU4610 XOR2HS $PINS O=n3607 I1=FE_OFN823_n4336 I2=Ix2[0]
XU4611 OAI22S $PINS O=n1209 A1=FE_OFN461_n1703 A2=FE_PHN3297_n3607
+ B1=FE_OFN1033_FE_DBTN11_n4099 B2=FE_PHN3303_n3606
XU4612 AOI22S $PINS O=n3612 A1=FE_OFN1661_n3611 A2=Ix2[1] B1=Ix2[0]
+ B2=FE_DBTN23_n4483
XU4613 OAI112HS $PINS O=n3616 A1=n3613 B1=n3612 C1=n3615 C2=n3614
XU4614 AO12 $PINS O=Ix2_shift[0] A1=n3616 B1=n3617
+ B2=FE_OFN604_shift_amount_reg_3
XU4615 MOAI1S $PINS O=n1192 A1=n3621 A2=n3620 B1=n3619 B2=Ix2[17]
XU4616 INV1S $PINS O=n3624 I=n3622
XU4617 AOI22S $PINS O=n3632 A1=FE_OFN789_n2278 A2=n3625 B1=n3624
+ B2=FE_OFN4344_n
XU4618 AOI22S $PINS O=n3631 A1=n3630 A2=FE_OFN800_n2447 B1=n3628
+ B2=FE_OFN955_n4489
XU4620 INV1S $PINS O=n3633 I=Ix2_Iy2[0]
XU4621 XOR2HS $PINS O=n3635 I1=n3636 I2=Ix2_Iy2[1]
XU4622 MUX2 $PINS O=det_abs[1] S=FE_OFN512_n3751 A=det[1] B=n3635
XU4623 NR2P $PINS O=n3641 I1=Ix2_Iy2[1] I2=n3636
XU4624 XNR2HS $PINS O=n3638 I1=n3637 I2=n3641
XU4625 MUX2 $PINS O=det_abs[2] S=FE_OFN512_n3751 A=det[2] B=n3638
XU4626 AOI12HS $PINS O=n3647 A1=n3639 B1=n3641 B2=n3640
XU4627 XOR2HS $PINS O=n3643 I1=n3642 I2=n3647
XU4628 MUX2 $PINS O=det_abs[3] S=FE_OFN512_n3751 A=det[3] B=n3643
XU4629 INV1S $PINS O=n3644 I=Ix2_Iy2[3]
XU4630 NR2 $PINS O=n3646 I1=n3644 I2=IxIy2[3]
XU4631 ND2S $PINS O=n3645 I1=IxIy2[3] I2=n3644
XU4632 OAI12H $PINS O=n3653 A1=n3645 B1=n3647 B2=n3646
XU4633 XNR2HS $PINS O=n3650 I1=n3648 I2=n3653
XU4634 MUX2 $PINS O=det_abs[4] S=FE_OFN512_n3751 A=det[4] B=n3650
XU4636 XOR2HS $PINS O=n3655 I1=n3654 I2=n3659
XU4637 MUX2 $PINS O=det_abs[5] S=FE_OFN512_n3751 A=det[5] B=n3655
XU4638 INV1S $PINS O=n3656 I=Ix2_Iy2[5]
XU4639 NR2 $PINS O=n3658 I1=n3656 I2=IxIy2[5]
XU4640 OAI12H $PINS O=n3664 A1=n3657 B1=n3659 B2=n3658
XU4641 XNR2HS $PINS O=n3661 I1=n3660 I2=n3664
XU4642 MUX2 $PINS O=det_abs[6] S=FE_OFN512_n3751 A=det[6] B=n3661
XU4643 AOI12HS $PINS O=n3670 A1=n3662 B1=n3664 B2=n3663
XU4644 XOR2HS $PINS O=n3666 I1=n3665 I2=n3670
XU4645 MUX2 $PINS O=det_abs[7] S=FE_OFN2733_n3751 A=det[7] B=n3666
XU4646 INV1S $PINS O=n3667 I=Ix2_Iy2[7]
XU4647 NR2 $PINS O=n3669 I1=n3667 I2=IxIy2[7]
XU4648 XNR2HS $PINS O=n3672 I1=n3671 I2=n3675
XU4649 MUX2 $PINS O=det_abs[8] S=FE_OFN2733_n3751 A=det[8] B=n3672
XU4650 AOI12HS $PINS O=n3681 A1=n3673 B1=n3675 B2=n3674
XU4651 XOR2HS $PINS O=n3677 I1=n3676 I2=n3681
XU4652 MUX2 $PINS O=det_abs[9] S=FE_OFN2733_n3751 A=det[9] B=n3677
XU4653 INV1S $PINS O=n3678 I=Ix2_Iy2[9]
XU4654 NR2 $PINS O=n3680 I1=n3678 I2=IxIy2[9]
XU4655 OAI12H $PINS O=n3687 A1=n3679 B1=n3681 B2=n3680
XU4656 XNR2HS $PINS O=n3684 I1=n3682 I2=n3687
XU4657 MUX2 $PINS O=det_abs[10] S=FE_OFN2733_n3751 A=det[10] B=n3684
XU4658 XOR2HS $PINS O=n3689 I1=n3688 I2=n3693
XU4659 MUX2 $PINS O=det_abs[11] S=FE_OFN2733_n3751 A=det[11] B=n3689
XU4660 INV1S $PINS O=n3690 I=Ix2_Iy2[11]
XU4661 NR2 $PINS O=n3692 I1=n3690 I2=IxIy2[11]
XU4662 OAI12H $PINS O=n3698 A1=n3691 B1=n3693 B2=n3692
XU4663 XNR2HS $PINS O=n3695 I1=n3694 I2=n3698
XU4664 MUX2 $PINS O=det_abs[12] S=FE_OFN510_n3751 A=det[12] B=n3695
XU4665 AOI12H $PINS O=n3704 A1=n3696 B1=n3698 B2=n3697
XU4666 XOR2HS $PINS O=n3700 I1=n3699 I2=n3704
XU4667 MUX2 $PINS O=det_abs[13] S=FE_OFN510_n3751 A=det[13] B=n3700
XU4668 INV1S $PINS O=n3701 I=Ix2_Iy2[13]
XU4669 NR2 $PINS O=n3703 I1=n3701 I2=IxIy2[13]
XU4670 OAI12H $PINS O=n3709 A1=n3702 B1=n3704 B2=n3703
XU4671 XNR2HS $PINS O=n3706 I1=n3705 I2=n3709
XU4672 MUX2 $PINS O=det_abs[14] S=FE_OFN510_n3751 A=det[14] B=n3706
XU4673 AOI12H $PINS O=n3715 A1=n3707 B1=n3709 B2=n3708
XU4674 XOR2HS $PINS O=n3711 I1=n3710 I2=n3715
XU4675 MUX2 $PINS O=det_abs[15] S=FE_OFN510_n3751 A=det[15] B=n3711
XU4676 INV1S $PINS O=n3712 I=Ix2_Iy2[15]
XU4677 NR2 $PINS O=n3714 I1=n3712 I2=IxIy2[15]
XU4678 OAI12H $PINS O=n3721 A1=n3713 B1=n3715 B2=n3714
XU4679 XNR2HS $PINS O=n3718 I1=n3716 I2=n3721
XU4680 MUX2 $PINS O=det_abs[16] S=FE_OFN4365_n A=det[16] B=n3718
XU4681 AOI12H $PINS O=n3727 A1=n3719 B1=n3721 B2=n3720
XU4682 XOR2HS $PINS O=n3723 I1=n3722 I2=n3727
XU4683 MUX2 $PINS O=det_abs[17] S=FE_OFN4365_n A=det[17] B=n3723
XU4684 INV1S $PINS O=n3724 I=Ix2_Iy2[17]
XU4685 NR2 $PINS O=n3726 I1=n3724 I2=IxIy2[17]
XU4686 OAI12H $PINS O=n3732 A1=n3725 B1=n3727 B2=n3726
XU4687 XNR2HS $PINS O=n3729 I1=n3728 I2=n3732
XU4688 MUX2 $PINS O=det_abs[18] S=FE_OFN508_n3751 A=det[18] B=n3729
XU4689 AOI12H $PINS O=n3738 A1=n3730 B1=n3732 B2=n3731
XU4690 XOR2HS $PINS O=n3734 I1=n3733 I2=n3738
XU4691 MUX2 $PINS O=det_abs[19] S=FE_OFN4216_FE_OFN508_n3751 A=det[19] B=n3734
XU4692 INV1S $PINS O=n3735 I=Ix2_Iy2[19]
XU4693 NR2 $PINS O=n3737 I1=n3735 I2=IxIy2[19]
XU4694 OAI12H $PINS O=n3743 A1=n3736 B1=n3738 B2=n3737
XU4695 XNR2HS $PINS O=n3740 I1=n3739 I2=n3743
XU4696 MUX2 $PINS O=det_abs[20] S=FE_OFN4216_FE_OFN508_n3751 A=det[20] B=n3740
XU4697 AOI12H $PINS O=n3749 A1=n3741 B1=n3743 B2=n3742
XU4698 XOR2HS $PINS O=n3745 I1=n3744 I2=n3749
XU4699 MUX2 $PINS O=det_abs[21] S=FE_OFN4216_FE_OFN508_n3751 A=det[21] B=n3745
XU4700 INV1S $PINS O=n3746 I=Ix2_Iy2[21]
XU4701 NR2 $PINS O=n3748 I1=n3746 I2=IxIy2[21]
XU4702 OAI12H $PINS O=n3755 A1=n3747 B1=n3749 B2=n3748
XU4703 XNR2HS $PINS O=n3752 I1=n3750 I2=n3755
XU4705 MUX2 $PINS O=det_abs[22] S=FE_OFN4215_FE_OFN508_n3751 A=det[22] B=n3752
XU4706 AOI12H $PINS O=n3761 A1=n3753 B1=n3755 B2=n3754
XU4707 XOR2HS $PINS O=n3757 I1=n3756 I2=n3761
XU4708 MUX2 $PINS O=det_abs[23] S=FE_OFN4215_FE_OFN508_n3751 A=det[23] B=n3757
XU4709 INV1S $PINS O=n3758 I=Ix2_Iy2[23]
XU4710 NR2 $PINS O=n3760 I1=n3758 I2=IxIy2[23]
XU4711 OAI12H $PINS O=n3766 A1=n3759 B1=n3761 B2=n3760
XU4712 XNR2HS $PINS O=n3763 I1=n3762 I2=n3766
XU4713 MUX2 $PINS O=det_abs[24] S=FE_OFN4215_FE_OFN508_n3751 A=det[24] B=n3763
XU4714 AOI12H $PINS O=n3773 A1=n3764 B1=n3766 B2=n3765
XU4715 XOR2HS $PINS O=n3769 I1=n3767 I2=n3773
XU4716 MUX2 $PINS O=det_abs[25] S=FE_OFN4215_FE_OFN508_n3751 A=det[25] B=n3769
XU4717 INV1S $PINS O=n3770 I=Ix2_Iy2[25]
XU4718 NR2 $PINS O=n3772 I1=n3770 I2=IxIy2[25]
XU4719 OAI12H $PINS O=n3778 A1=n3771 B1=n3773 B2=n3772
XU4720 XNR2HS $PINS O=n3775 I1=n3774 I2=n3778
XU4721 MUX2 $PINS O=det_abs[26] S=FE_OFN4215_FE_OFN508_n3751 A=det[26] B=n3775
XU4722 AOI12H $PINS O=n3784 A1=n3776 B1=n3778 B2=n3777
XU4723 XOR2HS $PINS O=n3780 I1=n3779 I2=n3784
XU4724 MUX2 $PINS O=det_abs[27] S=FE_OFN4215_FE_OFN508_n3751 A=det[27] B=n3780
XU4725 INV1S $PINS O=n3781 I=Ix2_Iy2[27]
XU4726 NR2 $PINS O=n3783 I1=n3781 I2=IxIy2[27]
XU4727 OAI12H $PINS O=n3790 A1=n3782 B1=n3784 B2=n3783
XU4728 XNR2HS $PINS O=n3787 I1=n3785 I2=n3790
XU4729 MUX2 $PINS O=det_abs[28] S=n3751 A=det[28] B=n3787
XU4730 XOR2HS $PINS O=n3792 I1=n3791 I2=n3796
XU4731 MUX2 $PINS O=det_abs[29] S=FE_OFN508_n3751 A=det[29] B=n3792
XU4732 INV1S $PINS O=n3793 I=Ix2_Iy2[29]
XU4733 NR2 $PINS O=n3795 I1=n3793 I2=IxIy2[29]
XU4734 OAI12HS $PINS O=n3801 A1=n3794 B1=n3796 B2=n3795
XU4735 XNR2HS $PINS O=n3798 I1=n3797 I2=n3801
XU4736 MUX2 $PINS O=det_abs[30] S=n3751 A=det[30] B=n3798
XU4737 INV1S $PINS O=n3803 I=IxIy2[31]
XU4738 AO12 $PINS O=n3802 A1=n3799 B1=n3801 B2=n3800
XU4739 FA1S $PINS S=n3804 A=Ix2_Iy2[31] B=n3803 CI=n3802
XU4740 MUX2 $PINS O=det_abs[31] S=n3751 A=det[31] B=n3804
XU4741 AOI22S $PINS O=n3809 A1=n3808 A2=FE_OFN4149_n B1=n3806 B2=IyIt[21]
XU4742 OAI112HS $PINS O=IyIt_shift[9] A1=n3810 B1=n3809 C1=FE_OFN4244_n2466
+ C2=n3826
XU4743 OA12 $PINS O=n3816 A1=n3811 B1=n3813 B2=FE_OFN4244_n2466
XU4744 OAI112HS $PINS O=IyIt_shift[12] A1=n3816 B1=n3815 C1=n3818
+ C2=FE_OFN927_n2619
XU4745 AOI22S $PINS O=n3824 A1=IyIt[21] A2=n3820 B1=n3819 B2=IyIt[22]
XU4746 OAI112HS $PINS O=IyIt_shift[13] A1=n3824 B1=n3823 C1=n3826
+ C2=FE_OFN927_n2619
XU4747 INV1S $PINS O=n3828 I=Vout[0]
XU4748 INV1S $PINS O=n3827 I=n3832
XU4749 OAI222S $PINS O=n1089 A1=n3828 A2=n3871 B1=FE_OFN4276_n3869 B2=n3827
+ C1=n1692 C2=n3864
XU4750 INV1S $PINS O=n3837 I=Vout[1]
XU4751 NR2 $PINS O=n3830 I1=FE_DBTN37_n4365 I2=n1692
XU4752 XOR2HS $PINS O=n3836 I1=n3831 I2=n3830
XU4753 ND2S $PINS O=n3833 I1=n3832 I2=FE_OFN525_n4365
XU4754 XNR2HS $PINS O=n3835 I1=n3834 I2=n3833
XU4755 OAI222S $PINS O=n1088 A1=n3837 A2=n3871 B1=n3864 B2=n3836
+ C1=FE_OFN4276_n3869 C2=n3835
XU4757 INV1S $PINS O=n3861 I=FE_OFN803_n3871
XU4759 ND2S $PINS O=n3840 I1=n3839 I2=FE_OFN527_n4365
XU4760 XNR2HS $PINS O=n3842 I1=n3841 I2=n3840
XU4761 AO222S $PINS O=n1087 A1=n3843 A2=FE_OFN802_n3869 B1=n3861 B2=Vout[2]
+ C1=FE_OFN1628_n3867 C2=n3842
XU4762 INV1S $PINS O=n3846 I=Vout[3]
XU4763 OAI222S $PINS O=n1086 A1=n3846 A2=FE_OFN803_n3871 B1=FE_OFN4276_n3869
+ B2=n3845 C1=n3867 C2=n3844
XU4764 INV1S $PINS O=n3849 I=Vout[4]
XU4765 OAI222S $PINS O=n1085 A1=n3849 A2=FE_OFN803_n3871 B1=n3848
+ B2=FE_OFN2731_n3867 C1=n3847 C2=FE_OFN4276_n3869
XU4766 INV1S $PINS O=n3852 I=Vout[5]
XU4767 OAI222S $PINS O=n1084 A1=n3852 A2=FE_OFN803_n3871 B1=n3851 B2=n3867
+ C1=n3850 C2=n3869
XU4768 INV1S $PINS O=n3854 I=n3853
XU4769 AO222S $PINS O=n1082 A1=n3855 A2=FE_OFN802_n3869 B1=n3861 B2=Vout[7]
+ C1=FE_OFN1628_n3867 C2=n3854
XU4770 INV1S $PINS O=n3856 I=Vout[8]
XU4771 OAI222S $PINS O=n1081 A1=n3869 A2=n3858 B1=n3867 B2=n3857
+ C1=FE_OFN803_n3871 C2=FE_PHN3254_n3856
XU4773 INV1S $PINS O=n3870 I=Vout[11]
XU4774 OAI222S $PINS O=n1078 A1=FE_OFN803_n3871 A2=n3870 B1=FE_OFN1618_n3869
+ B2=n3868 C1=FE_OFN513_n3867 C2=n3866
XU4775 NR2 $PINS O=N590 I1=col_reg[0] I2=n4333
XU4776 MOAI1S $PINS O=N591 A1=col_reg[1] A2=n3872 B1=col_reg[1] B2=N590
XU4777 NR2 $PINS O=n3874 I1=N590 I2=n4364
XU4778 ND2S $PINS O=n3876 I1=col_reg[0] I2=col_reg[1]
XU4779 AOI22S $PINS O=FE_PHN3291_N592 A1=col_reg[2] A2=n3874 B1=n3876 B2=n4362
XU4780 INV1S $PINS O=n3877 I=n3873
XU4781 ND2S $PINS O=n3875 I1=col_reg[2] I2=n3874
XU4782 MOAI1S $PINS O=N593 A1=n3877 A2=n3876 B1=FE_PHN3219_col_reg_3 B2=n3875
XU4783 MOAI1S $PINS O=mul_src_abs[1] A1=n3879 A2=n3878 B1=n3879 B2=n3878
XU4784 NR2 $PINS O=n3881 I1=FE_OFN1075_n3930 I2=n3880
XU4785 MOAI1S $PINS O=mul_src_abs[2] A1=n3882 A2=n3881 B1=n3882 B2=n3881
XU4786 MOAI1S $PINS O=mul_src_abs[3] A1=n3885 A2=n3884 B1=n3885 B2=n3884
XU4787 NR2 $PINS O=n3887 I1=FE_OFN1075_n3930 I2=n3886
XU4788 MOAI1S $PINS O=mul_src_abs[4] A1=n3888 A2=n3887 B1=n3888 B2=n3887
XU4789 MOAI1S $PINS O=mul_src_abs[5] A1=n3891 A2=n3890 B1=n3891 B2=n3890
XU4790 NR2 $PINS O=n3893 I1=FE_OFN1075_n3930 I2=n3892
XU4791 MOAI1S $PINS O=mul_src_abs[6] A1=n3894 A2=n3893 B1=n3894 B2=n3893
XU4792 MOAI1S $PINS O=mul_src_abs[7] A1=n3897 A2=n3896 B1=n3897 B2=n3896
XU4793 NR2 $PINS O=n3899 I1=n3898 I2=FE_OFN1075_n3930
XU4794 MOAI1S $PINS O=mul_src_abs[8] A1=n3900 A2=n3899 B1=n3900 B2=n3899
XU4795 MOAI1S $PINS O=mul_src_abs[9] A1=n3903 A2=n3902 B1=n3903 B2=n3902
XU4796 NR2 $PINS O=n3905 I1=n3904 I2=FE_OFN1075_n3930
XU4797 MOAI1S $PINS O=mul_src_abs[10] A1=n3906 A2=n3905 B1=n3906 B2=n3905
XU4798 NR2 $PINS O=n3908 I1=n3907 I2=FE_OFN1075_n3930
XU4799 MOAI1S $PINS O=mul_src_abs[12] A1=n3909 A2=n3908 B1=n3909 B2=n3908
XU4800 NR2 $PINS O=n3911 I1=n3910 I2=n3930
XU4801 MOAI1S $PINS O=mul_src_abs[14] A1=n3912 A2=n3911 B1=n3912 B2=n3911
XU4802 NR2 $PINS O=n3914 I1=n3913 I2=n3930
XU4803 MOAI1S $PINS O=mul_src_abs[16] A1=n3915 A2=n3914 B1=n3915 B2=n3914
XU4804 NR2 $PINS O=n3917 I1=n3916 I2=n3930
XU4805 MOAI1S $PINS O=mul_src_abs[18] A1=n3918 A2=n3917 B1=n3918 B2=n3917
XU4806 AOI22S $PINS O=n3922 A1=FE_OFN591_IyIt_21 A2=FE_OFN358_FE_DBTN19_n2355
+ B1=FE_OFN549_IxIt_21 B2=FE_OFN488_n2357
XU4807 AOI22S $PINS O=n3921 A1=FE_OFN562_Iy2_21 A2=FE_OFN344_FE_DBTN35_n1689
+ B1=FE_OFN579_IxIy_21 B2=FE_OFN694_FE_DBTN15_n2359
XU4808 ND3 $PINS O=n3928 I1=n3923 I2=n3922 I3=n3921
XU4809 ND2S $PINS O=n3927 I1=n3929 I2=FE_OFN934_n3926
XU4810 MOAI1S $PINS O=mul_src_abs[21] A1=n3928 A2=n3927 B1=n3928 B2=n3927
XU4811 NR3 $PINS O=mul_src_abs[22] I1=n3930 I2=n3929 I3=n3928
XU4812 AN2 $PINS O=n3933 I1=FE_OFN516_n4245 I2=start_valid
XU4813 OA22 $PINS O=n1256 A1=valid A2=n3933 B1=n3932 B2=n3931
XU4814 OR2 $PINS O=n1255 I1=FE_OFN516_n4245 I2=FE_PHN3205_start_valid
XU4815 INV1S $PINS O=intadd_22/B[0] I=b_reg[1]
XU4816 NR2 $PINS O=intadd_22/CI I1=b_reg[0] I2=FE_OFN4157_a_reg_0
XU4818 OAI22S $PINS O=n1253 A1=FE_OFN922_FE_DBTN1_n3943 A2=intadd_22/SUM[0]
+ B1=FE_OFN807_n3943 B2=FE_DBTN56_It_4_1
XU4819 INV1S $PINS O=intadd_22/B[1] I=b_reg[2]
XU4821 OAI22S $PINS O=n1252 A1=FE_OFN921_FE_DBTN1_n3943 A2=intadd_22/SUM[1]
+ B1=FE_OFN807_n3943 B2=FE_DBTN57_It_4_2
XU4822 INV1S $PINS O=intadd_22/B[2] I=b_reg[3]
XU4824 OAI22S $PINS O=n1251 A1=FE_OFN921_FE_DBTN1_n3943 A2=intadd_22/SUM[2]
+ B1=FE_OFN807_n3943 B2=FE_DBTN58_It_4_3
XU4825 INV1S $PINS O=intadd_22/B[3] I=b_reg[4]
XU4826 OAI22S $PINS O=n1250 A1=FE_OFN922_FE_DBTN1_n3943 A2=intadd_22/SUM[3]
+ B1=FE_OFN808_n3943 B2=FE_DBTN59_It_4_4
XU4827 INV1S $PINS O=intadd_22/B[4] I=b_reg[5]
XU4829 OAI22S $PINS O=n1249 A1=FE_OFN922_FE_DBTN1_n3943 A2=intadd_22/SUM[4]
+ B1=FE_OFN808_n3943 B2=FE_DBTN60_It_4_5
XU4830 INV1S $PINS O=intadd_22/B[5] I=b_reg[6]
XU4831 OAI22S $PINS O=n1248 A1=FE_OFN922_FE_DBTN1_n3943 A2=intadd_22/SUM[5]
+ B1=FE_OFN808_n3943 B2=FE_DBTN61_It_4_6
XU4832 INV1S $PINS O=intadd_22/B[6] I=b_reg[7]
XU4833 INV1S $PINS O=n4080 I=FE_OFN4274_It_4__7
XU4834 OAI22S $PINS O=n1247 A1=FE_OFN922_FE_DBTN1_n3943 A2=intadd_22/SUM[6]
+ B1=FE_OFN808_n3943 B2=n4080
XU4836 MOAI1S $PINS O=n1243 A1=FE_OFN916_FE_DBTN1_n3943
+ A2=FE_OFN332_FE_DBTN57_It_4_2 B1=FE_OFN916_FE_DBTN1_n3943 B2=FE_PHN3194_It_3_2
XU4837 MOAI1S $PINS O=n1242 A1=FE_OFN915_FE_DBTN1_n3943
+ A2=FE_OFN331_FE_DBTN58_It_4_3 B1=FE_OFN915_FE_DBTN1_n3943 B2=It[3][3]
XU4839 MOAI1S $PINS O=n1241 A1=FE_OFN920_FE_DBTN1_n3943
+ A2=FE_OFN330_FE_DBTN59_It_4_4 B1=FE_OFN920_FE_DBTN1_n3943 B2=It[3][4]
XU4840 MOAI1S $PINS O=n1240 A1=FE_OFN920_FE_DBTN1_n3943
+ A2=FE_OFN329_FE_DBTN60_It_4_5 B1=FE_OFN921_FE_DBTN1_n3943 B2=It[3][5]
XU4841 MOAI1S $PINS O=n1239 A1=FE_OFN921_FE_DBTN1_n3943 A2=FE_DBTN61_It_4_6
+ B1=FE_OFN921_FE_DBTN1_n3943 B2=It[3][6]
XU4842 MOAI1S $PINS O=n1238 A1=FE_OFN918_FE_DBTN1_n3943 A2=n4080
+ B1=FE_OFN918_FE_DBTN1_n3943 B2=It[3][7]
XU4843 MOAI1S $PINS O=n1237 A1=FE_OFN918_FE_DBTN1_n3943 A2=FE_DBTN62_It_4_8
+ B1=FE_OFN918_FE_DBTN1_n3943 B2=FE_PHN3155_It_3_8
XU4844 MUX2 $PINS O=n1236 S=FE_OFN914_FE_DBTN1_n3943 A=FE_PHN3177_It_3_0
+ B=It[2][0]
XU4846 MUX2 $PINS O=n1235 S=FE_OFN915_FE_DBTN1_n3943 A=It[3][1] B=It[2][1]
XU4847 MUX2 $PINS O=n1234 S=FE_OFN919_FE_DBTN1_n3943 A=FE_PHN3194_It_3_2
+ B=It[2][2]
XU4848 MUX2 $PINS O=n1233 S=FE_OFN919_FE_DBTN1_n3943 A=It[3][3] B=It[2][3]
XU4849 MUX2 $PINS O=n1232 S=FE_OFN915_FE_DBTN1_n3943 A=It[3][4] B=It[2][4]
XU4850 MUX2 $PINS O=n1231 S=FE_OFN920_FE_DBTN1_n3943 A=It[3][5] B=It[2][5]
XU4851 MUX2 $PINS O=n1230 S=FE_OFN916_FE_DBTN1_n3943 A=It[3][6] B=It[2][6]
XU4853 MUX2 $PINS O=n1229 S=FE_OFN917_FE_DBTN1_n3943 A=It[3][7]
+ B=FE_PHN3179_It_2_7
XU4854 MUX2 $PINS O=n1228 S=FE_OFN918_FE_DBTN1_n3943 A=FE_PHN3155_It_3_8
+ B=FE_PHN3148_It_2_8
XU4855 MUX2 $PINS O=n1227 S=FE_OFN914_FE_DBTN1_n3943 A=It[2][0]
+ B=FE_PHN3212_It_1_0
XU4856 MUX2 $PINS O=n1226 S=FE_OFN919_FE_DBTN1_n3943 A=It[2][1]
+ B=FE_PHN3190_It_1_1
XU4857 MUX2 $PINS O=n1225 S=FE_OFN919_FE_DBTN1_n3943 A=It[2][2] B=It[1][2]
XU4858 MUX2 $PINS O=n1224 S=FE_OFN919_FE_DBTN1_n3943 A=It[2][3]
+ B=FE_PHN3160_It_1_3
XU4859 MUX2 $PINS O=n1223 S=FE_OFN919_FE_DBTN1_n3943 A=It[2][4] B=It[1][4]
XU4860 MUX2 $PINS O=n1222 S=FE_OFN916_FE_DBTN1_n3943 A=It[2][5] B=It[1][5]
XU4861 MUX2 $PINS O=n1221 S=FE_OFN915_FE_DBTN1_n3943 A=It[2][6] B=It[1][6]
XU4862 MUX2 $PINS O=n1220 S=FE_OFN917_FE_DBTN1_n3943 A=FE_PHN3179_It_2_7
+ B=It[1][7]
XU4863 MUX2 $PINS O=n1219 S=FE_OFN918_FE_DBTN1_n3943 A=FE_PHN3148_It_2_8
+ B=It[1][8]
XU4864 MOAI1S $PINS O=n1218 A1=n3943 A2=FE_DBTN63_It_0_0 B1=FE_OFN805_n3943
+ B2=FE_PHN3212_It_1_0
XU4866 MOAI1S $PINS O=n1217 A1=FE_OFN805_n3943 A2=FE_DBTN64_It_0_1
+ B1=FE_OFN806_n3943 B2=FE_PHN3190_It_1_1
XU4868 MOAI1S $PINS O=n1216 A1=FE_OFN806_n3943 A2=FE_DBTN65_It_0_2
+ B1=FE_OFN806_n3943 B2=It[1][2]
XU4870 MOAI1S $PINS O=n1215 A1=FE_OFN805_n3943 A2=FE_DBTN66_It_0_3
+ B1=FE_OFN806_n3943 B2=FE_PHN3160_It_1_3
XU4872 MOAI1S $PINS O=n1214 A1=FE_OFN805_n3943 A2=FE_DBTN67_It_0_4
+ B1=FE_OFN805_n3943 B2=It[1][4]
XU4874 MOAI1S $PINS O=n1212 A1=FE_OFN804_n3943 A2=FE_DBTN69_It_0_6
+ B1=FE_OFN804_n3943 B2=It[1][6]
XU4875 MOAI1S $PINS O=n1210 A1=FE_OFN804_n3943 A2=FE_OFN317_FE_DBTN70_It_0_8
+ B1=FE_OFN804_n3943 B2=It[1][8]
XU4877 NR2 $PINS O=intadd_1/A[0] I1=FE_OFN360_FE_DBTN13_n4339 I2=n3949
XU4879 NR2 $PINS O=intadd_1/CI I1=FE_OFN4134_n4336 I2=FE_OFN437_intadd_21_SUM_3
XU4881 NR2 $PINS O=intadd_32/A[0] I1=FE_OFN437_intadd_21_SUM_3 I2=n3950
XU4882 NR2 $PINS O=n3952 I1=FE_OFN678_FE_DBTN45_intadd_21_SUM_1
+ I2=FE_OFN360_FE_DBTN13_n4339
XU4883 MOAI1S $PINS O=n3953 A1=n3952 A2=n3951 B1=FE_OFN360_FE_DBTN13_n4339
+ B2=FE_OFN437_intadd_21_SUM_3
XU4884 NR2 $PINS O=intadd_1/A[1] I1=n3953 I2=intadd_32/A[0]
XU4885 INV1S $PINS O=intadd_14/B[4] I=FE_PHN3284_a_reg_5
XU4886 NR2 $PINS O=intadd_1/B[1] I1=FE_OFN435_intadd_21_SUM_4
+ I2=FE_OFN4134_n4336
XU4887 NR2 $PINS O=intadd_32/CI I1=FE_OFN435_intadd_21_SUM_4 I2=n4337
XU4888 INV1S $PINS O=intadd_14/B[5] I=FE_PHN3285_a_reg_6
XU4889 NR2 $PINS O=intadd_1/B[2] I1=FE_OFN429_intadd_21_SUM_5
+ I2=FE_OFN4134_n4336
XU4890 NR2 $PINS O=n3954 I1=n4339 I2=FE_OFN4240_intadd_21_SUM_3
XU4891 MOAI1S $PINS O=n3955 A1=n3954 A2=FE_OFN678_FE_DBTN45_intadd_21_SUM_1
+ B1=FE_OFN4240_intadd_21_SUM_3 B2=FE_OFN435_intadd_21_SUM_4
XU4892 AN2B1S $PINS O=intadd_32/A[1] I1=n3956 B1=n3955
XU4893 NR2 $PINS O=intadd_32/B[1] I1=FE_OFN429_intadd_21_SUM_5 I2=n4337
XU4894 INV1S $PINS O=intadd_14/B[6] I=a_reg[7]
XU4895 NR2 $PINS O=intadd_1/B[3] I1=FE_OFN426_intadd_21_SUM_6
+ I2=FE_OFN4134_n4336
XU4896 NR2 $PINS O=intadd_32/B[2] I1=FE_OFN426_intadd_21_SUM_6 I2=n4337
XU4897 FA1S $PINS S=intadd_1/A[5] CO=n3104 A=n3959 B=n3958 CI=n3957
XU4898 FA1S $PINS S=n3103 CO=n3968 A=n3962 B=n3961 CI=n3960
XU4899 NR2 $PINS O=n3965 I1=FE_OFN426_intadd_21_SUM_6
+ I2=FE_OFN4239_intadd_21_SUM_3
XU4900 OAI12HS $PINS O=n3970 A1=FE_OFN431_intadd_21_SUM_5 B1=n3965 B2=n1575
XU4901 OA222 $PINS O=n3966 A1=n3965 A2=n3970 B1=n3965
+ B2=FE_OFN431_intadd_21_SUM_5 C1=n3970 C2=n1575
XU4902 FA1S $PINS S=intadd_1/B[7] CO=intadd_1/A[8] A=n3968 B=n3967 CI=n3966
XU4903 NR2 $PINS O=n3971 I1=FE_OFN4239_intadd_21_SUM_3 I2=n1495
XU4904 INV1S $PINS O=intadd_1/B[8] I=n3969
XU4905 FA1S $PINS S=n3969 CO=n3973 A=n3972 B=n3971 CI=n3970
XU4906 INV1S $PINS O=intadd_1/A[9] I=n3973
XU4907 NR2 $PINS O=n3975 I1=FE_OFN434_intadd_21_SUM_4 I2=FE_OFN748_n1495
XU4908 OAI222S $PINS O=intadd_1/B[9] A1=n3975 A2=FE_OFN432_intadd_21_SUM_5
+ B1=n3975 B2=n3974 C1=n3974 C2=FE_OFN428_intadd_21_SUM_6
XU4909 XNR2HS $PINS O=n3978 I1=n3976 I2=n3977
XU4910 OAI22S $PINS O=n1189 A1=n3978 A2=n1703 B1=FE_OFN1032_FE_DBTN11_n4099
+ B2=n3977
XU4911 XNR2HS $PINS O=n3981 I1=n3979 I2=FE_OFN533_Ix2_21
XU4912 MOAI1S $PINS O=n1188 A1=n3981 A2=FE_OFN456_n1703 B1=FE_OFN533_Ix2_21
+ B2=FE_OFN939_n4099
XU4913 INV1S $PINS O=n3985 I=IxIt[1]
XU4914 AN2 $PINS O=n3988 I1=IxIt[0] I2=n3982
XU4915 ND2S $PINS O=n3984 I1=It[4][1] I2=FE_OFN4138_n4336
XU4916 MOAI1S $PINS O=n3987 A1=IxIt[1] A2=n3984 B1=IxIt[1] B2=n3984
XU4917 NR2 $PINS O=n3986 I1=FE_OFN521_n4337 I2=FE_DBTN55_It_4_0
XU4918 MOAI1S $PINS O=n1185 A1=FE_OFN1034_FE_DBTN11_n4099 A2=n3985
+ B1=FE_OFN811_n3993 B2=n3983
XU4919 NR2 $PINS O=intadd_20/A[0] I1=n3985 I2=n3984
XU4920 ND2S $PINS O=n3991 I1=It[4][2] I2=FE_OFN4138_n4336
XU4921 MOAI1S $PINS O=intadd_20/B[0] A1=IxIt[2] A2=n3991 B1=IxIt[2] B2=n3991
XU4922 NR2 $PINS O=intadd_20/CI I1=FE_OFN521_n4337 I2=FE_DBTN56_It_4_1
XU4923 FA1S $PINS S=n3983 CO=n3994 A=n3988 B=n3987 CI=n3986
XU4924 NR2 $PINS O=n3995 I1=FE_OFN442_intadd_21_SUM_1 I2=FE_DBTN55_It_4_0
XU4925 MOAI1S $PINS O=n3989 A1=n3995 A2=intadd_20/SUM[0] B1=n3995
+ B2=intadd_20/SUM[0]
XU4926 MOAI1S $PINS O=n3990 A1=n3994 A2=n3989 B1=n3994 B2=n3989
XU4927 MOAI1S $PINS O=n1184 A1=FE_OFN1034_FE_DBTN11_n4099 A2=FE_OFN1712_IxIt_2
+ B1=FE_OFN811_n3993 B2=n3990
XU4928 NR2 $PINS O=intadd_26/A[0] I1=FE_OFN1712_IxIt_2 I2=n3991
XU4929 ND2S $PINS O=n3998 I1=It[4][3] I2=FE_OFN4138_n4336
XU4930 NR2 $PINS O=intadd_26/CI I1=FE_OFN4153_n4337
+ I2=FE_OFN332_FE_DBTN57_It_4_2
XU4931 NR2 $PINS O=intadd_20/B[1] I1=FE_OFN442_intadd_21_SUM_1
+ I2=FE_OFN333_FE_DBTN56_It_4_1
XU4934 MAO222 $PINS O=n4000 A1=n3995 B1=intadd_20/SUM[0] C1=n3994
XU4935 NR2 $PINS O=n4001 I1=FE_OFN1746_FE_DBTN13_n4339 I2=FE_DBTN55_It_4_0
XU4936 MOAI1S $PINS O=n3996 A1=n4001 A2=intadd_20/SUM[1] B1=n4001
+ B2=intadd_20/SUM[1]
XU4937 MOAI1S $PINS O=n3997 A1=n4000 A2=n3996 B1=n4000 B2=n3996
XU4938 MOAI1S $PINS O=n1183 A1=FE_OFN1034_FE_DBTN11_n4099 A2=n1353
+ B1=FE_OFN811_n3993 B2=n3997
XU4939 NR2 $PINS O=intadd_19/A[0] I1=n1353 I2=n3998
XU4940 ND2S $PINS O=n4004 I1=It[4][4] I2=FE_OFN4138_n4336
XU4941 MOAI1S $PINS O=intadd_19/B[0] A1=IxIt[4] A2=n4004 B1=IxIt[4] B2=n4004
XU4942 NR2 $PINS O=intadd_19/CI I1=FE_OFN4153_n4337
+ I2=FE_OFN331_FE_DBTN58_It_4_3
XU4943 NR2 $PINS O=intadd_26/B[1] I1=FE_OFN441_intadd_21_SUM_1
+ I2=FE_OFN332_FE_DBTN57_It_4_2
XU4944 NR2 $PINS O=intadd_20/B[2] I1=FE_OFN1746_FE_DBTN13_n4339
+ I2=FE_OFN333_FE_DBTN56_It_4_1
XU4945 MAO222 $PINS O=n4006 A1=n4001 B1=intadd_20/SUM[1] C1=n4000
XU4946 NR2 $PINS O=n4007 I1=FE_OFN439_intadd_21_SUM_3
+ I2=FE_OFN334_FE_DBTN55_It_4_0
XU4947 MOAI1S $PINS O=n4002 A1=n4007 A2=intadd_20/SUM[2] B1=n4007
+ B2=intadd_20/SUM[2]
XU4948 MOAI1S $PINS O=n4003 A1=n4006 A2=n4002 B1=n4006 B2=n4002
XU4949 MOAI1S $PINS O=n1182 A1=FE_OFN1034_FE_DBTN11_n4099 A2=n4005
+ B1=FE_OFN811_n3993 B2=n4003
XU4950 NR2 $PINS O=intadd_18/A[0] I1=n4005 I2=n4004
XU4951 ND2S $PINS O=n4010 I1=It[4][5] I2=FE_OFN4138_n4336
XU4952 NR2 $PINS O=intadd_19/B[1] I1=FE_OFN441_intadd_21_SUM_1
+ I2=FE_OFN331_FE_DBTN58_It_4_3
XU4953 NR2 $PINS O=intadd_26/B[2] I1=FE_OFN1746_FE_DBTN13_n4339
+ I2=FE_OFN332_FE_DBTN57_It_4_2
XU4954 NR2 $PINS O=intadd_20/B[3] I1=FE_OFN439_intadd_21_SUM_3
+ I2=FE_OFN333_FE_DBTN56_It_4_1
XU4955 MAO222 $PINS O=n4012 A1=n4007 B1=intadd_20/SUM[2] C1=n4006
XU4956 NR2 $PINS O=n4013 I1=FE_OFN436_intadd_21_SUM_4
+ I2=FE_OFN334_FE_DBTN55_It_4_0
XU4957 MOAI1S $PINS O=n4008 A1=n4013 A2=intadd_20/SUM[3] B1=n4013
+ B2=intadd_20/SUM[3]
XU4958 MOAI1S $PINS O=n4009 A1=n4012 A2=n4008 B1=n4012 B2=n4008
XU4959 MOAI1S $PINS O=n1181 A1=FE_OFN1034_FE_DBTN11_n4099 A2=n4011
+ B1=FE_OFN811_n3993 B2=n4009
XU4960 NR2 $PINS O=intadd_20/A[4] I1=FE_OFN430_intadd_21_SUM_5
+ I2=FE_OFN334_FE_DBTN55_It_4_0
XU4961 NR2 $PINS O=intadd_20/B[4] I1=FE_OFN436_intadd_21_SUM_4
+ I2=FE_OFN333_FE_DBTN56_It_4_1
XU4962 NR2 $PINS O=intadd_17/A[0] I1=n4011 I2=n4010
XU4963 ND2 $PINS O=n4017 I1=It[4][6] I2=FE_OFN4138_n4336
XU4964 MOAI1 $PINS O=intadd_17/B[0] A1=IxIt[6] A2=n4017 B1=IxIt[6] B2=n4017
XU4965 NR2 $PINS O=intadd_17/CI I1=FE_OFN4153_n4337
+ I2=FE_OFN329_FE_DBTN60_It_4_5
XU4966 NR2 $PINS O=intadd_18/B[1] I1=FE_OFN441_intadd_21_SUM_1
+ I2=FE_OFN330_FE_DBTN59_It_4_4
XU4967 NR2 $PINS O=intadd_19/B[2] I1=FE_OFN361_FE_DBTN13_n4339
+ I2=FE_OFN331_FE_DBTN58_It_4_3
XU4968 NR2 $PINS O=intadd_26/B[3] I1=FE_OFN439_intadd_21_SUM_3
+ I2=FE_OFN332_FE_DBTN57_It_4_2
XU4970 MAO222 $PINS O=n4022 A1=n4013 B1=intadd_20/SUM[3] C1=n4012
XU4971 OR2 $PINS O=n4021 I1=intadd_26/SUM[3] I2=intadd_20/SUM[4]
XU4972 ND2S $PINS O=n4014 I1=intadd_20/SUM[4] I2=intadd_26/SUM[3]
XU4973 MOAI1S $PINS O=n4016 A1=n4022 A2=n4015 B1=n4022 B2=n4015
XU4974 MOAI1S $PINS O=n1180 A1=FE_OFN1035_FE_DBTN11_n4099 A2=FE_PHN3263_n1350
+ B1=FE_OFN811_n3993 B2=n4016
XU4975 NR2 $PINS O=intadd_16/A[0] I1=n1350 I2=n4017
XU4976 ND2S $PINS O=n4027 I1=FE_OFN4274_It_4__7 I2=FE_OFN4136_n4336
XU4977 NR2 $PINS O=intadd_16/CI I1=FE_OFN4153_n4337
+ I2=FE_OFN327_FE_DBTN61_It_4_6
XU4978 NR2 $PINS O=intadd_17/B[1] I1=FE_OFN441_intadd_21_SUM_1
+ I2=FE_OFN329_FE_DBTN60_It_4_5
XU4979 NR2 $PINS O=intadd_18/B[2] I1=FE_OFN361_FE_DBTN13_n4339
+ I2=FE_OFN330_FE_DBTN59_It_4_4
XU4980 NR2 $PINS O=intadd_19/B[3] I1=FE_OFN440_intadd_21_SUM_3
+ I2=FE_OFN331_FE_DBTN58_It_4_3
XU4981 NR2 $PINS O=intadd_20/B[5] I1=FE_OFN425_intadd_21_SUM_6
+ I2=FE_OFN334_FE_DBTN55_It_4_0
XU4982 NR2 $PINS O=intadd_26/A[4] I1=n3964 I2=FE_OFN333_FE_DBTN56_It_4_1
XU4983 NR2 $PINS O=intadd_26/B[4] I1=FE_OFN436_intadd_21_SUM_4
+ I2=FE_OFN332_FE_DBTN57_It_4_2
XU4984 AOI22S $PINS O=n4031 A1=intadd_26/SUM[3] A2=intadd_20/SUM[4] B1=n4022
+ B2=n4021
XU4985 NR2 $PINS O=n4030 I1=intadd_20/SUM[5] I2=intadd_26/SUM[4]
XU4986 ND2S $PINS O=n4023 I1=intadd_20/SUM[5] I2=intadd_26/SUM[4]
XU4987 OR2B1S $PINS O=n4024 I1=n4030 B1=n4023
XU4988 MOAI1S $PINS O=n4025 A1=n4031 A2=n4024 B1=n4031 B2=n4024
XU4990 OAI22S $PINS O=n1179 A1=FE_OFN463_n1703 A2=n4025
+ B1=FE_OFN1035_FE_DBTN11_n4099 B2=FE_PHN3236_n1347
XU4991 NR2 $PINS O=intadd_19/A[4] I1=n3964 I2=FE_DBTN57_It_4_2
XU4992 NR2 $PINS O=intadd_19/B[4] I1=FE_OFN436_intadd_21_SUM_4
+ I2=FE_OFN331_FE_DBTN58_It_4_3
XU4993 NR2 $PINS O=intadd_15/A[0] I1=n1347 I2=n4027
XU4994 NR2 $PINS O=intadd_15/CI I1=FE_OFN521_n4337 I2=n4080
XU4995 NR2 $PINS O=intadd_16/B[1] I1=FE_OFN441_intadd_21_SUM_1
+ I2=FE_OFN327_FE_DBTN61_It_4_6
XU4996 NR2 $PINS O=intadd_17/B[2] I1=FE_OFN361_FE_DBTN13_n4339
+ I2=FE_OFN329_FE_DBTN60_It_4_5
XU4997 NR2 $PINS O=intadd_18/B[3] I1=FE_OFN440_intadd_21_SUM_3
+ I2=FE_OFN330_FE_DBTN59_It_4_4
XU4998 INV1S $PINS O=n4038 I=intadd_18/SUM[3]
XU4999 NR2 $PINS O=n4037 I1=n1495 I2=FE_OFN334_FE_DBTN55_It_4_0
XU5000 MOAI1S $PINS O=n4032 A1=intadd_20/SUM[6] A2=n4040 B1=intadd_20/SUM[6]
+ B2=n4040
XU5001 MOAI1 $PINS O=n4039 A1=n4031 A2=n4030 B1=intadd_26/SUM[4]
+ B2=intadd_20/SUM[5]
XU5002 MOAI1S $PINS O=n4033 A1=n4032 A2=n4039 B1=n4032 B2=n4039
XU5003 MOAI1S $PINS O=n1178 A1=FE_OFN463_n1703 A2=n4033 B1=n4099
+ B2=FE_OFN556_IxIt_8
XU5004 NR2 $PINS O=intadd_31/A[0] I1=FE_OFN521_n4337 I2=FE_DBTN62_It_4_8
XU5005 ND2S $PINS O=intadd_31/CI I1=FE_OFN4274_It_4__7
+ I2=FE_DBTN45_intadd_21_SUM_1
XU5006 INV1S $PINS O=intadd_15/A[1] I=intadd_31/SUM[0]
XU5007 NR2 $PINS O=intadd_15/B[1] I1=FE_DBTN13_n4339
+ I2=FE_OFN327_FE_DBTN61_It_4_6
XU5008 NR2 $PINS O=intadd_16/B[2] I1=FE_OFN440_intadd_21_SUM_3
+ I2=FE_OFN329_FE_DBTN60_It_4_5
XU5009 NR2 $PINS O=intadd_17/B[3] I1=FE_OFN434_intadd_21_SUM_4
+ I2=FE_OFN330_FE_DBTN59_It_4_4
XU5010 NR2 $PINS O=intadd_18/A[4] I1=FE_OFN425_intadd_21_SUM_6
+ I2=FE_DBTN57_It_4_2
XU5011 NR2 $PINS O=intadd_18/B[4] I1=n3964 I2=FE_DBTN58_It_4_3
XU5012 INV1S $PINS O=n4051 I=intadd_19/SUM[5]
XU5013 INV1S $PINS O=n4050 I=intadd_18/SUM[4]
XU5014 NR2 $PINS O=n4041 I1=n4039 I2=intadd_20/SUM[6]
XU5015 MOAI1 $PINS O=n4052 A1=n4041 A2=n4040 B1=n4039 B2=intadd_20/SUM[6]
XU5016 MOAI1S $PINS O=n4042 A1=n4053 A2=n4052 B1=n4053 B2=n4052
XU5017 MOAI1S $PINS O=n4044 A1=intadd_20/n1 A2=n4042 B1=intadd_20/n1 B2=n4042
XU5018 MOAI1S $PINS O=n1177 A1=FE_OFN463_n1703 A2=n4044 B1=n4099
+ B2=FE_OFN555_IxIt_9
XU5019 NR2 $PINS O=intadd_16/A[3] I1=n3964 I2=FE_DBTN59_It_4_4
XU5020 NR2 $PINS O=intadd_16/B[3] I1=FE_OFN436_intadd_21_SUM_4
+ I2=FE_OFN329_FE_DBTN60_It_4_5
XU5021 NR2 $PINS O=intadd_25/B[0] I1=FE_OFN442_intadd_21_SUM_1
+ I2=FE_DBTN62_It_4_8
XU5022 ND2S $PINS O=intadd_31/B[1] I1=FE_OFN4274_It_4__7 I2=n4339
XU5023 INV1S $PINS O=intadd_15/A[2] I=intadd_31/SUM[1]
XU5024 NR2 $PINS O=intadd_15/B[2] I1=FE_OFN440_intadd_21_SUM_3
+ I2=FE_OFN327_FE_DBTN61_It_4_6
XU5025 NR2 $PINS O=intadd_17/B[4] I1=FE_OFN425_intadd_21_SUM_6
+ I2=FE_DBTN58_It_4_3
XU5026 FA1S $PINS S=n4053 CO=n4059 A=n4051 B=n4050 CI=n4049
XU5027 NR2 $PINS O=n4054 I1=n4052 I2=intadd_20/n1
XU5028 MOAI1 $PINS O=n4061 A1=n4054 A2=n4053 B1=n4052 B2=intadd_20/n1
XU5029 MOAI1S $PINS O=n4055 A1=n4061 A2=intadd_19/SUM[6] B1=intadd_19/SUM[6]
+ B2=n4061
XU5030 MOAI1S $PINS O=n4056 A1=n4059 A2=n4055 B1=n4059 B2=n4055
XU5031 OAI22S $PINS O=n1176 A1=FE_OFN463_n1703 A2=n4056
+ B1=FE_OFN1035_FE_DBTN11_n4099 B2=intadd_25/A[0]
XU5032 NR2 $PINS O=intadd_25/B[1] I1=FE_OFN360_FE_DBTN13_n4339
+ I2=FE_OFN325_FE_DBTN62_It_4_8
XU5033 OR2 $PINS O=intadd_31/B[2] I1=n4080 I2=FE_OFN440_intadd_21_SUM_3
XU5034 INV1S $PINS O=intadd_15/A[3] I=intadd_31/SUM[2]
XU5035 NR2 $PINS O=intadd_15/B[3] I1=FE_OFN434_intadd_21_SUM_4
+ I2=FE_OFN328_FE_DBTN61_It_4_6
XU5036 NR2 $PINS O=intadd_16/A[4] I1=FE_OFN425_intadd_21_SUM_6
+ I2=FE_DBTN59_It_4_4
XU5037 NR2 $PINS O=intadd_16/B[4] I1=n3964 I2=FE_DBTN60_It_4_5
XU5038 INV1S $PINS O=n4060 I=n4059
XU5039 MAO222 $PINS O=n4066 A1=n4061 B1=intadd_19/SUM[6] C1=n4060
XU5040 MOAI1S $PINS O=n4062 A1=intadd_18/SUM[6] A2=n4066 B1=intadd_18/SUM[6]
+ B2=n4066
XU5041 MOAI1S $PINS O=n4063 A1=intadd_19/n1 A2=n4062 B1=intadd_19/n1 B2=n4062
XU5042 MOAI1S $PINS O=n1175 A1=FE_OFN1035_FE_DBTN11_n4099 A2=intadd_25/A[1]
+ B1=FE_OFN810_n3993 B2=n4063
XU5043 NR2 $PINS O=intadd_16/B[5] I1=FE_OFN425_intadd_21_SUM_6
+ I2=FE_DBTN60_It_4_5
XU5044 NR2 $PINS O=intadd_25/B[2] I1=FE_OFN437_intadd_21_SUM_3
+ I2=FE_OFN325_FE_DBTN62_It_4_8
XU5045 INV1S $PINS O=intadd_15/A[4] I=intadd_31/SUM[3]
XU5046 NR2 $PINS O=intadd_15/B[4] I1=FE_OFN432_intadd_21_SUM_5
+ I2=FE_OFN328_FE_DBTN61_It_4_6
XU5047 MAO222 $PINS O=n4070 A1=n4066 B1=intadd_19/n1 C1=intadd_18/SUM[6]
XU5048 MOAI1S $PINS O=n4067 A1=intadd_17/SUM[6] A2=n4070 B1=intadd_17/SUM[6]
+ B2=n4070
XU5049 MOAI1S $PINS O=n4068 A1=intadd_18/n1 A2=n4067 B1=intadd_18/n1 B2=n4067
XU5050 MOAI1S $PINS O=n1174 A1=FE_OFN1035_FE_DBTN11_n4099 A2=intadd_25/A[2]
+ B1=FE_OFN810_n3993 B2=n4068
XU5051 NR2 $PINS O=intadd_15/B[5] I1=FE_OFN428_intadd_21_SUM_6
+ I2=FE_OFN328_FE_DBTN61_It_4_6
XU5052 NR2 $PINS O=intadd_25/B[3] I1=FE_OFN434_intadd_21_SUM_4
+ I2=FE_OFN325_FE_DBTN62_It_4_8
XU5053 INV1S $PINS O=intadd_16/B[6] I=intadd_31/SUM[4]
XU5054 MAO222 $PINS O=n4075 A1=n4070 B1=intadd_18/n1 C1=intadd_17/SUM[6]
XU5055 MOAI1S $PINS O=n4071 A1=intadd_16/SUM[6] A2=n4075 B1=intadd_16/SUM[6]
+ B2=n4075
XU5056 MOAI1S $PINS O=n4072 A1=intadd_17/n1 A2=n4071 B1=intadd_17/n1 B2=n4071
XU5057 MOAI1S $PINS O=n1173 A1=FE_OFN1035_FE_DBTN11_n4099 A2=intadd_25/A[3]
+ B1=FE_OFN810_n3993 B2=n4072
XU5058 NR2 $PINS O=intadd_25/B[4] I1=FE_OFN429_intadd_21_SUM_5
+ I2=FE_OFN325_FE_DBTN62_It_4_8
XU5059 NR2 $PINS O=n4081 I1=FE_OFN748_n1495 I2=FE_OFN328_FE_DBTN61_It_4_6
XU5060 INV1S $PINS O=intadd_15/A[6] I=n4074
XU5061 INV1S $PINS O=intadd_15/B[6] I=intadd_31/n1
XU5062 MAO222 $PINS O=n4083 A1=n4075 B1=intadd_17/n1 C1=intadd_16/SUM[6]
XU5063 MOAI1S $PINS O=n4076 A1=intadd_15/SUM[6] A2=n4083 B1=intadd_15/SUM[6]
+ B2=n4083
XU5064 MOAI1S $PINS O=n4077 A1=intadd_16/n1 A2=n4076 B1=intadd_16/n1 B2=n4076
XU5065 MOAI1S $PINS O=n1172 A1=FE_OFN1033_FE_DBTN11_n4099 A2=intadd_25/A[4]
+ B1=FE_OFN810_n3993 B2=n4077
XU5066 NR2 $PINS O=intadd_36/B[0] I1=FE_OFN428_intadd_21_SUM_6
+ I2=FE_OFN325_FE_DBTN62_It_4_8
XU5067 NR2 $PINS O=intadd_36/CI I1=FE_OFN748_n1495 I2=n4080
XU5068 FA1S $PINS S=n4074 CO=intadd_25/B[5] A=n4082 B=n4081 CI=intadd_25/SUM[4]
XU5069 MAO222P $PINS O=n4087 A1=n4083 B1=intadd_16/n1 C1=intadd_15/SUM[6]
XU5070 MOAI1S $PINS O=n4084 A1=intadd_25/SUM[5] A2=n4087 B1=intadd_25/SUM[5]
+ B2=n4087
XU5071 MOAI1S $PINS O=n4085 A1=intadd_15/n1 A2=n4084 B1=intadd_15/n1 B2=n4084
XU5072 OAI22S $PINS O=n1171 A1=FE_OFN463_n1703 A2=n4085
+ B1=FE_OFN1033_FE_DBTN11_n4099 B2=intadd_36/A[0]
XU5073 ND2S $PINS O=n4086 I1=intadd_15/n1 I2=n4087
XU5074 MOAI1S $PINS O=n4089 A1=intadd_25/n1 A2=n4088 B1=intadd_25/n1 B2=n4088
XU5075 OAI22S $PINS O=n1170 A1=FE_OFN461_n1703 A2=n4089
+ B1=FE_OFN1033_FE_DBTN11_n4099 B2=intadd_36/A[1]
XU5076 MAO222 $PINS O=intadd_36/B[2] A1=intadd_36/SUM[1] B1=n4090
+ C1=intadd_25/n1
XU5077 NR2 $PINS O=n4093 I1=n4092 I2=n4091
XU5078 MOAI1S $PINS O=n4094 A1=FE_OFN4277_IxIt_18 A2=n4093
+ B1=FE_OFN4277_IxIt_18 B2=n4093
XU5079 OAI22S $PINS O=n1167 A1=FE_OFN459_n1703 A2=n4094
+ B1=FE_OFN1032_FE_DBTN11_n4099 B2=n4095
XU5081 MOAI1 $PINS O=n4100 A1=IxIt[20] A2=n4097 B1=IxIt[20] B2=n4097
XU5082 OAI22S $PINS O=n1166 A1=FE_OFN456_n1703 A2=n4100
+ B1=FE_OFN1032_FE_DBTN11_n4099 B2=n4098
XU5083 NR2 $PINS O=intadd_0/A[0] I1=FE_OFN948_n4268 I2=n4102
XU5084 NR2 $PINS O=n4105 I1=FE_OFN414_intadd_14_SUM_1
+ I2=FE_OFN420_intadd_14_SUM_0
XU5085 MOAI1S $PINS O=intadd_0/B[0] A1=n4105 A2=n4104 B1=n4105 B2=n4104
XU5086 NR2 $PINS O=intadd_0/CI I1=FE_OFN1751_n4113 I2=FE_OFN404_intadd_14_SUM_3
XU5087 NR2 $PINS O=intadd_0/B[1] I1=FE_OFN399_intadd_14_SUM_4
+ I2=FE_OFN1751_n4113
XU5088 NR2 $PINS O=intadd_33/A[0] I1=FE_OFN412_intadd_14_SUM_2 I2=n4106
XU5089 NR2 $PINS O=intadd_33/CI I1=FE_OFN399_intadd_14_SUM_4
+ I2=FE_OFN417_intadd_14_SUM_0
XU5090 NR2 $PINS O=intadd_0/B[2] I1=FE_OFN396_intadd_14_SUM_5
+ I2=FE_OFN1751_n4113
XU5092 MOAI1S $PINS O=n4111 A1=FE_OFN412_intadd_14_SUM_2
+ A2=FE_OFN4139_intadd_14_SUM_1 B1=FE_OFN405_intadd_14_SUM_3 B2=n4107
XU5093 NR2 $PINS O=intadd_33/A[1] I1=n4112 I2=n4111
XU5094 NR2 $PINS O=intadd_33/B[1] I1=FE_OFN396_intadd_14_SUM_5
+ I2=FE_OFN417_intadd_14_SUM_0
XU5095 NR2 $PINS O=intadd_0/B[3] I1=intadd_14/SUM[6] I2=FE_OFN1751_n4113
XU5096 NR2 $PINS O=intadd_33/B[2] I1=intadd_14/SUM[6]
+ I2=FE_OFN417_intadd_14_SUM_0
XU5097 MOAI1S $PINS O=intadd_0/B[4] A1=n4118 A2=n4117 B1=n4118 B2=n4117
XU5098 NR2 $PINS O=n4125 I1=FE_OFN396_intadd_14_SUM_5
+ I2=FE_OFN4121_intadd_14_SUM_2
XU5099 MOAI1S $PINS O=n4124 A1=FE_OFN399_intadd_14_SUM_4 A2=n4121 B1=n4120
+ B2=FE_OFN4120_intadd_14_SUM_2
XU5100 NR2 $PINS O=n4123 I1=intadd_14/SUM[6] I2=FE_OFN413_intadd_14_SUM_1
XU5101 FA1S $PINS S=intadd_0/A[5] CO=n4130 A=n4125 B=n4124 CI=n4123
XU5102 NR2 $PINS O=n4133 I1=FE_OFN392_intadd_14_SUM_6
+ I2=FE_OFN4121_intadd_14_SUM_2
XU5103 NR2 $PINS O=n4132 I1=FE_OFN396_intadd_14_SUM_5
+ I2=FE_OFN405_intadd_14_SUM_3
XU5104 OAI22S $PINS O=n4131 A1=FE_OFN4121_intadd_14_SUM_2
+ A2=FE_OFN399_intadd_14_SUM_4 B1=FE_OFN405_intadd_14_SUM_3
+ B2=FE_OFN1692_intadd_14_SUM_4
XU5105 FA1S $PINS S=intadd_0/B[6] CO=intadd_0/A[7] A=n4130 B=n4129 CI=n4128
XU5106 FA1S $PINS S=n4129 CO=n4139 A=n4133 B=n4132 CI=n4131
XU5107 NR2 $PINS O=n4136 I1=FE_OFN392_intadd_14_SUM_6
+ I2=FE_OFN1648_intadd_14_SUM_3
XU5108 OAI12HS $PINS O=n4142 A1=n4212 B1=n4136 B2=FE_OFN1690_intadd_14_SUM_4
XU5109 OA222 $PINS O=n4137 A1=n4136 A2=n4142 B1=n4136 B2=n4212 C1=n4142
+ C2=FE_OFN1690_intadd_14_SUM_4
XU5110 FA1S $PINS S=intadd_0/B[7] CO=intadd_0/A[8] A=n4139 B=n4138 CI=n4137
XU5111 NR2 $PINS O=n4143 I1=FE_OFN1648_intadd_14_SUM_3 I2=n1439
XU5112 INV1S $PINS O=intadd_0/B[8] I=n4141
XU5113 FA1S $PINS S=n4141 CO=n4145 A=n4144 B=n4143 CI=n4142
XU5114 INV1S $PINS O=intadd_0/A[9] I=n4145
XU5115 NR2 $PINS O=n4147 I1=FE_OFN1692_intadd_14_SUM_4 I2=n1439
XU5116 OAI222S $PINS O=intadd_0/B[9] A1=n4147 A2=FE_OFN397_intadd_14_SUM_5
+ B1=n4147 B2=n4146 C1=n4146 C2=FE_OFN392_intadd_14_SUM_6
XU5117 ND2S $PINS O=n4149 I1=n4148 I2=IxIy[0]
XU5118 OAI22S $PINS O=FE_PHN3295_n1140 A1=FE_OFN517_n4245 A2=n4149 B1=n4148
+ B2=IxIy[0]
XU5120 INV1S $PINS O=n4156 I=IxIy[1]
XU5121 FA1S $PINS S=n4154 CO=n4159 A=n4153 B=n4152 CI=n4151
XU5122 MOAI1S $PINS O=n1139 A1=FE_OFN1050_FE_DBTN0_n4229 A2=n4156
+ B1=FE_OFN816_n4217 B2=n4154
XU5123 NR2 $PINS O=intadd_13/A[0] I1=n4156 I2=n4155
XU5124 ND2S $PINS O=n4161 I1=Ix[0][2] I2=FE_OFN949_n4268
XU5125 MOAI1S $PINS O=intadd_13/B[0] A1=IxIy[2] A2=n4161 B1=IxIy[2] B2=n4161
XU5126 NR2 $PINS O=intadd_13/CI I1=FE_OFN419_intadd_14_SUM_0
+ I2=FE_OFN341_FE_DBTN48_Ix_0_1
XU5127 MOAI1S $PINS O=n4158 A1=n4157 A2=intadd_13/SUM[0] B1=n4157
+ B2=intadd_13/SUM[0]
XU5128 MOAI1S $PINS O=n4160 A1=n4159 A2=n4158 B1=n4159 B2=n4158
XU5129 MOAI1S $PINS O=n1138 A1=FE_OFN1050_FE_DBTN0_n4229 A2=n4162
+ B1=FE_OFN816_n4217 B2=n4160
XU5130 NR2 $PINS O=intadd_27/A[0] I1=n4162 I2=n4161
XU5131 ND2S $PINS O=n4168 I1=Ix[0][3] I2=FE_OFN1747_n4113
XU5132 MOAI1S $PINS O=intadd_27/B[0] A1=IxIy[3] A2=n4168 B1=IxIy[3] B2=n4168
XU5133 NR2 $PINS O=intadd_27/CI I1=FE_OFN419_intadd_14_SUM_0
+ I2=FE_DBTN49_Ix_0_2
XU5134 NR2 $PINS O=intadd_13/B[1] I1=FE_OFN413_intadd_14_SUM_1
+ I2=FE_OFN341_FE_DBTN48_Ix_0_1
XU5136 MOAI1S $PINS O=n4164 A1=n4163 A2=intadd_13/SUM[1] B1=n4163
+ B2=intadd_13/SUM[1]
XU5137 MOAI1S $PINS O=n4166 A1=n4165 A2=n4164 B1=n4165 B2=n4164
XU5138 MOAI1S $PINS O=n1137 A1=FE_OFN1050_FE_DBTN0_n4229 A2=FE_PHN3233_n1332
+ B1=n4217 B2=n4166
XU5139 NR2 $PINS O=intadd_12/A[0] I1=n1332 I2=n4168
XU5140 ND2S $PINS O=n4170 I1=Ix[0][4] I2=FE_OFN1747_n4113
XU5141 MOAI1S $PINS O=intadd_12/B[0] A1=IxIy[4] A2=n4170 B1=IxIy[4] B2=n4170
XU5142 NR2 $PINS O=intadd_12/CI I1=FE_OFN419_intadd_14_SUM_0
+ I2=FE_DBTN50_Ix_0_3
XU5143 NR2 $PINS O=intadd_27/B[1] I1=FE_OFN415_intadd_14_SUM_1
+ I2=FE_OFN340_FE_DBTN49_Ix_0_2
XU5144 NR2 $PINS O=intadd_13/B[2] I1=FE_OFN407_intadd_14_SUM_2
+ I2=FE_OFN341_FE_DBTN48_Ix_0_1
XU5145 NR2 $PINS O=intadd_11/A[0] I1=n4171 I2=n4170
XU5147 NR2 $PINS O=intadd_11/CI I1=FE_OFN419_intadd_14_SUM_0
+ I2=FE_DBTN51_Ix_0_4
XU5148 NR2 $PINS O=intadd_12/B[1] I1=FE_OFN415_intadd_14_SUM_1
+ I2=FE_OFN339_FE_DBTN50_Ix_0_3
XU5149 NR2 $PINS O=intadd_27/B[2] I1=FE_OFN407_intadd_14_SUM_2
+ I2=FE_OFN340_FE_DBTN49_Ix_0_2
XU5150 NR2 $PINS O=intadd_13/B[3] I1=FE_OFN406_intadd_14_SUM_3
+ I2=FE_OFN341_FE_DBTN48_Ix_0_1
XU5151 MOAI1S $PINS O=n4173 A1=n4172 A2=intadd_13/SUM[3] B1=n4172
+ B2=intadd_13/SUM[3]
XU5152 MOAI1S $PINS O=n4175 A1=n4174 A2=n4173 B1=n4174 B2=n4173
XU5153 MOAI1S $PINS O=n1135 A1=FE_DBTN0_n4229 A2=FE_OFN587_IxIy_5 B1=n4217
+ B2=n4175
XU5154 NR2 $PINS O=intadd_13/A[4] I1=FE_OFN4158_intadd_14_SUM_5
+ I2=FE_OFN342_FE_DBTN47_Ix_0_0
XU5155 NR2 $PINS O=intadd_13/B[4] I1=FE_OFN1691_intadd_14_SUM_4
+ I2=FE_OFN341_FE_DBTN48_Ix_0_1
XU5156 NR2 $PINS O=intadd_10/A[0] I1=FE_OFN587_IxIy_5 I2=n4179
XU5157 ND2S $PINS O=n4187 I1=Ix[0][6] I2=FE_OFN949_n4268
XU5159 NR2 $PINS O=intadd_10/CI I1=FE_OFN419_intadd_14_SUM_0
+ I2=FE_DBTN52_Ix_0_5
XU5160 NR2 $PINS O=intadd_11/B[1] I1=FE_OFN415_intadd_14_SUM_1
+ I2=FE_OFN338_FE_DBTN51_Ix_0_4
XU5161 NR2 $PINS O=intadd_12/B[2] I1=FE_OFN407_intadd_14_SUM_2
+ I2=FE_OFN339_FE_DBTN50_Ix_0_3
XU5162 NR2 $PINS O=intadd_27/B[3] I1=FE_OFN1649_intadd_14_SUM_3
+ I2=FE_OFN340_FE_DBTN49_Ix_0_2
XU5163 ND2S $PINS O=n4181 I1=intadd_13/SUM[4] I2=intadd_27/SUM[3]
XU5164 MOAI1S $PINS O=n4185 A1=n4184 A2=n4183 B1=n4184 B2=n4183
XU5165 MOAI1S $PINS O=n1134 A1=FE_DBTN0_n4229 A2=n4188 B1=n4217 B2=n4185
XU5166 NR2 $PINS O=intadd_9/A[0] I1=n4188 I2=n4187
XU5167 ND2S $PINS O=n4196 I1=Ix[0][7] I2=FE_OFN1747_n4113
XU5168 NR2 $PINS O=intadd_9/CI I1=FE_OFN419_intadd_14_SUM_0 I2=FE_DBTN53_Ix_0_6
XU5169 NR2 $PINS O=intadd_10/B[1] I1=FE_OFN415_intadd_14_SUM_1
+ I2=FE_OFN337_FE_DBTN52_Ix_0_5
XU5170 NR2 $PINS O=intadd_11/B[2] I1=FE_OFN407_intadd_14_SUM_2
+ I2=FE_OFN338_FE_DBTN51_Ix_0_4
XU5171 NR2 $PINS O=intadd_12/B[3] I1=FE_OFN1649_intadd_14_SUM_3
+ I2=FE_OFN339_FE_DBTN50_Ix_0_3
XU5172 NR2 $PINS O=intadd_13/B[5] I1=n4297 I2=FE_OFN342_FE_DBTN47_Ix_0_0
XU5173 NR2 $PINS O=intadd_27/A[4] I1=FE_OFN4158_intadd_14_SUM_5
+ I2=FE_OFN341_FE_DBTN48_Ix_0_1
XU5174 NR2 $PINS O=intadd_27/B[4] I1=FE_OFN1691_intadd_14_SUM_4
+ I2=FE_OFN340_FE_DBTN49_Ix_0_2
XU5175 ND2S $PINS O=n4191 I1=intadd_13/SUM[5] I2=intadd_27/SUM[4]
XU5176 OR2B1S $PINS O=n4193 I1=n4192 B1=n4191
XU5177 MOAI1S $PINS O=n4195 A1=n4194 A2=n4193 B1=n4194 B2=n4193
XU5179 OAI22S $PINS O=n1133 A1=FE_OFN445_n1693 A2=n4195 B1=FE_DBTN0_n4229
+ B2=n1329
XU5180 NR2 $PINS O=intadd_12/A[4] I1=FE_OFN4158_intadd_14_SUM_5
+ I2=FE_OFN340_FE_DBTN49_Ix_0_2
XU5181 NR2 $PINS O=intadd_12/B[4] I1=FE_OFN1691_intadd_14_SUM_4
+ I2=FE_OFN339_FE_DBTN50_Ix_0_3
XU5182 NR2 $PINS O=intadd_8/A[0] I1=n1329 I2=n4196
XU5184 NR2 $PINS O=intadd_8/CI I1=FE_OFN417_intadd_14_SUM_0 I2=n1296
XU5185 NR2 $PINS O=intadd_9/B[1] I1=FE_OFN415_intadd_14_SUM_1
+ I2=FE_DBTN53_Ix_0_6
XU5186 NR2 $PINS O=intadd_10/B[2] I1=FE_OFN4121_intadd_14_SUM_2
+ I2=FE_OFN337_FE_DBTN52_Ix_0_5
XU5187 NR2 $PINS O=intadd_11/B[3] I1=FE_OFN1649_intadd_14_SUM_3
+ I2=FE_OFN338_FE_DBTN51_Ix_0_4
XU5188 MOAI1S $PINS O=n4201 A1=intadd_13/SUM[6] A2=n4199 B1=intadd_13/SUM[6]
+ B2=n4199
XU5189 MOAI1S $PINS O=n4202 A1=n4201 A2=n4200 B1=n4201 B2=n4200
XU5190 MOAI1S $PINS O=n1132 A1=FE_OFN445_n1693 A2=n4202 B1=n4229 B2=IxIy[8]
XU5191 NR2 $PINS O=intadd_30/A[0] I1=FE_OFN417_intadd_14_SUM_0
+ I2=FE_DBTN54_Ix_0_8
XU5192 ND2 $PINS O=intadd_30/CI I1=FE_OFN389_Ix_0__7
+ I2=FE_OFN4139_intadd_14_SUM_1
XU5193 INV1S $PINS O=intadd_8/A[1] I=intadd_30/SUM[0]
XU5194 NR2 $PINS O=intadd_9/B[2] I1=FE_OFN1648_intadd_14_SUM_3
+ I2=FE_OFN337_FE_DBTN52_Ix_0_5
XU5195 NR2 $PINS O=intadd_10/B[3] I1=FE_OFN1692_intadd_14_SUM_4
+ I2=FE_OFN338_FE_DBTN51_Ix_0_4
XU5196 NR2 $PINS O=intadd_11/A[4] I1=n4297 I2=FE_OFN340_FE_DBTN49_Ix_0_2
XU5197 NR2 $PINS O=intadd_11/B[4] I1=FE_OFN4158_intadd_14_SUM_5
+ I2=FE_OFN339_FE_DBTN50_Ix_0_3
XU5198 NR2 $PINS O=intadd_9/A[3] I1=FE_OFN4158_intadd_14_SUM_5
+ I2=FE_OFN338_FE_DBTN51_Ix_0_4
XU5199 NR2 $PINS O=intadd_9/B[3] I1=FE_OFN1692_intadd_14_SUM_4
+ I2=FE_OFN337_FE_DBTN52_Ix_0_5
XU5200 INV1S $PINS O=intadd_24/A[0] I=IxIy[10]
XU5201 NR2 $PINS O=intadd_24/B[0] I1=FE_OFN415_intadd_14_SUM_1
+ I2=FE_OFN335_FE_DBTN54_Ix_0_8
XU5202 INV1S $PINS O=intadd_8/A[2] I=intadd_30/SUM[1]
XU5203 NR2 $PINS O=intadd_8/B[2] I1=FE_OFN1648_intadd_14_SUM_3
+ I2=FE_OFN336_FE_DBTN53_Ix_0_6
XU5204 NR2 $PINS O=intadd_10/B[4] I1=n4297 I2=FE_OFN339_FE_DBTN50_Ix_0_3
XU5205 MOAI1S $PINS O=n4206 A1=intadd_12/SUM[6] A2=n4205 B1=intadd_12/SUM[6]
+ B2=n4205
XU5206 MOAI1S $PINS O=n4208 A1=n4207 A2=n4206 B1=n4207 B2=n4206
XU5207 OAI22S $PINS O=n1130 A1=n1693 A2=n4208 B1=FE_DBTN0_n4229
+ B2=intadd_24/A[0]
XU5208 NR2 $PINS O=intadd_24/B[1] I1=FE_OFN4121_intadd_14_SUM_2
+ I2=FE_OFN335_FE_DBTN54_Ix_0_8
XU5209 INV1S $PINS O=intadd_8/A[3] I=intadd_30/SUM[2]
XU5210 NR2 $PINS O=intadd_8/B[3] I1=FE_OFN1692_intadd_14_SUM_4
+ I2=FE_OFN336_FE_DBTN53_Ix_0_6
XU5211 NR2 $PINS O=intadd_9/A[4] I1=n4297 I2=FE_OFN338_FE_DBTN51_Ix_0_4
XU5212 NR2 $PINS O=intadd_9/B[4] I1=FE_OFN4158_intadd_14_SUM_5
+ I2=FE_OFN337_FE_DBTN52_Ix_0_5
XU5213 MOAI1S $PINS O=n4210 A1=intadd_11/SUM[6] A2=n4209 B1=intadd_11/SUM[6]
+ B2=n4209
XU5214 MOAI1S $PINS O=n4211 A1=intadd_12/n1 A2=n4210 B1=intadd_12/n1 B2=n4210
XU5215 MOAI1S $PINS O=n1129 A1=FE_OFN1049_FE_DBTN0_n4229 A2=intadd_24/A[1]
+ B1=FE_OFN819_n4217 B2=n4211
XU5216 NR2 $PINS O=intadd_9/B[5] I1=n4297 I2=FE_OFN337_FE_DBTN52_Ix_0_5
XU5217 NR2 $PINS O=intadd_24/B[2] I1=FE_OFN1648_intadd_14_SUM_3
+ I2=FE_OFN335_FE_DBTN54_Ix_0_8
XU5218 INV1S $PINS O=intadd_8/A[4] I=intadd_30/SUM[3]
XU5219 NR2 $PINS O=intadd_8/B[4] I1=FE_OFN397_intadd_14_SUM_5
+ I2=FE_OFN336_FE_DBTN53_Ix_0_6
XU5220 NR2 $PINS O=intadd_8/B[5] I1=n4297 I2=FE_OFN336_FE_DBTN53_Ix_0_6
XU5221 NR2 $PINS O=intadd_24/B[3] I1=FE_OFN1692_intadd_14_SUM_4
+ I2=FE_OFN335_FE_DBTN54_Ix_0_8
XU5222 INV1S $PINS O=intadd_9/B[6] I=intadd_30/SUM[4]
XU5223 NR2 $PINS O=intadd_24/B[4] I1=FE_OFN397_intadd_14_SUM_5
+ I2=FE_OFN335_FE_DBTN54_Ix_0_8
XU5224 NR2 $PINS O=n4219 I1=n1439 I2=FE_OFN336_FE_DBTN53_Ix_0_6
XU5225 INV1S $PINS O=intadd_8/A[6] I=n4213
XU5226 INV1S $PINS O=intadd_8/B[6] I=intadd_30/n1
XU5227 MAO222P $PINS O=n4221 A1=n4214 B1=intadd_10/n1 C1=intadd_9/SUM[6]
XU5228 MOAI1S $PINS O=n4215 A1=intadd_8/SUM[6] A2=n4221 B1=intadd_8/SUM[6]
+ B2=n4221
XU5229 MOAI1S $PINS O=n4216 A1=intadd_9/n1 A2=n4215 B1=intadd_9/n1 B2=n4215
XU5230 MOAI1S $PINS O=n1126 A1=FE_OFN1049_FE_DBTN0_n4229 A2=intadd_24/A[4]
+ B1=FE_OFN819_n4217 B2=n4216
XU5231 NR2 $PINS O=intadd_35/B[0] I1=FE_OFN392_intadd_14_SUM_6
+ I2=FE_OFN335_FE_DBTN54_Ix_0_8
XU5232 NR2 $PINS O=intadd_35/CI I1=n1439 I2=n1296
XU5233 FA1S $PINS S=n4213 CO=intadd_24/B[5] A=n4220 B=n4219 CI=intadd_24/SUM[4]
XU5234 MAO222P $PINS O=n4225 A1=intadd_8/SUM[6] B1=intadd_9/n1 C1=n4221
XU5235 MOAI1S $PINS O=n4222 A1=intadd_24/SUM[5] A2=n4225 B1=intadd_24/SUM[5]
+ B2=n4225
XU5236 MOAI1S $PINS O=n4223 A1=intadd_8/n1 A2=n4222 B1=intadd_8/n1 B2=n4222
XU5237 OAI22S $PINS O=n1125 A1=FE_OFN445_n1693 A2=n4223
+ B1=FE_OFN1051_FE_DBTN0_n4229 B2=intadd_35/A[0]
XU5238 ND2 $PINS O=n4224 I1=intadd_8/n1 I2=n4225
XU5239 MOAI1S $PINS O=n4226 A1=intadd_35/SUM[1] A2=n4228 B1=intadd_35/SUM[1]
+ B2=n4228
XU5240 MOAI1S $PINS O=n4227 A1=intadd_24/n1 A2=n4226 B1=intadd_24/n1 B2=n4226
XU5241 OAI22S $PINS O=n1124 A1=FE_OFN445_n1693 A2=n4227
+ B1=FE_OFN1051_FE_DBTN0_n4229 B2=intadd_35/A[1]
XU5242 MAO222 $PINS O=intadd_35/B[2] A1=intadd_35/SUM[1] B1=n4228
+ C1=intadd_24/n1
XU5243 MOAI1S $PINS O=n1123 A1=intadd_35/SUM[2] A2=FE_OFN445_n1693
+ B1=FE_OFN943_n4229 B2=IxIy[17]
XU5244 NR2 $PINS O=n4233 I1=n4232 I2=n4231
XU5245 MOAI1S $PINS O=n4235 A1=FE_OFN581_IxIy_18 A2=n4233 B1=FE_OFN581_IxIy_18
+ B2=n4233
XU5246 OAI22S $PINS O=n1121 A1=FE_OFN447_n1693 A2=n4235
+ B1=FE_OFN1053_FE_DBTN0_n4229 B2=n4234
XU5247 ND2S $PINS O=n4238 I1=n4237 I2=n4236
XU5249 OAI22H $PINS O=n1119 A1=FE_OFN449_n1693 A2=n4240
+ B1=FE_OFN1053_FE_DBTN0_n4229 B2=n1320
XU5250 ND2S $PINS O=n4244 I1=n4243 I2=IyIt[0]
XU5251 OAI22S $PINS O=n1117 A1=FE_OFN517_n4245 A2=n4244 B1=n4243 B2=IyIt[0]
XU5252 NR2 $PINS O=intadd_7/A[0] I1=n4247 I2=n4246
XU5253 ND2S $PINS O=n4255 I1=It[0][2] I2=FE_OFN951_n4268
XU5254 MOAI1S $PINS O=intadd_7/B[0] A1=IyIt[2] A2=n4255 B1=IyIt[2] B2=n4255
XU5255 NR2 $PINS O=intadd_7/CI I1=FE_OFN418_intadd_14_SUM_0
+ I2=FE_OFN323_FE_DBTN64_It_0_1
XU5256 MOAI1S $PINS O=n4250 A1=n4249 A2=intadd_7/SUM[0] B1=n4249
+ B2=intadd_7/SUM[0]
XU5257 MOAI1S $PINS O=n4252 A1=n4251 A2=n4250 B1=n4251 B2=n4250
XU5258 MOAI1S $PINS O=n1115 A1=FE_OFN1050_FE_DBTN0_n4229 A2=n4256
+ B1=FE_OFN816_n4217 B2=n4252
XU5259 NR2 $PINS O=intadd_28/A[0] I1=n4256 I2=n4255
XU5260 ND2S $PINS O=n4259 I1=It[0][3] I2=FE_OFN1750_n4113
XU5261 MOAI1S $PINS O=intadd_28/B[0] A1=IyIt[3] A2=n4259 B1=IyIt[3] B2=n4259
XU5263 NR2 $PINS O=intadd_28/CI I1=FE_OFN418_intadd_14_SUM_0
+ I2=FE_OFN322_FE_DBTN65_It_0_2
XU5264 NR2 $PINS O=intadd_7/B[1] I1=FE_OFN1636_intadd_14_SUM_1
+ I2=FE_OFN323_FE_DBTN64_It_0_1
XU5265 NR2 $PINS O=intadd_6/A[0] I1=n1317 I2=n4259
XU5266 MOAI1S $PINS O=intadd_6/B[0] A1=IyIt[4] A2=n4262 B1=IyIt[4] B2=n4262
XU5267 NR2 $PINS O=intadd_6/CI I1=FE_OCPN2942_intadd_14_SUM_0
+ I2=FE_OFN321_FE_DBTN66_It_0_3
XU5268 NR2 $PINS O=intadd_28/B[1] I1=FE_OFN1636_intadd_14_SUM_1
+ I2=FE_OFN322_FE_DBTN65_It_0_2
XU5269 NR2 $PINS O=intadd_7/B[2] I1=FE_OFN408_intadd_14_SUM_2
+ I2=FE_OFN323_FE_DBTN64_It_0_1
XU5270 NR2 $PINS O=intadd_5/A[0] I1=n1314 I2=n4262
XU5271 ND2S $PINS O=n4264 I1=It[0][5] I2=FE_OFN1750_n4113
XU5273 NR2 $PINS O=intadd_5/CI I1=FE_OCPN2942_intadd_14_SUM_0
+ I2=FE_OFN320_FE_DBTN67_It_0_4
XU5274 NR2 $PINS O=intadd_6/B[1] I1=n4109 I2=FE_OFN321_FE_DBTN66_It_0_3
XU5275 NR2 $PINS O=intadd_28/B[2] I1=FE_OFN408_intadd_14_SUM_2
+ I2=FE_OFN322_FE_DBTN65_It_0_2
XU5276 NR2 $PINS O=intadd_7/B[3] I1=FE_OFN403_intadd_14_SUM_3
+ I2=FE_OFN323_FE_DBTN64_It_0_1
XU5277 NR2 $PINS O=intadd_7/A[4] I1=FE_OFN398_intadd_14_SUM_5
+ I2=FE_OFN324_FE_DBTN63_It_0_0
XU5278 NR2 $PINS O=intadd_7/B[4] I1=FE_OFN400_intadd_14_SUM_4
+ I2=FE_OFN323_FE_DBTN64_It_0_1
XU5279 NR2 $PINS O=intadd_4/A[0] I1=FE_OFN599_IyIt_5 I2=n4264
XU5280 ND2 $PINS O=n4266 I1=It[0][6] I2=FE_OFN1750_n4113
XU5282 NR2 $PINS O=intadd_4/CI I1=FE_OCPN2942_intadd_14_SUM_0
+ I2=FE_OFN319_FE_DBTN68_It_0_5
XU5283 NR2 $PINS O=intadd_5/B[1] I1=n4109 I2=FE_OFN320_FE_DBTN67_It_0_4
XU5284 NR2 $PINS O=intadd_6/B[2] I1=FE_OFN408_intadd_14_SUM_2
+ I2=FE_OFN321_FE_DBTN66_It_0_3
XU5285 NR2 $PINS O=intadd_28/B[3] I1=FE_OFN403_intadd_14_SUM_3
+ I2=FE_OFN322_FE_DBTN65_It_0_2
XU5286 NR2 $PINS O=intadd_3/A[0] I1=n1311 I2=n4266
XU5287 ND2S $PINS O=n4271 I1=It[0][7] I2=FE_OFN950_n4268
XU5288 NR2 $PINS O=intadd_3/CI I1=FE_OFN420_intadd_14_SUM_0 I2=FE_DBTN69_It_0_6
XU5289 NR2 $PINS O=intadd_4/B[1] I1=n4109 I2=FE_OFN319_FE_DBTN68_It_0_5
XU5290 NR2 $PINS O=intadd_5/B[2] I1=FE_OFN408_intadd_14_SUM_2
+ I2=FE_OFN320_FE_DBTN67_It_0_4
XU5291 NR2 $PINS O=intadd_6/B[3] I1=intadd_14/SUM[3]
+ I2=FE_OFN321_FE_DBTN66_It_0_3
XU5292 NR2 $PINS O=intadd_7/B[5] I1=FE_OFN390_intadd_14_SUM_6
+ I2=FE_OFN324_FE_DBTN63_It_0_0
XU5293 NR2 $PINS O=intadd_28/A[4] I1=FE_OFN398_intadd_14_SUM_5
+ I2=FE_OFN323_FE_DBTN64_It_0_1
XU5294 NR2 $PINS O=intadd_28/B[4] I1=FE_OFN400_intadd_14_SUM_4
+ I2=FE_OFN322_FE_DBTN65_It_0_2
XU5295 NR2 $PINS O=intadd_6/A[4] I1=FE_OFN398_intadd_14_SUM_5
+ I2=FE_OFN322_FE_DBTN65_It_0_2
XU5296 NR2 $PINS O=intadd_6/B[4] I1=FE_OFN400_intadd_14_SUM_4
+ I2=FE_DBTN66_It_0_3
XU5297 AN2B1S $PINS O=intadd_2/A[0] I1=IyIt[7] B1=n4271
XU5298 NR2 $PINS O=intadd_2/CI I1=FE_OFN420_intadd_14_SUM_0 I2=n1362
XU5299 NR2 $PINS O=intadd_3/B[1] I1=n4109 I2=FE_DBTN69_It_0_6
XU5300 NR2 $PINS O=intadd_4/B[2] I1=FE_OFN408_intadd_14_SUM_2
+ I2=FE_OFN319_FE_DBTN68_It_0_5
XU5301 NR2 $PINS O=intadd_5/B[3] I1=intadd_14/SUM[3]
+ I2=FE_OFN320_FE_DBTN67_It_0_4
XU5302 MOAI1S $PINS O=n4277 A1=intadd_7/SUM[6] A2=n4275 B1=intadd_7/SUM[6]
+ B2=n4275
XU5303 MOAI1S $PINS O=n4279 A1=n4277 A2=n4276 B1=n4277 B2=n4276
XU5304 OAI22S $PINS O=n1109 A1=FE_OFN453_n1693 A2=n4279
+ B1=FE_OFN1054_FE_DBTN0_n4229 B2=FE_PHN3245_n1308
XU5305 NR2 $PINS O=intadd_29/A[0] I1=FE_OFN420_intadd_14_SUM_0
+ I2=FE_DBTN70_It_0_8
XU5306 ND2S $PINS O=intadd_29/CI I1=FE_OFN387_It_0__7
+ I2=FE_OFN4139_intadd_14_SUM_1
XU5307 INV1S $PINS O=intadd_2/A[1] I=intadd_29/SUM[0]
XU5308 NR2 $PINS O=intadd_2/B[1] I1=intadd_14/SUM[2]
+ I2=FE_OFN318_FE_DBTN69_It_0_6
XU5309 NR2 $PINS O=intadd_3/B[2] I1=intadd_14/SUM[3]
+ I2=FE_OFN319_FE_DBTN68_It_0_5
XU5310 NR2 $PINS O=intadd_4/B[3] I1=FE_OFN400_intadd_14_SUM_4
+ I2=FE_DBTN67_It_0_4
XU5311 NR2 $PINS O=intadd_5/A[4] I1=FE_OFN390_intadd_14_SUM_6
+ I2=FE_DBTN65_It_0_2
XU5312 NR2 $PINS O=intadd_5/B[4] I1=FE_OFN398_intadd_14_SUM_5
+ I2=FE_OFN321_FE_DBTN66_It_0_3
XU5313 NR2 $PINS O=intadd_3/A[3] I1=FE_OCPN5_intadd_14_SUM_5
+ I2=FE_DBTN67_It_0_4
XU5314 NR2 $PINS O=intadd_3/B[3] I1=FE_OFN400_intadd_14_SUM_4
+ I2=FE_DBTN68_It_0_5
XU5315 NR2 $PINS O=intadd_23/B[0] I1=FE_OFN414_intadd_14_SUM_1
+ I2=FE_DBTN70_It_0_8
XU5316 INV1S $PINS O=intadd_2/A[2] I=intadd_29/SUM[1]
XU5317 NR2 $PINS O=intadd_2/B[2] I1=intadd_14/SUM[3]
+ I2=FE_OFN318_FE_DBTN69_It_0_6
XU5318 NR2 $PINS O=intadd_4/B[4] I1=FE_OFN390_intadd_14_SUM_6
+ I2=FE_OFN321_FE_DBTN66_It_0_3
XU5319 MOAI1S $PINS O=n4287 A1=intadd_6/SUM[6] A2=n4286 B1=intadd_6/SUM[6]
+ B2=n4286
XU5320 MOAI1S $PINS O=n4290 A1=n4288 A2=n4287 B1=n4288 B2=n4287
XU5321 OAI22S $PINS O=n1107 A1=FE_OFN452_n1693 A2=n4290
+ B1=FE_OFN1055_FE_DBTN0_n4229 B2=intadd_23/A[0]
XU5322 NR2 $PINS O=intadd_23/B[1] I1=intadd_14/SUM[2] I2=FE_DBTN70_It_0_8
XU5323 INV1S $PINS O=intadd_2/A[3] I=intadd_29/SUM[2]
XU5324 NR2 $PINS O=intadd_2/B[3] I1=FE_DBTN46_intadd_14_SUM_4
+ I2=FE_OFN318_FE_DBTN69_It_0_6
XU5325 NR2 $PINS O=intadd_3/A[4] I1=FE_OFN390_intadd_14_SUM_6
+ I2=FE_DBTN67_It_0_4
XU5326 NR2 $PINS O=intadd_3/B[4] I1=FE_OCPN5_intadd_14_SUM_5
+ I2=FE_DBTN68_It_0_5
XU5327 NR2 $PINS O=intadd_3/B[5] I1=FE_OFN390_intadd_14_SUM_6
+ I2=FE_OFN319_FE_DBTN68_It_0_5
XU5328 NR2 $PINS O=intadd_23/B[2] I1=FE_OFN404_intadd_14_SUM_3
+ I2=FE_DBTN70_It_0_8
XU5329 INV1S $PINS O=intadd_2/A[4] I=intadd_29/SUM[3]
XU5330 NR2 $PINS O=intadd_2/B[4] I1=FE_OFN394_intadd_14_SUM_5
+ I2=FE_OFN318_FE_DBTN69_It_0_6
XU5331 NR2 $PINS O=intadd_2/B[5] I1=FE_OFN391_intadd_14_SUM_6
+ I2=FE_OFN318_FE_DBTN69_It_0_6
XU5332 NR2 $PINS O=intadd_23/B[3] I1=FE_OFN401_intadd_14_SUM_4
+ I2=FE_DBTN70_It_0_8
XU5333 INV1S $PINS O=intadd_3/B[6] I=intadd_29/SUM[4]
XU5334 NR2 $PINS O=intadd_23/B[4] I1=FE_OFN394_intadd_14_SUM_5
+ I2=FE_OFN317_FE_DBTN70_It_0_8
XU5335 NR2 $PINS O=n4303 I1=FE_OFN422_intadd_14_n1
+ I2=FE_OFN318_FE_DBTN69_It_0_6
XU5336 INV1S $PINS O=intadd_2/A[6] I=n4299
XU5337 INV1S $PINS O=intadd_2/B[6] I=intadd_29/n1
XU5338 NR2 $PINS O=intadd_34/B[0] I1=FE_OFN391_intadd_14_SUM_6
+ I2=FE_OFN317_FE_DBTN70_It_0_8
XU5339 NR2 $PINS O=intadd_34/CI I1=FE_OFN422_intadd_14_n1 I2=n1362
XU5340 FA1S $PINS S=n4299 CO=intadd_23/B[5] A=n4304 B=n4303 CI=intadd_23/SUM[4]
XU5341 MAO222P $PINS O=n4309 A1=intadd_2/SUM[6] B1=intadd_3/n1 C1=n4305
XU5342 MOAI1S $PINS O=n4306 A1=intadd_23/SUM[5] A2=n4309 B1=intadd_23/SUM[5]
+ B2=n4309
XU5343 MOAI1S $PINS O=n4307 A1=intadd_2/n1 A2=n4306 B1=intadd_2/n1 B2=n4306
XU5344 OAI22S $PINS O=n1102 A1=FE_OFN454_n1693 A2=n4307
+ B1=FE_OFN1055_FE_DBTN0_n4229 B2=intadd_34/A[0]
XU5345 ND2 $PINS O=n4308 I1=intadd_2/n1 I2=n4309
XU5347 MOAI1S $PINS O=n4310 A1=intadd_34/SUM[1] A2=n4312 B1=intadd_34/SUM[1]
+ B2=n4312
XU5348 MOAI1S $PINS O=n4311 A1=intadd_23/n1 A2=n4310 B1=intadd_23/n1 B2=n4310
XU5349 OAI22S $PINS O=n1101 A1=FE_OFN454_n1693 A2=n4311
+ B1=FE_OFN1055_FE_DBTN0_n4229 B2=intadd_34/A[1]
XU5350 MAO222 $PINS O=intadd_34/B[2] A1=intadd_34/SUM[1] B1=n4312
+ C1=intadd_23/n1
XU5351 NR2 $PINS O=n4315 I1=n4314 I2=n4313
XU5352 MOAI1S $PINS O=n4318 A1=FE_OFN593_IyIt_18 A2=n4315 B1=FE_OFN593_IyIt_18
+ B2=n4315
XU5353 OAI22S $PINS O=n1098 A1=FE_OFN451_n1693 A2=n4318
+ B1=FE_OFN1053_FE_DBTN0_n4229 B2=FE_OFN518_n4316
XU5354 ND2S $PINS O=n4322 I1=n4321 I2=n4320
XU5355 MOAI1S $PINS O=n4325 A1=FE_OFN591_IyIt_21 A2=n4322 B1=FE_OFN591_IyIt_21
+ B2=n4322
XU5356 OAI22S $PINS O=n1096 A1=FE_OFN451_n1693 A2=n4325
+ B1=FE_OFN1053_FE_DBTN0_n4229 B2=n1299
XU5357 OAI22S $PINS O=n1091 A1=n4330 A2=n4329 B1=n4328 B2=n4327
XU5358 OA12 $PINS O=n4357 A1=n4333 B1=row_reg[0] B2=n4331
XU5359 NR2 $PINS O=n4332 I1=n4333 I2=FE_PHN3214_row_reg_0
XU5360 NR2 $PINS O=n1077 I1=n4357 I2=n4332
XU5361 AN2 $PINS O=n4358 I1=n4333 I2=row_reg[0]
XU5362 OR2B1S $PINS O=n4335 I1=n4334 B1=n4358
XU5363 MOAI1S $PINS O=FE_PHN3293_n1076 A1=row_reg[3] A2=n4335 B1=row_reg[3]
+ B2=n4335
XU5365 MOAI1S $PINS O=n1075 A1=FE_OFN494_n2949 A2=FE_OFN4137_n4336
+ B1=FE_OFN494_n2949 B2=FE_PHN3153_Ix_4_0
XU5366 MOAI1S $PINS O=n1074 A1=FE_OFN497_n2949 A2=FE_OFN521_n4337
+ B1=FE_OFN497_n2949 B2=Ix[4][1]
XU5367 MOAI1S $PINS O=n1073 A1=FE_OFN499_n2949 A2=FE_OFN441_intadd_21_SUM_1
+ B1=FE_OFN496_n2949 B2=FE_PHN3185_Ix_4_2
XU5368 MOAI1S $PINS O=n1072 A1=FE_OFN499_n2949 A2=FE_OFN1746_FE_DBTN13_n4339
+ B1=FE_OFN499_n2949 B2=Ix[4][3]
XU5369 MOAI1S $PINS O=n1069 A1=FE_OFN505_n2949 A2=FE_OFN430_intadd_21_SUM_5
+ B1=FE_OFN505_n2949 B2=FE_PHN3178_Ix_4_6
XU5371 MOAI1S $PINS O=n1068 A1=FE_OFN505_n2949 A2=FE_OFN425_intadd_21_SUM_6
+ B1=FE_OFN505_n2949 B2=Ix[4][7]
XU5372 MOAI1S $PINS O=n1067 A1=FE_OFN496_n2949 A2=FE_OFN748_n1495
+ B1=FE_OFN496_n2949 B2=FE_PHN3175_Ix_4_8
XU5373 MUX2 $PINS O=n1066 S=FE_OFN493_n2949 A=FE_PHN3153_Ix_4_0 B=Ix[3][0]
XU5374 MUX2 $PINS O=n1065 S=FE_OFN497_n2949 A=Ix[4][1] B=FE_PHN3140_Ix_3_1
XU5375 MUX2 $PINS O=n1064 S=FE_OFN498_n2949 A=FE_PHN3185_Ix_4_2 B=Ix[3][2]
XU5377 MUX2 $PINS O=n1063 S=FE_OFN499_n2949 A=Ix[4][3] B=FE_PHN3158_Ix_3_3
XU5378 MUX2 $PINS O=n1062 S=FE_OFN501_n2949 A=Ix[4][4] B=Ix[3][4]
XU5379 MUX2 $PINS O=n1061 S=FE_OFN506_n2949 A=Ix[4][5] B=FE_PHN3164_Ix_3_5
XU5380 MUX2 $PINS O=n1060 S=FE_OFN506_n2949 A=FE_PHN3178_Ix_4_6
+ B=FE_PHN3193_Ix_3_6
XU5381 MUX2 $PINS O=n1059 S=FE_OFN506_n2949 A=Ix[4][7] B=Ix[3][7]
XU5382 MUX2 $PINS O=n1058 S=FE_OFN495_n2949 A=FE_PHN3175_Ix_4_8
+ B=FE_PHN3210_Ix_3_8
XU5384 MUX2 $PINS O=n1057 S=FE_OFN492_n2949 A=Ix[3][0] B=FE_PHN3165_Ix_2_0
XU5385 MUX2 $PINS O=n1056 S=FE_OFN495_n2949 A=FE_PHN3140_Ix_3_1
+ B=FE_PHN3136_Ix_2_1
XU5386 MUX2 $PINS O=n1055 S=FE_OFN498_n2949 A=Ix[3][2] B=FE_PHN3159_Ix_2_2
XU5387 MUX2 $PINS O=n1054 S=FE_OFN498_n2949 A=FE_PHN3158_Ix_3_3 B=Ix[2][3]
XU5388 MUX2 $PINS O=n1053 S=FE_OFN499_n2949 A=Ix[3][4] B=FE_PHN3191_Ix_2_4
XU5389 MUX2 $PINS O=n1052 S=FE_OFN501_n2949 A=FE_PHN3164_Ix_3_5 B=Ix[2][5]
XU5390 MUX2 $PINS O=n1051 S=FE_OFN506_n2949 A=FE_PHN3193_Ix_3_6 B=Ix[2][6]
XU5391 MUX2 $PINS O=n1050 S=FE_OFN496_n2949 A=Ix[3][7] B=FE_PHN3187_Ix_2_7
XU5392 MUX2 $PINS O=n1049 S=FE_OFN491_n2949 A=FE_PHN3210_Ix_3_8 B=Ix[2][8]
XU5393 MUX2 $PINS O=n1048 S=FE_OFN492_n2949 A=FE_PHN3165_Ix_2_0
+ B=FE_PHN3151_Ix_1_0
XU5394 MUX2 $PINS O=n1047 S=FE_OFN492_n2949 A=FE_PHN3136_Ix_2_1 B=Ix[1][1]
XU5395 MUX2 $PINS O=n1046 S=FE_OFN497_n2949 A=FE_PHN3159_Ix_2_2
+ B=FE_PHN3184_Ix_1_2
XU5396 MUX2 $PINS O=n1045 S=FE_OFN497_n2949 A=Ix[2][3] B=FE_PHN3211_Ix_1_3
XU5397 MUX2 $PINS O=n1044 S=FE_OFN493_n2949 A=FE_PHN3191_Ix_2_4
+ B=FE_PHN3208_Ix_1_4
XU5398 MUX2 $PINS O=n1043 S=FE_OFN497_n2949 A=Ix[2][5] B=Ix[1][5]
XU5399 MUX2 $PINS O=n1042 S=FE_OFN493_n2949 A=Ix[2][6] B=FE_PHN3182_Ix_1_6
XU5400 MUX2 $PINS O=n1041 S=FE_OFN491_n2949 A=FE_PHN3187_Ix_2_7
+ B=FE_PHN3204_Ix_1_7
XU5401 MUX2 $PINS O=n1040 S=FE_OFN491_n2949 A=Ix[2][8] B=Ix[1][8]
XU5402 MOAI1S $PINS O=n1039 A1=FE_OFN824_n4348 A2=FE_DBTN47_Ix_0_0
+ B1=FE_OFN824_n4348 B2=FE_PHN3151_Ix_1_0
XU5403 MOAI1S $PINS O=n1035 A1=FE_OFN824_n4348 A2=FE_DBTN51_Ix_0_4
+ B1=FE_OFN824_n4348 B2=FE_PHN3208_Ix_1_4
XU5404 MOAI1S $PINS O=n1034 A1=FE_OFN825_n4348 A2=FE_DBTN52_Ix_0_5
+ B1=FE_OFN825_n4348 B2=Ix[1][5]
XU5405 MOAI1S $PINS O=n1033 A1=n4348 A2=FE_DBTN53_Ix_0_6 B1=n4348
+ B2=FE_PHN3182_Ix_1_6
XU5406 MOAI1S $PINS O=n1032 A1=FE_OFN825_n4348 A2=n1296 B1=FE_OFN825_n4348
+ B2=FE_PHN3204_Ix_1_7
XU5407 ND2S $PINS O=n4359 I1=row_reg[1] I2=n4357
XU5408 OA12 $PINS O=n1030 A1=n4359 B1=row_reg[1] B2=n4358
XU5409 ND2S $PINS O=n4360 I1=row_reg[1] I2=n4358
XU5410 MOAI1S $PINS O=n1029 A1=row_reg[2] A2=n4360 B1=row_reg[2] B2=n4359
XU5411 FA1S $PINS S=intadd_32/SUM[2] CO=intadd_32/n2 A=intadd_32/B[2]
+ B=intadd_32/A[2] CI=intadd_32/n3
XU5412 FA1 $PINS S=intadd_14/SUM[2] CO=intadd_14/n5 A=intadd_14/B[2]
+ B=img1[0][3] CI=intadd_14/n6
XU5413 FA1 $PINS S=intadd_14/SUM[1] CO=intadd_14/n6 A=intadd_14/B[1]
+ B=img1[0][2] CI=intadd_14/n7
XU5414 FA1 $PINS S=intadd_14/SUM[3] CO=intadd_14/n4 A=intadd_14/B[3]
+ B=img1[0][4] CI=intadd_14/n5
XU5415 FA1 $PINS S=intadd_20/SUM[6] CO=intadd_20/n1 A=intadd_26/n1
+ B=intadd_19/SUM[4] CI=intadd_20/n2
XU5416 FA1 $PINS S=intadd_20/SUM[5] CO=intadd_20/n2 A=intadd_20/B[5]
+ B=intadd_19/SUM[3] CI=intadd_20/n3
XU5417 FA1 $PINS S=intadd_1/SUM[4] CO=intadd_1/n6 A=intadd_32/SUM[2]
+ B=intadd_1/A[4] CI=intadd_1/n7
XU5418 FA1 $PINS S=intadd_14/SUM[0] CO=intadd_14/n7 A=intadd_14/B[0]
+ B=img1[0][1] CI=intadd_14/CI
XU5419 FA1 $PINS S=intadd_13/SUM[6] CO=intadd_13/n1 A=intadd_27/n1
+ B=intadd_12/SUM[4] CI=intadd_13/n2
XU5420 FA1 $PINS S=intadd_13/SUM[5] CO=intadd_13/n2 A=intadd_13/B[5]
+ B=intadd_12/SUM[3] CI=intadd_13/n3
XU5421 FA1 $PINS S=intadd_21/SUM[3] CO=intadd_21/n4 A=intadd_14/B[3]
+ B=img1[12][4] CI=n1687
XU5422 FA1 $PINS S=intadd_14/SUM[5] CO=intadd_14/n2 A=intadd_14/B[5]
+ B=img1[0][6] CI=intadd_14/n3
XL_mul LOD_W23 $PINS in[22]=mul_src_abs[22] in[21]=mul_src_abs[21]
+ in[20]=mul_src_abs[20] in[19]=mul_src_abs[19] in[18]=mul_src_abs[18]
+ in[17]=mul_src_abs[17] in[16]=mul_src_abs[16] in[15]=mul_src_abs[15]
+ in[14]=mul_src_abs[14] in[13]=mul_src_abs[13] in[12]=mul_src_abs[12]
+ in[11]=mul_src_abs[11] in[10]=mul_src_abs[10] in[9]=mul_src_abs[9]
+ in[8]=mul_src_abs[8] in[7]=mul_src_abs[7] in[6]=mul_src_abs[6]
+ in[5]=mul_src_abs[5] in[4]=mul_src_abs[4] in[3]=mul_src_abs[3]
+ in[2]=mul_src_abs[2] in[1]=mul_src_abs[1] in[0]=mul_src[0] pos[4]=mul_pos[4]
+ pos[3]=mul_pos[3] pos[2]=mul_pos[2] pos[1]=mul_pos[1] pos[0]=mul_pos[0]
+ valid=mul_valid
XM1 mult_pipe_5 $PINS rst_n=FE_OFN26_i_reset_n_i A[15]=Iy2_shift[15]
+ A[14]=FE_DBTN27_Iy2_shift_14 A[13]=Iy2_shift[13] A[12]=Iy2_shift[12]
+ A[11]=FE_OFN1292_Iy2_shift_11 A[10]=Iy2_shift[10] A[9]=FE_OFN1304_Iy2_shift_9
+ A[8]=Iy2_shift[8] A[7]=n1622 A[6]=Iy2_shift[6] A[5]=n4486 A[4]=Iy2_shift[4]
+ A[3]=FE_DBTN38_n1438 A[2]=FE_OFN1320_Iy2_shift_2 A[1]=Iy2_shift[1]
+ A[0]=Iy2_shift[0] B[15]=IxIt_shift[15] B[14]=IxIt_shift[14]
+ B[13]=IxIt_shift[13] B[12]=IxIt_shift[12] B[11]=FE_OFN1352_IxIt_shift_11
+ B[10]=IxIt_shift[10] B[9]=IxIt_shift[9] B[8]=IxIt_shift[8]
+ B[7]=FE_DBTN28_IxIt_shift_7 B[6]=IxIt_shift[6] B[5]=IxIt_shift[5]
+ B[4]=FE_DBTN43_n4487 B[3]=IxIt_shift[3] B[2]=FE_DBTN39_n1437 B[1]=IxIt_shift[1]
+ B[0]=IxIt_shift[0] result[31]=Iy2_IxIt[31] result[30]=Iy2_IxIt[30]
+ result[29]=Iy2_IxIt[29] result[28]=Iy2_IxIt[28] result[27]=Iy2_IxIt[27]
+ result[26]=Iy2_IxIt[26] result[25]=Iy2_IxIt[25] result[24]=Iy2_IxIt[24]
+ result[23]=Iy2_IxIt[23] result[22]=Iy2_IxIt[22] result[21]=Iy2_IxIt[21]
+ result[20]=Iy2_IxIt[20] result[19]=Iy2_IxIt[19] result[18]=Iy2_IxIt[18]
+ result[17]=Iy2_IxIt[17] result[16]=Iy2_IxIt[16] result[15]=Iy2_IxIt[15]
+ result[14]=Iy2_IxIt[14] result[13]=Iy2_IxIt[13] result[12]=Iy2_IxIt[12]
+ result[11]=Iy2_IxIt[11] result[10]=Iy2_IxIt[10] result[9]=Iy2_IxIt[9]
+ result[8]=Iy2_IxIt[8] result[7]=Iy2_IxIt[7] result[6]=Iy2_IxIt[6]
+ result[5]=Iy2_IxIt[5] result[4]=Iy2_IxIt[4] result[3]=Iy2_IxIt[3]
+ result[2]=Iy2_IxIt[2] result[1]=Iy2_IxIt[1] result[0]=Iy2_IxIt[0]
+ Iy2_shift_15=FE_OFN1090_Iy2_shift_15 Iy2_shift_14=FE_DBTN27_Iy2_shift_14
+ IxIt_shift_7=IxIt_shift[7] n1438=n1438 n1437=n1437 n4486=FE_DBTN42_n4486
+ n4487=n4487 FE_OFN114_i_reset_n_i=FE_OFN258_i_reset_n_i
+ FE_OFN111_i_reset_n_i=FE_OFN257_i_reset_n_i
+ FE_OFN107_i_reset_n_i=FE_OFN231_i_reset_n_i
+ FE_OFN103_i_reset_n_i=FE_OFN227_i_reset_n_i
+ FE_OFN101_i_reset_n_i=FE_OFN226_i_reset_n_i
+ FE_OFN99_i_reset_n_i=FE_OFN225_i_reset_n_i
+ FE_OFN92_i_reset_n_i=FE_OFN198_i_reset_n_i
+ FE_OFN90_i_reset_n_i=FE_OFN197_i_reset_n_i
+ FE_OFN87_i_reset_n_i=FE_OFN187_i_reset_n_i
+ FE_OFN85_i_reset_n_i=FE_OFN186_i_reset_n_i
+ FE_OFN83_i_reset_n_i=FE_OFN181_i_reset_n_i
+ FE_OFN73_i_reset_n_i=FE_OFN154_i_reset_n_i
+ FE_OFN72_i_reset_n_i=FE_OFN152_i_reset_n_i
+ FE_OFN66_i_reset_n_i=FE_OFN140_i_reset_n_i
+ FE_OFN64_i_reset_n_i=FE_OFN139_i_reset_n_i
+ FE_OFN62_i_reset_n_i=FE_OFN138_i_reset_n_i
+ FE_OFN50_i_reset_n_i=FE_OFN101_i_reset_n_i
+ FE_OFN43_i_reset_n_i=FE_OFN92_i_reset_n_i
+ FE_OFN42_i_reset_n_i=FE_OFN91_i_reset_n_i
+ FE_OFN39_i_reset_n_i=FE_OFN90_i_reset_n_i
+ FE_OFN23_i_reset_n_i=FE_OFN54_i_reset_n_i
+ FE_OFN135_IxIt_shift_1=FE_OFN862_IxIt_shift_1
+ FE_OFN134_IxIt_shift_1=FE_OFN861_IxIt_shift_1
+ FE_OFN133_IxIt_shift_1=FE_OFN859_IxIt_shift_1
+ FE_OFN137_IxIt_shift_0=FE_OFN866_IxIt_shift_0
+ FE_OFN150_IxIt_shift_15=IxIt_shift[15]
+ FE_OFN149_IxIt_shift_15=FE_OFN981_IxIt_shift_15
+ FE_OFN151_IxIt_shift_14=FE_OFN984_IxIt_shift_14
+ FE_OFN153_IxIt_shift_13=FE_OFN988_IxIt_shift_13
+ FE_OFN152_IxIt_shift_13=FE_OFN986_IxIt_shift_13
+ FE_OFN177_n1437=FE_OFN1197_n1437 FE_OFN186_n4487=FE_OFN1248_n4487
+ FE_OFN225_IxIt_shift_12=FE_OFN1349_IxIt_shift_12
+ FE_OFN224_IxIt_shift_12=FE_OFN1347_IxIt_shift_12
+ FE_OFN226_IxIt_shift_11=FE_OFN1726_IxIt_shift_11
+ FE_OFN227_IxIt_shift_10=FE_OFN1356_IxIt_shift_10
+ FE_OFN230_IxIt_shift_8=FE_OFN1360_IxIt_shift_8
+ FE_OFN229_IxIt_shift_8=FE_OFN1361_IxIt_shift_8
+ FE_OFN228_IxIt_shift_8=FE_OFN1361_IxIt_shift_8
+ FE_OFN232_IxIt_shift_7=FE_OFN1367_IxIt_shift_7
+ FE_OFN231_IxIt_shift_7=FE_OFN1366_IxIt_shift_7
+ FE_OFN234_IxIt_shift_3=FE_OFN1369_IxIt_shift_3 FE_OFN240_FE_DBTN39_n1437=n1437
+ FE_OFN261_IxIt_shift_6=FE_OFN1736_IxIt_shift_6
+ FE_OFN199_i_reset_n_i=FE_OFN199_i_reset_n_i
+ FE_OFN1194_FE_DBTN12_Iy2_shift_15=FE_OFN1194_FE_DBTN12_Iy2_shift_15
+ FE_OFN1306_Iy2_shift_9=FE_OFN1306_Iy2_shift_9 clk_clone3=CTS_109
+ clk_clone2=CTS_111 clk_clone1=CTS_122 clk=CTS_123
XM2 mult_pipe_4 $PINS rst_n=FE_OFN24_i_reset_n_i A[15]=FE_OFN1078_Ix2_shift_15
+ A[14]=FE_DBTN26_Ix2_shift_14 A[13]=FE_OFN1580_Ix2_shift_13
+ A[12]=FE_DBTN20_Ix2_shift_12 A[11]=FE_OFN4245_FE_OFN1554_n3259
+ A[10]=Ix2_shift[10] A[9]=FE_OFN1262_Ix2_shift_9 A[8]=FE_OFN1270_Ix2_shift_8
+ A[7]=FE_OFN1279_Ix2_shift_7 A[6]=Ix2_shift[6] A[5]=FE_OFN1282_Ix2_shift_5
+ A[4]=FE_OFN1493_FE_DBTN31_Ix2_shift_4 A[3]=FE_OFN1502_FE_DBTN25_Ix2_shift_3
+ A[2]=FE_OFN1291_Ix2_shift_2 A[1]=Ix2_shift[1] A[0]=FE_OFN831_Ix2_shift_0
+ B[15]=FE_DBTN22_IyIt_shift_15 B[14]=IyIt_shift[14] B[13]=IyIt_shift[13]
+ B[12]=IyIt_shift[12] B[11]=FE_OFN1371_IyIt_shift_11 B[10]=IyIt_shift[10]
+ B[9]=IyIt_shift[9] B[8]=FE_OFN1378_IyIt_shift_8 B[7]=FE_OFN1139_IyIt_shift_7
+ B[6]=IyIt_shift[6] B[5]=IyIt_shift[5] B[4]=FE_DBTN44_n4488
+ B[3]=FE_OFN1385_IyIt_shift_3 B[2]=FE_DBTN29_n4484 B[1]=IyIt_shift[1]
+ B[0]=IyIt_shift[0] result[31]=Ix2_IyIt[31] result[30]=Ix2_IyIt[30]
+ result[29]=Ix2_IyIt[29] result[28]=Ix2_IyIt[28] result[27]=Ix2_IyIt[27]
+ result[26]=Ix2_IyIt[26] result[25]=Ix2_IyIt[25] result[24]=Ix2_IyIt[24]
+ result[23]=Ix2_IyIt[23] result[22]=Ix2_IyIt[22] result[21]=Ix2_IyIt[21]
+ result[20]=Ix2_IyIt[20] result[19]=Ix2_IyIt[19] result[18]=Ix2_IyIt[18]
+ result[17]=Ix2_IyIt[17] result[16]=Ix2_IyIt[16] result[15]=Ix2_IyIt[15]
+ result[14]=Ix2_IyIt[14] result[13]=Ix2_IyIt[13] result[12]=Ix2_IyIt[12]
+ result[11]=Ix2_IyIt[11] result[10]=Ix2_IyIt[10] result[9]=Ix2_IyIt[9]
+ result[8]=Ix2_IyIt[8] result[7]=Ix2_IyIt[7] result[6]=Ix2_IyIt[6]
+ result[5]=Ix2_IyIt[5] result[4]=Ix2_IyIt[4] result[3]=Ix2_IyIt[3]
+ result[2]=Ix2_IyIt[2] result[1]=Ix2_IyIt[1] result[0]=Ix2_IyIt[0]
+ IyIt_shift_7=FE_DBTN14_IyIt_shift_7
+ Ix2_shift_12=FE_OFN1503_FE_DBTN20_Ix2_shift_12
+ Ix2_shift_15=FE_OFN4165_FE_OFN1078_Ix2_shift_15 IyIt_shift_15=IyIt_shift[15]
+ Ix2_shift_3=FE_OFN1288_Ix2_shift_3 Ix2_shift_14=FE_OFN1086_Ix2_shift_14
+ n4484=n4484 Ix2_shift_4=FE_OFN1284_Ix2_shift_4 n4488=n4488
+ FE_OFN113_i_reset_n_i=FE_OFN258_i_reset_n_i
+ FE_OFN112_i_reset_n_i=FE_OFN257_i_reset_n_i
+ FE_OFN106_i_reset_n_i=FE_OFN231_i_reset_n_i
+ FE_OFN98_i_reset_n_i=FE_OFN224_i_reset_n_i
+ FE_OFN91_i_reset_n_i=FE_OFN197_i_reset_n_i
+ FE_OFN84_i_reset_n_i=FE_OFN181_i_reset_n_i
+ FE_OFN71_i_reset_n_i=FE_OFN152_i_reset_n_i
+ FE_OFN65_i_reset_n_i=FE_OFN139_i_reset_n_i
+ FE_OFN63_i_reset_n_i=FE_OFN138_i_reset_n_i
+ FE_OFN61_i_reset_n_i=FE_OFN137_i_reset_n_i
+ FE_OFN60_i_reset_n_i=FE_OFN135_i_reset_n_i
+ FE_OFN49_i_reset_n_i=FE_OFN101_i_reset_n_i
+ FE_OFN46_i_reset_n_i=FE_OFN97_i_reset_n_i
+ FE_OFN41_i_reset_n_i=FE_OFN91_i_reset_n_i
+ FE_OFN40_i_reset_n_i=FE_OFN90_i_reset_n_i
+ FE_OFN38_i_reset_n_i=FE_OFN89_i_reset_n_i
+ FE_OFN37_i_reset_n_i=FE_OFN88_i_reset_n_i
+ FE_OFN28_i_reset_n_i=FE_OFN61_i_reset_n_i
+ FE_OFN26_i_reset_n_i=FE_OFN58_i_reset_n_i
+ FE_OFN22_i_reset_n_i=FE_OFN54_i_reset_n_i
+ FE_OFN21_i_reset_n_i=FE_OFN53_i_reset_n_i
+ FE_OFN6_i_reset_n_i=FE_OFN26_i_reset_n_i
+ FE_OFN139_IyIt_shift_1=FE_OFN872_IyIt_shift_1
+ FE_OFN138_IyIt_shift_1=FE_OFN871_IyIt_shift_1
+ FE_OFN141_IyIt_shift_0=IyIt_shift[0] FE_OFN140_IyIt_shift_0=IyIt_shift[0]
+ FE_OFN154_IyIt_shift_14=FE_OFN993_IyIt_shift_14
+ FE_OFN160_Ix2_shift_15=FE_OFN4164_FE_OFN1078_Ix2_shift_15
+ FE_OFN166_IyIt_shift_15=FE_OFN1126_IyIt_shift_15
+ FE_OFN168_IyIt_shift_13=FE_OFN1129_IyIt_shift_13
+ FE_OFN167_IyIt_shift_13=FE_OFN1128_IyIt_shift_13
+ FE_OFN170_IyIt_shift_12=FE_OFN1134_IyIt_shift_12
+ FE_OFN169_IyIt_shift_12=FE_OFN1133_IyIt_shift_12
+ FE_OFN171_IyIt_shift_9=FE_OFN1136_IyIt_shift_9
+ FE_OFN172_IyIt_shift_7=FE_OFN1140_IyIt_shift_7 FE_OFN185_n4484=FE_OFN1239_n4484
+ FE_OFN184_n4484=FE_OFN1238_n4484 FE_OFN188_n4488=FE_OFN1254_n4488
+ FE_OFN187_n4488=FE_OFN1253_n4488
+ FE_OFN194_Ix2_shift_9=FE_OFN4175_FE_OFN1263_Ix2_shift_9
+ FE_OFN201_Ix2_shift_7=FE_OFN1280_Ix2_shift_7
+ FE_OFN236_IyIt_shift_11=FE_OFN1372_IyIt_shift_11
+ FE_OFN235_IyIt_shift_11=IyIt_shift[11]
+ FE_OFN238_IyIt_shift_8=FE_OFN1568_IyIt_shift_8
+ FE_OFN237_IyIt_shift_8=FE_OFN1377_IyIt_shift_8
+ FE_OFN239_IyIt_shift_3=IyIt_shift[3]
+ FE_OFN242_FE_DBTN31_Ix2_shift_4=FE_OFN1491_FE_DBTN31_Ix2_shift_4
+ FE_OFN250_IyIt_shift_8=IyIt_shift[8]
+ FE_OFN262_IyIt_shift_11=FE_OFN4126_IyIt_shift_11
+ FE_OFN1263_Ix2_shift_9=FE_OFN4175_FE_OFN1263_Ix2_shift_9
+ FE_OFN267_FE_OFN1554_n3259=FE_OFN4246_FE_OFN1554_n3259 clk_clone3=CTS_106
+ clk_clone2=CTS_109 clk_clone1=CTS_111 clk=CTS_122
XM3 mult_pipe_3 $PINS rst_n=FE_OFN16_i_reset_n_i
+ A[15]=FE_OFN1188_FE_DBTN21_Ix2_shift_15 A[14]=FE_DBTN26_Ix2_shift_14
+ A[13]=FE_OFN959_Ix2_shift_13 A[12]=FE_OFN1258_Ix2_shift_12
+ A[11]=FE_OFN1230_n3259 A[10]=Ix2_shift[10] A[9]=FE_OFN1263_Ix2_shift_9
+ A[8]=Ix2_shift[8] A[7]=Ix2_shift[7] A[6]=n1640 A[5]=FE_OFN1282_Ix2_shift_5
+ A[4]=FE_DBTN31_Ix2_shift_4 A[3]=Ix2_shift[3] A[2]=FE_OFN1291_Ix2_shift_2
+ A[1]=Ix2_shift[1] A[0]=Ix2_shift[0] B[15]=Iy2_shift[15]
+ B[14]=FE_DBTN27_Iy2_shift_14 B[13]=Iy2_shift[13] B[12]=n1668
+ B[11]=FE_OFN1292_Iy2_shift_11 B[10]=FE_OFN1299_Iy2_shift_10 B[9]=FE_OFN4369_n
+ B[8]=FE_OFN1310_Iy2_shift_8 B[7]=n1622 B[6]=FE_OFN1316_Iy2_shift_6
+ B[5]=FE_DBTN42_n4486 B[4]=n1627 B[3]=FE_DBTN38_n1438
+ B[2]=FE_OFN1318_Iy2_shift_2 B[1]=Iy2_shift[1] B[0]=Iy2_shift[0]
+ result[31]=Ix2_Iy2[31] result[30]=Ix2_Iy2[30] result[29]=Ix2_Iy2[29]
+ result[28]=Ix2_Iy2[28] result[27]=Ix2_Iy2[27] result[26]=Ix2_Iy2[26]
+ result[25]=Ix2_Iy2[25] result[24]=Ix2_Iy2[24] result[23]=Ix2_Iy2[23]
+ result[22]=Ix2_Iy2[22] result[21]=Ix2_Iy2[21] result[20]=Ix2_Iy2[20]
+ result[19]=Ix2_Iy2[19] result[18]=Ix2_Iy2[18] result[17]=Ix2_Iy2[17]
+ result[16]=Ix2_Iy2[16] result[15]=Ix2_Iy2[15] result[14]=Ix2_Iy2[14]
+ result[13]=Ix2_Iy2[13] result[12]=Ix2_Iy2[12] result[11]=Ix2_Iy2[11]
+ result[10]=Ix2_Iy2[10] result[9]=Ix2_Iy2[9] result[8]=Ix2_Iy2[8]
+ result[7]=Ix2_Iy2[7] result[6]=Ix2_Iy2[6] result[5]=Ix2_Iy2[5]
+ result[4]=Ix2_Iy2[4] result[3]=Ix2_Iy2[3] result[2]=Ix2_Iy2[2]
+ result[1]=Ix2_Iy2[1] result[0]=Ix2_Iy2[0]
+ Iy2_shift_15=FE_OFN1194_FE_DBTN12_Iy2_shift_15 Ix2_shift_12=Ix2_shift[12]
+ Ix2_shift_15=Ix2_shift[15] Ix2_shift_3=FE_OFN1288_Ix2_shift_3
+ Ix2_shift_14=Ix2_shift[14] Iy2_shift_14=FE_DBTN27_Iy2_shift_14
+ Ix2_shift_4=Ix2_shift[4] n1438=FE_DBTN38_n1438 n4486=FE_OFN1243_n4486
+ FE_OFN96_i_reset_n_i=FE_OFN216_i_reset_n_i
+ FE_OFN95_i_reset_n_i=FE_OFN212_i_reset_n_i
+ FE_OFN82_i_reset_n_i=FE_OFN170_i_reset_n_i
+ FE_OFN80_i_reset_n_i=FE_OFN169_i_reset_n_i
+ FE_OFN79_i_reset_n_i=FE_OFN168_i_reset_n_i
+ FE_OFN75_i_reset_n_i=FE_OFN166_i_reset_n_i
+ FE_OFN59_i_reset_n_i=FE_OFN128_i_reset_n_i
+ FE_OFN57_i_reset_n_i=FE_OFN120_i_reset_n_i
+ FE_OFN55_i_reset_n_i=FE_OFN118_i_reset_n_i
+ FE_OFN54_i_reset_n_i=FE_OFN117_i_reset_n_i
+ FE_OFN52_i_reset_n_i=FE_OFN116_i_reset_n_i
+ FE_OFN34_i_reset_n_i=FE_OFN81_i_reset_n_i
+ FE_OFN33_i_reset_n_i=FE_OFN76_i_reset_n_i
+ FE_OFN32_i_reset_n_i=FE_OFN75_i_reset_n_i
+ FE_OFN20_i_reset_n_i=FE_OFN47_i_reset_n_i
+ FE_OFN18_i_reset_n_i=FE_OFN46_i_reset_n_i
+ FE_OFN15_i_reset_n_i=FE_OFN44_i_reset_n_i
+ FE_OFN12_i_reset_n_i=FE_OFN40_i_reset_n_i
+ FE_OFN3_i_reset_n_i=FE_OFN19_i_reset_n_i
+ FE_OFN117_Ix2_shift_1=FE_OFN830_Ix2_shift_1
+ FE_OFN116_Ix2_shift_1=FE_OFN828_Ix2_shift_1
+ FE_OFN119_Ix2_shift_0=FE_OFN832_Ix2_shift_0
+ FE_OFN118_Ix2_shift_0=FE_OFN831_Ix2_shift_0
+ FE_OFN120_Iy2_shift_1=FE_OFN837_Iy2_shift_1
+ FE_OFN122_Iy2_shift_0=FE_OFN843_Iy2_shift_0
+ FE_OFN121_Iy2_shift_0=FE_OFN841_Iy2_shift_0
+ FE_OFN143_Ix2_shift_13=Ix2_shift[13]
+ FE_OFN142_Ix2_shift_13=FE_OFN958_Ix2_shift_13
+ FE_OFN145_Iy2_shift_13=FE_OFN966_Iy2_shift_13
+ FE_OFN144_Iy2_shift_13=FE_OFN963_Iy2_shift_13
+ FE_OFN159_Ix2_shift_15=FE_OFN1081_Ix2_shift_15
+ FE_OFN158_Ix2_shift_15=FE_OFN4164_FE_OFN1078_Ix2_shift_15
+ FE_OFN157_Ix2_shift_15=FE_OFN1078_Ix2_shift_15
+ FE_OFN156_Ix2_shift_15=FE_OFN1079_Ix2_shift_15
+ FE_OFN161_Ix2_shift_14=FE_OFN1086_Ix2_shift_14
+ FE_OFN173_FE_DBTN27_Iy2_shift_14=FE_OFN1181_FE_DBTN27_Iy2_shift_14
+ FE_OFN174_FE_DBTN26_Ix2_shift_14=FE_OFN1184_FE_DBTN26_Ix2_shift_14
+ FE_OFN176_FE_DBTN21_Ix2_shift_15=FE_OFN1077_Ix2_shift_15
+ FE_OFN175_FE_DBTN21_Ix2_shift_15=FE_OFN1188_FE_DBTN21_Ix2_shift_15
+ FE_OFN183_n3259=FE_OFN1554_n3259 FE_OFN182_n3259=FE_OFN1231_n3259
+ FE_OFN181_n3259=FE_OFN1228_n3259 FE_OFN190_Ix2_shift_10=FE_OFN1260_Ix2_shift_10
+ FE_OFN189_Ix2_shift_10=FE_OFN1259_Ix2_shift_10
+ FE_OFN193_Ix2_shift_9=FE_OFN4178_FE_OFN1263_Ix2_shift_9
+ FE_OFN192_Ix2_shift_9=FE_OFN1263_Ix2_shift_9
+ FE_OFN191_Ix2_shift_9=FE_OFN4175_FE_OFN1263_Ix2_shift_9
+ FE_OFN197_Ix2_shift_8=FE_OFN4351_Ix2_shift_8
+ FE_OFN196_Ix2_shift_8=FE_OFN1271_Ix2_shift_8
+ FE_OFN195_Ix2_shift_8=FE_OFN1270_Ix2_shift_8
+ FE_OFN200_Ix2_shift_7=FE_OFN1280_Ix2_shift_7
+ FE_OFN199_Ix2_shift_7=FE_OFN1279_Ix2_shift_7 FE_OFN198_Ix2_shift_7=Ix2_shift[7]
+ FE_OFN202_Ix2_shift_5=Ix2_shift[5] FE_OFN203_Ix2_shift_4=FE_OFN1284_Ix2_shift_4
+ FE_OFN204_Ix2_shift_3=FE_DBTN25_Ix2_shift_3 FE_OFN205_Ix2_shift_2=Ix2_shift[2]
+ FE_OFN206_Iy2_shift_11=FE_OFN1294_Iy2_shift_11
+ FE_OFN207_Iy2_shift_10=FE_OFN1301_Iy2_shift_10
+ FE_OFN209_Iy2_shift_9=FE_OFN1552_Iy2_shift_9
+ FE_OFN208_Iy2_shift_9=FE_OFN1304_Iy2_shift_9
+ FE_OFN211_Iy2_shift_8=FE_OFN1313_Iy2_shift_8
+ FE_OFN210_Iy2_shift_8=FE_OFN1310_Iy2_shift_8
+ FE_OFN213_Iy2_shift_2=FE_OFN1320_Iy2_shift_2
+ FE_OFN212_Iy2_shift_2=FE_OFN1318_Iy2_shift_2
+ FE_OFN241_FE_DBTN38_n1438=FE_DBTN38_n1438
+ FE_OFN243_FE_DBTN31_Ix2_shift_4=FE_OFN1493_FE_DBTN31_Ix2_shift_4
+ FE_OFN246_FE_DBTN25_Ix2_shift_3=FE_OFN1288_Ix2_shift_3
+ FE_OFN247_FE_DBTN20_Ix2_shift_12=FE_OFN1505_FE_DBTN20_Ix2_shift_12
+ FE_OFN256_Ix2_shift_13=FE_OFN1580_Ix2_shift_13
+ FE_OFN258_Ix2_shift_3=FE_OFN1608_Ix2_shift_3
+ FE_OFN260_Iy2_shift_15=FE_OFN1088_Iy2_shift_15
+ FE_OFN1278_Ix2_shift_7=FE_OFN1278_Ix2_shift_7
+ FE_OFN263_FE_OFN1078_Ix2_shift_15=FE_OFN4165_FE_OFN1078_Ix2_shift_15
+ FE_OFN268_FE_OFN1554_n3259=FE_OFN4246_FE_OFN1554_n3259
+ FE_OFN266_FE_OFN1554_n3259=FE_OFN4245_FE_OFN1554_n3259 FE_OFN269_n=FE_OFN4349_n
+ clk_clone3=CTS_129 clk_clone5=CTS_127 clk_clone4=CTS_128 clk_clone2=CTS_132
+ clk_clone1=CTS_134 clk=CTS_135
XM4 mult_pipe_2 $PINS rst_n=FE_OFN9_i_reset_n_i A[15]=FE_OFN1570_n2620
+ A[14]=FE_OFN971_IxIy_shift_14 A[13]=FE_OFN1583_IxIy_shift_13
+ A[12]=FE_OFN978_IxIy_shift_12 A[11]=FE_OFN1217_n2891
+ A[10]=FE_OFN4182_FE_OFN1323_IxIy_shift_10 A[9]=FE_OFN1557_n3310
+ A[8]=FE_OFN1109_IxIy_shift_8 A[7]=FE_OFN1578_IxIy_shift_7 A[6]=n1653
+ A[5]=FE_OFN1496_FE_DBTN30_IxIy_shift_5 A[4]=FE_OFN1509_FE_DBTN10_IxIy_shift_4
+ A[3]=FE_OFN1346_IxIy_shift_3 A[2]=n1650 A[1]=FE_OFN847_IxIy_shift_1
+ A[0]=FE_OFN857_IxIy_shift_0 B[15]=FE_DBTN22_IyIt_shift_15
+ B[14]=FE_OFN993_IyIt_shift_14 B[13]=FE_OFN1129_IyIt_shift_13
+ B[12]=FE_OFN1134_IyIt_shift_12 B[11]=FE_OFN1372_IyIt_shift_11
+ B[10]=IyIt_shift[10] B[9]=FE_OFN1136_IyIt_shift_9 B[8]=FE_OFN1378_IyIt_shift_8
+ B[7]=FE_DBTN14_IyIt_shift_7 B[6]=IyIt_shift[6] B[5]=IyIt_shift[5]
+ B[4]=FE_DBTN44_n4488 B[3]=FE_OFN1385_IyIt_shift_3 B[2]=FE_DBTN29_n4484
+ B[1]=FE_OFN872_IyIt_shift_1 B[0]=IyIt_shift[0] result[31]=IxIy_IyIt[31]
+ result[30]=IxIy_IyIt[30] result[29]=IxIy_IyIt[29] result[28]=IxIy_IyIt[28]
+ result[27]=IxIy_IyIt[27] result[26]=IxIy_IyIt[26] result[25]=IxIy_IyIt[25]
+ result[24]=IxIy_IyIt[24] result[23]=IxIy_IyIt[23] result[22]=IxIy_IyIt[22]
+ result[21]=IxIy_IyIt[21] result[20]=IxIy_IyIt[20] result[19]=IxIy_IyIt[19]
+ result[18]=IxIy_IyIt[18] result[17]=IxIy_IyIt[17] result[16]=IxIy_IyIt[16]
+ result[15]=IxIy_IyIt[15] result[14]=IxIy_IyIt[14] result[13]=IxIy_IyIt[13]
+ result[12]=IxIy_IyIt[12] result[11]=IxIy_IyIt[11] result[10]=IxIy_IyIt[10]
+ result[9]=IxIy_IyIt[9] result[8]=IxIy_IyIt[8] result[7]=IxIy_IyIt[7]
+ result[6]=IxIy_IyIt[6] result[5]=IxIy_IyIt[5] result[4]=IxIy_IyIt[4]
+ result[3]=IxIy_IyIt[3] result[2]=IxIy_IyIt[2] result[1]=IxIy_IyIt[1]
+ result[0]=IxIy_IyIt[0] IxIy_shift_4=FE_OFN1337_IxIy_shift_4
+ IyIt_shift_7=FE_DBTN14_IyIt_shift_7 IyIt_shift_15=FE_OFN1126_IyIt_shift_15
+ n4484=FE_OFN1239_n4484 IxIy_shift_5=FE_OFN1331_IxIy_shift_5
+ n4488=FE_OFN1254_n4488 FE_OFN108_i_reset_n_i=FE_OFN245_i_reset_n_i
+ FE_OFN93_i_reset_n_i=FE_OFN211_i_reset_n_i
+ FE_OFN74_i_reset_n_i=FE_OFN165_i_reset_n_i
+ FE_OFN70_i_reset_n_i=FE_OFN146_i_reset_n_i
+ FE_OFN51_i_reset_n_i=FE_OFN115_i_reset_n_i
+ FE_OFN48_i_reset_n_i=FE_OFN99_i_reset_n_i
+ FE_OFN47_i_reset_n_i=FE_OFN97_i_reset_n_i
+ FE_OFN29_i_reset_n_i=FE_OFN73_i_reset_n_i
+ FE_OFN27_i_reset_n_i=FE_OFN60_i_reset_n_i
+ FE_OFN25_i_reset_n_i=FE_OFN58_i_reset_n_i
+ FE_OFN9_i_reset_n_i=FE_OFN15_i_reset_n_i
+ FE_OFN8_i_reset_n_i=FE_OFN29_i_reset_n_i
+ FE_OFN7_i_reset_n_i=FE_OFN28_i_reset_n_i
+ FE_OFN127_IxIy_shift_1=FE_OFN851_IxIy_shift_1
+ FE_OFN132_IxIy_shift_0=FE_OFN856_IxIy_shift_0 FE_OFN180_n2891=FE_OFN1220_n2891
+ FE_OFN219_IxIy_shift_4=FE_OFN1339_IxIy_shift_4
+ FE_OFN222_IxIy_shift_3=FE_OFN1346_IxIy_shift_3 FE_OFN252_n2620=FE_OFN1572_n2620
+ FE_OFN254_IxIy_shift_7=FE_OFN4190_FE_OFN1124_IxIy_shift_7
+ FE_OFN259_IxIy_shift_12=FE_OFN974_IxIy_shift_12 clk_clone1=CTS_106 clk=CTS_107
XM5 mult_pipe_1 $PINS rst_n=FE_OFN26_i_reset_n_i A[15]=FE_OFN1057_n2620
+ A[14]=IxIy_shift[14] A[13]=IxIy_shift[13] A[12]=IxIy_shift[12] A[11]=n2891
+ A[10]=IxIy_shift[10] A[9]=n3310 A[8]=IxIy_shift[8] A[7]=IxIy_shift[7]
+ A[6]=IxIy_shift[6] A[5]=FE_DBTN30_IxIy_shift_5 A[4]=FE_DBTN10_IxIy_shift_4
+ A[3]=IxIy_shift[3] A[2]=n1650 A[1]=IxIy_shift[1] A[0]=IxIy_shift[0]
+ B[15]=FE_OFN981_IxIt_shift_15 B[14]=FE_OFN984_IxIt_shift_14
+ B[13]=FE_OFN986_IxIt_shift_13 B[12]=FE_OFN1349_IxIt_shift_12
+ B[11]=FE_OFN1726_IxIt_shift_11 B[10]=FE_OFN1356_IxIt_shift_10 B[9]=n1658
+ B[8]=FE_OFN1361_IxIt_shift_8 B[7]=FE_DBTN28_IxIt_shift_7
+ B[6]=FE_OFN1736_IxIt_shift_6 B[5]=IxIt_shift[5] B[4]=FE_DBTN43_n4487
+ B[3]=FE_OFN1369_IxIt_shift_3 B[2]=n1437 B[1]=FE_OFN861_IxIt_shift_1
+ B[0]=FE_OFN866_IxIt_shift_0 result[31]=IxIy_IxIt[31] result[30]=IxIy_IxIt[30]
+ result[29]=IxIy_IxIt[29] result[28]=IxIy_IxIt[28] result[27]=IxIy_IxIt[27]
+ result[26]=IxIy_IxIt[26] result[25]=IxIy_IxIt[25] result[24]=IxIy_IxIt[24]
+ result[23]=IxIy_IxIt[23] result[22]=IxIy_IxIt[22] result[21]=IxIy_IxIt[21]
+ result[20]=IxIy_IxIt[20] result[19]=IxIy_IxIt[19] result[18]=IxIy_IxIt[18]
+ result[17]=IxIy_IxIt[17] result[16]=IxIy_IxIt[16] result[15]=IxIy_IxIt[15]
+ result[14]=IxIy_IxIt[14] result[13]=IxIy_IxIt[13] result[12]=IxIy_IxIt[12]
+ result[11]=IxIy_IxIt[11] result[10]=IxIy_IxIt[10] result[9]=IxIy_IxIt[9]
+ result[8]=IxIy_IxIt[8] result[7]=IxIy_IxIt[7] result[6]=IxIy_IxIt[6]
+ result[5]=IxIy_IxIt[5] result[4]=IxIy_IxIt[4] result[3]=IxIy_IxIt[3]
+ result[2]=IxIy_IxIt[2] result[1]=IxIy_IxIt[1] result[0]=IxIy_IxIt[0]
+ IxIy_shift_4=IxIy_shift[4] IxIt_shift_7=FE_OFN1366_IxIt_shift_7
+ IxIy_shift_5=IxIy_shift[5] n1437=FE_DBTN39_n1437 n4487=FE_OFN1248_n4487
+ FE_OFN115_i_reset_n_i=FE_OFN261_i_reset_n_i
+ FE_OFN105_i_reset_n_i=FE_OFN228_i_reset_n_i
+ FE_OFN104_i_reset_n_i=FE_OFN227_i_reset_n_i
+ FE_OFN102_i_reset_n_i=FE_OFN226_i_reset_n_i
+ FE_OFN100_i_reset_n_i=FE_OFN225_i_reset_n_i
+ FE_OFN89_i_reset_n_i=FE_OFN192_i_reset_n_i
+ FE_OFN88_i_reset_n_i=FE_OFN190_i_reset_n_i
+ FE_OFN86_i_reset_n_i=FE_OFN186_i_reset_n_i
+ FE_OFN69_i_reset_n_i=FE_OFN142_i_reset_n_i
+ FE_OFN68_i_reset_n_i=FE_OFN141_i_reset_n_i
+ FE_OFN67_i_reset_n_i=FE_OFN140_i_reset_n_i
+ FE_OFN45_i_reset_n_i=FE_OFN94_i_reset_n_i
+ FE_OFN44_i_reset_n_i=FE_OFN92_i_reset_n_i
+ FE_OFN24_i_reset_n_i=FE_OFN56_i_reset_n_i
+ FE_OFN136_IxIt_shift_1=FE_OFN862_IxIt_shift_1 FE_OFN178_n1437=FE_OFN1199_n1437
+ FE_OFN233_IxIt_shift_7=FE_OFN1367_IxIt_shift_7 FE_OFN251_n2620=FE_OFN1570_n2620
+ clk_clone1=CTS_122 clk_clone3=CTS_110 clk_clone2=CTS_111 clk=CTS_123
XM6 mult_pipe_0 $PINS rst_n=FE_OFN15_i_reset_n_i A[15]=FE_OFN1572_n2620
+ A[14]=FE_OFN968_IxIy_shift_14 A[13]=IxIy_shift[13]
+ A[12]=FE_OFN978_IxIy_shift_12 A[11]=FE_OFN1217_n2891
+ A[10]=FE_OFN1321_IxIy_shift_10 A[9]=FE_OFN1065_n3310 A[8]=IxIy_shift[8]
+ A[7]=FE_OFN1578_IxIy_shift_7 A[6]=n1441 A[5]=n1441 A[4]=n1441 A[3]=n1441
+ A[2]=n1441 A[1]=n1441 A[0]=n1441 B[15]=n1441 B[14]=n1441 B[13]=n1441
+ B[12]=n1441 B[11]=n1441 B[10]=n1441 B[9]=n1441 B[8]=n1441 B[7]=n1441 B[6]=n1652
+ B[5]=FE_DBTN30_IxIy_shift_5 B[4]=FE_OFN1506_FE_DBTN10_IxIy_shift_4
+ B[3]=IxIy_shift[3] B[2]=n1650 B[1]=FE_OFN849_IxIy_shift_1 B[0]=IxIy_shift[0]
+ result[31]=IxIy2[31] result[30]=IxIy2[30] result[29]=IxIy2[29]
+ result[28]=IxIy2[28] result[27]=IxIy2[27] result[26]=IxIy2[26]
+ result[25]=IxIy2[25] result[24]=IxIy2[24] result[23]=IxIy2[23]
+ result[22]=IxIy2[22] result[21]=IxIy2[21] result[20]=IxIy2[20]
+ result[19]=IxIy2[19] result[18]=IxIy2[18] result[17]=IxIy2[17]
+ result[16]=IxIy2[16] result[15]=IxIy2[15] result[14]=IxIy2[14]
+ result[13]=IxIy2[13] result[12]=IxIy2[12] result[11]=IxIy2[11]
+ result[10]=IxIy2[10] result[9]=IxIy2[9] result[8]=IxIy2[8] result[7]=IxIy2[7]
+ result[6]=IxIy2[6] result[5]=IxIy2[5] result[4]=IxIy2[4] result[3]=IxIy2[3]
+ result[2]=IxIy2[2] result[1]=SYNOPSYS_UNCONNECTED__0 result[0]=IxIy2[0]
+ IxIy_shift_4=FE_OFN1763_IxIy_shift_4 IxIy_shift_5=FE_OFN1764_IxIy_shift_5
+ FE_OFN109_i_reset_n_i=FE_OFN252_i_reset_n_i
+ FE_OFN94_i_reset_n_i=FE_OFN212_i_reset_n_i
+ FE_OFN81_i_reset_n_i=FE_OFN169_i_reset_n_i
+ FE_OFN78_i_reset_n_i=FE_OFN168_i_reset_n_i
+ FE_OFN77_i_reset_n_i=FE_OFN166_i_reset_n_i
+ FE_OFN58_i_reset_n_i=FE_OFN128_i_reset_n_i
+ FE_OFN56_i_reset_n_i=FE_OFN118_i_reset_n_i
+ FE_OFN53_i_reset_n_i=FE_OFN117_i_reset_n_i
+ FE_OFN36_i_reset_n_i=FE_OFN81_i_reset_n_i
+ FE_OFN35_i_reset_n_i=FE_OFN81_i_reset_n_i
+ FE_OFN31_i_reset_n_i=FE_OFN75_i_reset_n_i
+ FE_OFN30_i_reset_n_i=FE_OFN74_i_reset_n_i
+ FE_OFN19_i_reset_n_i=FE_OFN47_i_reset_n_i
+ FE_OFN17_i_reset_n_i=FE_OFN46_i_reset_n_i
+ FE_OFN13_i_reset_n_i=FE_OFN41_i_reset_n_i
+ FE_OFN11_i_reset_n_i=FE_OFN40_i_reset_n_i
+ FE_OFN10_i_reset_n_i=FE_OFN39_i_reset_n_i
+ FE_OFN4_i_reset_n_i=FE_OFN19_i_reset_n_i
+ FE_OFN126_IxIy_shift_1=FE_OFN847_IxIy_shift_1
+ FE_OFN125_IxIy_shift_1=IxIy_shift[1]
+ FE_OFN124_IxIy_shift_1=FE_OFN846_IxIy_shift_1
+ FE_OFN123_IxIy_shift_1=FE_OFN844_IxIy_shift_1
+ FE_OFN131_IxIy_shift_0=FE_OFN858_IxIy_shift_0
+ FE_OFN130_IxIy_shift_0=FE_OFN857_IxIy_shift_0
+ FE_OFN129_IxIy_shift_0=FE_OFN856_IxIy_shift_0
+ FE_OFN128_IxIy_shift_0=FE_OFN854_IxIy_shift_0
+ FE_OFN146_IxIy_shift_14=FE_OFN971_IxIy_shift_14
+ FE_OFN148_IxIy_shift_12=IxIy_shift[12]
+ FE_OFN147_IxIy_shift_12=FE_OFN974_IxIy_shift_12
+ FE_OFN155_n3310=FE_OFN1557_n3310
+ FE_OFN162_IxIy_shift_13=FE_OFN1099_IxIy_shift_13
+ FE_OFN163_IxIy_shift_8=FE_OFN1109_IxIy_shift_8
+ FE_OFN165_IxIy_shift_7=FE_OFN1124_IxIy_shift_7
+ FE_OFN164_IxIy_shift_7=FE_OFN1121_IxIy_shift_7 FE_OFN179_n2891=FE_OFN1220_n2891
+ FE_OFN214_IxIy_shift_10=FE_OFN4181_FE_OFN1323_IxIy_shift_10
+ FE_OFN216_IxIy_shift_5=FE_OFN1331_IxIy_shift_5
+ FE_OFN215_IxIy_shift_5=FE_OFN1328_IxIy_shift_5
+ FE_OFN218_IxIy_shift_4=FE_OFN1339_IxIy_shift_4
+ FE_OFN217_IxIy_shift_4=FE_OFN1337_IxIy_shift_4
+ FE_OFN223_IxIy_shift_3=FE_OFN1346_IxIy_shift_3
+ FE_OFN221_IxIy_shift_3=FE_OFN1345_IxIy_shift_3
+ FE_OFN220_IxIy_shift_3=FE_OFN4354_IxIy_shift_3
+ FE_OFN245_FE_DBTN30_IxIy_shift_5=FE_OFN1496_FE_DBTN30_IxIy_shift_5
+ FE_OFN244_FE_DBTN30_IxIy_shift_5=FE_OFN1494_FE_DBTN30_IxIy_shift_5
+ FE_OFN249_FE_DBTN10_IxIy_shift_4=FE_OFN1509_FE_DBTN10_IxIy_shift_4
+ FE_OFN248_FE_DBTN10_IxIy_shift_4=FE_OFN1507_FE_DBTN10_IxIy_shift_4
+ FE_OFN253_IxIy_shift_1=FE_OFN851_IxIy_shift_1
+ FE_OFN255_IxIy_shift_7=FE_OFN4189_FE_OFN1124_IxIy_shift_7
+ FE_OFN257_IxIy_shift_13=FE_OFN1583_IxIy_shift_13
+ FE_OFN264_FE_OFN1323_IxIy_shift_10=FE_OFN4182_FE_OFN1323_IxIy_shift_10
+ FE_OFN265_FE_OFN1124_IxIy_shift_7=FE_OFN4190_FE_OFN1124_IxIy_shift_7
+ FE_OFN270_IxIy_shift_3=FE_OFN4356_IxIy_shift_3 clk_clone4=CTS_127
+ clk_clone3=CTS_128 clk_clone2=CTS_132 clk_clone1=CTS_134 clk=CTS_135
XL1 LOD_W33 $PINS in[32]=n1441 in[31]=det_abs[31] in[30]=det_abs[30]
+ in[29]=det_abs[29] in[28]=det_abs[28] in[27]=det_abs[27] in[26]=det_abs[26]
+ in[25]=det_abs[25] in[24]=det_abs[24] in[23]=det_abs[23] in[22]=det_abs[22]
+ in[21]=det_abs[21] in[20]=det_abs[20] in[19]=det_abs[19] in[18]=det_abs[18]
+ in[17]=det_abs[17] in[16]=det_abs[16] in[15]=det_abs[15] in[14]=det_abs[14]
+ in[13]=det_abs[13] in[12]=det_abs[12] in[11]=det_abs[11] in[10]=det_abs[10]
+ in[9]=det_abs[9] in[8]=det_abs[8] in[7]=det_abs[7] in[6]=det_abs[6]
+ in[5]=det_abs[5] in[4]=det_abs[4] in[3]=det_abs[3] in[2]=det_abs[2]
+ in[1]=det_abs[1] in[0]=det[0] pos[5]=SYNOPSYS_UNCONNECTED__1
+ pos[4]=FE_OFN4144_div_pos_4 pos[3]=div_pos[3] pos[2]=div_pos[2]
+ pos[1]=div_pos[1] pos[0]=div_pos[0] valid=div_valid
XH1 Harris_width8 $PINS Ix2[15]=FE_OFN1188_FE_DBTN21_Ix2_shift_15
+ Ix2[14]=FE_OFN1184_FE_DBTN26_Ix2_shift_14 Ix2[13]=FE_OFN959_Ix2_shift_13
+ Ix2[12]=FE_OFN1505_FE_DBTN20_Ix2_shift_12 Ix2[11]=FE_OFN1230_n3259
+ Ix2[10]=FE_OFN1259_Ix2_shift_10 Ix2[9]=FE_OFN4178_FE_OFN1263_Ix2_shift_9
+ Ix2[8]=FE_OFN4351_Ix2_shift_8 Ix2[7]=Ix2_shift[7] Ix2[6]=n1641
+ Ix2[5]=Ix2_shift[5] Ix2[4]=FE_DBTN31_Ix2_shift_4 Ix2[3]=FE_OFN1608_Ix2_shift_3
+ Ix2[2]=Ix2_shift[2] Ix2[1]=FE_OFN830_Ix2_shift_1 Ix2[0]=FE_OFN832_Ix2_shift_0
+ Iy2[15]=FE_OFN1088_Iy2_shift_15 Iy2[14]=FE_OFN1181_FE_DBTN27_Iy2_shift_14
+ Iy2[13]=FE_OFN963_Iy2_shift_13 Iy2[12]=Iy2_shift[12]
+ Iy2[11]=FE_OFN1294_Iy2_shift_11 Iy2[10]=FE_OFN1299_Iy2_shift_10
+ Iy2[9]=FE_OFN1552_Iy2_shift_9 Iy2[8]=FE_OFN4349_n Iy2[7]=Iy2_shift[7]
+ Iy2[6]=FE_OFN1316_Iy2_shift_6 Iy2[5]=FE_DBTN42_n4486 Iy2[4]=n1626
+ Iy2[3]=FE_DBTN38_n1438 Iy2[2]=FE_OFN1318_Iy2_shift_2
+ Iy2[1]=FE_OFN837_Iy2_shift_1 Iy2[0]=FE_OFN843_Iy2_shift_0 det[32]=n1441
+ det[31]=det[31] det[30]=det[30] det[29]=det[29] det[28]=det[28] det[27]=det[27]
+ det[26]=det[26] det[25]=det[25] det[24]=det[24] det[23]=det[23] det[22]=det[22]
+ det[21]=det[21] det[20]=det[20] det[19]=det[19] det[18]=det[18] det[17]=det[17]
+ det[16]=det[16] det[15]=det[15] det[14]=det[14] det[13]=det[13] det[12]=det[12]
+ det[11]=det[11] det[10]=det[10] det[9]=det[9] det[8]=det[8] det[7]=det[7]
+ det[6]=det[6] det[5]=det[5] det[4]=det[4] det[3]=det[3] det[2]=det[2]
+ det[1]=det[1] det[0]=det[0] clk=CTS_135 rst_n=FE_OFN0_i_reset_n_i corner=corner
+ IN0=n4365 FE_OFN110_i_reset_n_i=FE_OFN252_i_reset_n_i
+ FE_OFN97_i_reset_n_i=FE_OFN217_i_reset_n_i
+ FE_OFN76_i_reset_n_i=FE_OFN166_i_reset_n_i
+ FE_OFN16_i_reset_n_i=FE_OFN45_i_reset_n_i
+ FE_OFN14_i_reset_n_i=FE_OFN44_i_reset_n_i
+ FE_OFN5_i_reset_n_i=FE_OFN22_i_reset_n_i
+ FE_OFN2_i_reset_n_i=FE_OFN18_i_reset_n_i
+ FE_OFN1_i_reset_n_i=FE_OFN7_i_reset_n_i FE_OFN0_i_reset_n_i=FE_OFN4_i_reset_n_i
+ clk_clone4=CTS_128 clk_clone3=CTS_129 clk_clone2=CTS_131 clk_clone1=CTS_132
XIx2_reg[11] QDFFRBN $PINS Q=Ix2[11] D=n1198 CK=CTS_119 RB=FE_OFN32_i_reset_n_i
XIx2_reg[4] QDFFRBN $PINS Q=Ix2[4] D=n1205 CK=CTS_119 RB=FE_OFN236_i_reset_n_i
Xrow_reg_reg[1] QDFFRSBN $PINS Q=row_reg[1] D=n1030 CK=CTS_124 RB=n4485
+ SB=FE_OFN199_i_reset_n_i
Ximg1_reg[0][7] QDFFRBS $PINS Q=img1[0][7] D=FE_PHN3037_img1_1_7 CK=CTS_118
+ RB=FE_OFN238_i_reset_n_i
Ximg1_reg[0][6] QDFFRBS $PINS Q=img1[0][6] D=FE_PHN3010_img1_1_6 CK=CTS_118
+ RB=FE_OFN107_i_reset_n_i
Ximg1_reg[0][5] QDFFRBS $PINS Q=img1[0][5] D=FE_PHN3066_img1_1_5 CK=CTS_118
+ RB=FE_OFN12_i_reset_n_i
Ximg1_reg[0][4] QDFFRBS $PINS Q=img1[0][4] D=FE_PHN3034_img1_1_4 CK=CTS_118
+ RB=FE_OFN218_i_reset_n_i
Ximg1_reg[0][3] QDFFRBS $PINS Q=img1[0][3] D=FE_PHN3115_img1_1_3 CK=CTS_118
+ RB=FE_OFN12_i_reset_n_i
Ximg1_reg[13][0] QDFFRBS $PINS Q=FE_PHN3099_img1_13_0 D=FE_PHN3181_a_reg_0
+ CK=CTS_127 RB=FE_OFN64_i_reset_n_i
XUy_reg_reg[31] QDFFRBS $PINS Q=Uy_pad[39] D=Uy[31] CK=CTS_110
+ RB=FE_OFN143_i_reset_n_i
XUy_reg_reg[16] QDFFRBS $PINS Q=Uy_pad[24] D=Uy[16] CK=CTS_111
+ RB=FE_OFN93_i_reset_n_i
XUy_reg_reg[1] QDFFRBS $PINS Q=Uy_pad[9] D=Uy[1] CK=CTS_111
+ RB=FE_OFN136_i_reset_n_i
XUx_reg_reg[27] QDFFRBS $PINS Q=Ux_pad[35] D=Ux[27] CK=CTS_106
+ RB=FE_OFN150_i_reset_n_i
XUx_reg_reg[12] QDFFRBS $PINS Q=Ux_pad[20] D=Ux[12] CK=CTS_109
+ RB=FE_OFN194_i_reset_n_i
Xdiv_pos_reg_reg[0] QDFFRBS $PINS Q=div_pos_reg[0] D=div_pos[0] CK=CTS_107
+ RB=FE_OFN245_i_reset_n_i
XIt_reg[3][4] QDFFRBS $PINS Q=FE_PHN3231_It_3_4 D=n1241 CK=CTS_115
+ RB=FE_OFN14_i_reset_n_i
XIt_reg[1][1] QDFFRBS $PINS Q=It[1][1] D=n1226 CK=CTS_115
+ RB=FE_OFN161_i_reset_n_i
XIt_reg[0][7] QDFFRBS $PINS Q=It[0][7] D=n1211 CK=CTS_120
+ RB=FE_OFN109_i_reset_n_i
XIxIt_reg[2] QDFFRBS $PINS Q=IxIt[2] D=n1184 CK=CTS_120
+ RB=FE_OFN235_i_reset_n_i
XIxIt_reg[21] QDFFRBS $PINS Q=IxIt[21] D=n1165 CK=CTS_119
+ RB=FE_OFN202_i_reset_n_i
XIyIt_reg[0] QDFFRBS $PINS Q=IyIt[0] D=n1117 CK=CTS_120
+ RB=FE_OFN110_i_reset_n_i
XIyIt_reg[16] QDFFRBN $PINS Q=IyIt[16] D=n1101 CK=CTS_120
+ RB=FE_OFN203_i_reset_n_i
XIx_reg[4][2] QDFFRBS $PINS Q=Ix[4][2] D=n1073 CK=CTS_114
+ RB=FE_OFN268_i_reset_n_i
XIx_reg[3][8] QDFFRBS $PINS Q=Ix[3][8] D=n1058 CK=CTS_114
+ RB=FE_OFN209_i_reset_n_i
XIx_reg[1][5] QDFFRBS $PINS Q=Ix[1][5] D=n1043 CK=CTS_114
+ RB=FE_OFN160_i_reset_n_i
Xdiv_pos_reg_reg[3] QDFFRBS $PINS Q=div_pos_reg[3] D=div_pos[3] CK=CTS_107
+ RB=FE_OFN97_i_reset_n_i
XIxIt_reg[20] QDFFRBS $PINS Q=IxIt[20] D=n1166 CK=CTS_119
+ RB=FE_OFN155_i_reset_n_i
XIxIy_reg[8] QDFFRBN $PINS Q=IxIy[8] D=n1132 CK=CTS_124
+ RB=FE_OFN153_i_reset_n_i
XU3742 NR2 $PINS O=n3244 I1=n2673 I2=n2672
XU2543 NR2P $PINS O=n1701 I1=n1474 I2=n4091
XU1451 ND2S $PINS O=n2809 I1=n2451 I2=n2450
XU1465 ND2S $PINS O=n2661 I1=n3909 I2=n3907
XU1469 NR2 $PINS O=n3913 I1=n3132 I2=n3130
XU1472 ND2S $PINS O=n3140 I1=n3918 I2=n3916
XU1479 ND2S $PINS O=n3234 I1=n2481 I2=n2480
XU1480 ND2S $PINS O=n3195 I1=n2506 I2=n2505
XU1485 ND2S $PINS O=n3929 I1=n3925 I2=n3924
XU1487 ND2S $PINS O=n4262 I1=It[0][4] I2=FE_OFN1750_n4113
XU1494 ND2 $PINS O=n3610 I1=n2830 I2=n2829
XU1503 ND2S $PINS O=n2678 I1=IyIt[22] I2=FE_OFN604_shift_amount_reg_3
XU1506 ND2P $PINS O=IyIt_shift[6] I1=n2827 I2=n2826
XU1508 ND2S $PINS O=n3222 I1=n3221 I2=FE_DBTN2_n2466
XU1515 ND2 $PINS O=IxIt_shift[6] I1=n2463 I2=n2462
XU1521 ND2S $PINS O=n4107 I1=FE_OFN677_FE_DBTN46_intadd_14_SUM_4
+ I2=FE_OFN4139_intadd_14_SUM_1
XU1527 ND2 $PINS O=IxIt_shift[5] I1=n2509 I2=n2508
XU1530 ND2P $PINS O=IxIy_shift[6] I1=n2280 I2=n2279
XU1533 ND2S $PINS O=n2613 I1=n2840 I2=FE_OFN1574_n1710
XU1536 ND2 $PINS O=n1653 I1=n2280 I2=n2279
XU1539 ND2 $PINS O=Ix2_shift[5] I1=n2496 I2=n2495
XU1542 ND2 $PINS O=n3622 I1=n2710 I2=n2709
XU1544 ND2S $PINS O=n3245 I1=n3244 I2=FE_OFN954_n4489
XU1547 ND2 $PINS O=Ix2_shift[6] I1=n3632 I2=n3631
XU1550 ND2 $PINS O=n3173 I1=n2688 I2=n2687
XU1557 ND2S $PINS O=n2684 I1=n2592 I2=n2591
XU1560 ND2 $PINS O=n3177 I1=n2915 I2=n2914
XU1561 ND2S $PINS O=n3120 I1=FE_OFN678_FE_DBTN45_intadd_21_SUM_1 I2=n4339
XU1566 ND2S $PINS O=n2099 I1=FE_OFN685_FE_DBTN32_div_pos_reg_3
+ I2=FE_OFN616_div_pos_reg_2
XU1569 ND2T $PINS O=n2053 I1=corner I2=div_valid
XU1572 ND2S $PINS O=n2869 I1=n2868 I2=FE_OFN4347_n
XU1574 ND2S $PINS O=n2554 I1=IxIy[22] I2=FE_OFN603_shift_amount_reg_3
XU1575 ND2 $PINS O=n2854 I1=n2742 I2=n2741
XU1580 ND2S $PINS O=n1627 I1=n1720 I2=n1719
XU1581 ND2 $PINS O=n3118 I1=n2658 I2=n2657
XU1583 AN3 $PINS O=Ix2_shift[3] I1=n3139 I2=n3138 I3=n3137
XU1584 ND2 $PINS O=Iy2_shift[13] I1=n2610 I2=n2609
XU1587 ND2S $PINS O=n2813 I1=n1708 I2=n1707
XU1589 ND2S $PINS O=intadd_33/A[2] I1=FE_OFN421_intadd_14_n1 I2=FE_OFN950_n4268
XU1590 ND2S $PINS O=n3949 I1=FE_OFN4136_n4336 I2=FE_DBTN45_intadd_21_SUM_1
XU1592 ND2S $PINS O=n2107 I1=FE_OFN607_div_pos_reg_4 I2=n1927
XU1593 ND2S $PINS O=n3039 I1=Ix[0][1] I2=FE_OFN393_intadd_14_SUM_6
XU1595 ND2S $PINS O=n2855 I1=n2738 I2=n2737
XU1598 ND2 $PINS O=Ix2_shift[8] I1=n2702 I2=n2701
XU1604 ND2S $PINS O=IxIt_shift[8] I1=n2601 I2=n2600
XU1610 ND2S $PINS O=n3800 I1=n2230 I2=Ix2_Iy2[30]
XU1613 ND2S $PINS O=n1652 I1=n2280 I2=n2279
XU1616 ND2 $PINS O=Ix2_shift[7] I1=n2660 I2=n2659
XU1619 ND2S $PINS O=n2947 I1=n2498 I2=n3872
XU1622 ND2S $PINS O=n2843 I1=n2842 I2=n2841
XU1625 ND2S $PINS O=n2735 I1=Iy2[19] I2=n2733
XU1628 ND2S $PINS O=n3976 I1=FE_OFN534_Ix2_19 I2=n2846
XU1631 ND2S $PINS O=n3595 I1=n3312 I2=n3311
XU1640 ND2S $PINS O=n2949 I1=n2948 I2=n2947
XU1642 AO222 $PINS O=n1080 A1=n3860 A2=FE_OFN1628_n3867 B1=n3859
+ B2=FE_OFN802_n3869 C1=n3861 C2=Vout[9]
XU1643 TIE1 $PINS O=n4485
XU1646 OR2 $PINS O=n4483 I1=shift_amount_reg[0] I2=n2348
XU1651 AN3 $PINS O=n4484 I1=n3247 I2=n3246 I3=n3245
XU1652 AN2 $PINS O=n4486 I1=n2524 I2=n2523
XU1659 AN2 $PINS O=n4487 I1=n2686 I2=n2685
XU1662 OA112 $PINS O=n4488 A1=n3280 B1=n3279 C1=n3818
+ C2=FE_OFN1028_FE_DBTN41_n4489
XU1675 NR2P $PINS O=n4489 I1=n1718 I2=FE_OFN682_FE_DBTN33_shift_amount_reg_3
.ENDS

.SUBCKT CHIP clk rst_n a[7] a[6] a[5] a[4] a[3] a[2] a[1] a[0] b[7] b[6] b[5]
+ b[4] b[3] b[2] b[1] b[0] valid Vout[11] Vout[10] Vout[9] Vout[8] Vout[7]
+ Vout[6] Vout[5] Vout[4] Vout[3] Vout[2] Vout[1] Vout[0]
XFE_OFC384_n_logic1 BUF1 $PINS O=FE_OFN386_n_logic1 I=FE_OFN385_n_logic1
XFE_OFC383_n_logic1 BUF1 $PINS O=FE_OFN385_n_logic1 I=n_logic1
XFE_OFC382_n_logic0 BUF1 $PINS O=FE_OFN384_n_logic0 I=FE_OFN383_n_logic0
XFE_OFC381_n_logic0 BUF1 $PINS O=FE_OFN383_n_logic0 I=FE_OFN382_n_logic0
XFE_OFC380_n_logic0 BUF1 $PINS O=FE_OFN382_n_logic0 I=FE_OFN380_n_logic0
XFE_OFC379_n_logic0 BUF1 $PINS O=FE_OFN381_n_logic0 I=FE_OFN379_n_logic0
XFE_OFC378_n_logic0 BUF1 $PINS O=FE_OFN380_n_logic0 I=FE_OFN378_n_logic0
XFE_OFC377_n_logic0 BUF1 $PINS O=FE_OFN379_n_logic0 I=FE_OFN377_n_logic0
XFE_OFC376_n_logic0 BUF1 $PINS O=FE_OFN378_n_logic0 I=FE_OFN376_n_logic0
XFE_OFC375_n_logic0 BUF1 $PINS O=FE_OFN377_n_logic0 I=FE_OFN375_n_logic0
XFE_OFC374_n_logic0 BUF1 $PINS O=FE_OFN376_n_logic0 I=FE_OFN374_n_logic0
XFE_OFC373_n_logic0 BUF1 $PINS O=FE_OFN375_n_logic0 I=FE_OFN373_n_logic0
XFE_OFC372_n_logic0 BUF1 $PINS O=FE_OFN374_n_logic0 I=FE_OFN372_n_logic0
XFE_OFC371_n_logic0 BUF1 $PINS O=FE_OFN373_n_logic0 I=FE_OFN371_n_logic0
XFE_OFC370_n_logic0 BUF1 $PINS O=FE_OFN372_n_logic0 I=FE_OFN370_n_logic0
XFE_OFC369_n_logic0 BUF1 $PINS O=FE_OFN371_n_logic0 I=FE_OFN369_n_logic0
XFE_OFC368_n_logic0 BUF1 $PINS O=FE_OFN370_n_logic0 I=FE_OFN368_n_logic0
XFE_OFC367_n_logic0 BUF1 $PINS O=FE_OFN369_n_logic0 I=FE_OFN367_n_logic0
XFE_OFC366_n_logic0 BUF1 $PINS O=FE_OFN368_n_logic0 I=FE_OFN366_n_logic0
XFE_OFC365_n_logic0 BUF1 $PINS O=FE_OFN367_n_logic0 I=FE_OFN364_n_logic0
XFE_OFC364_n_logic0 INV1S $PINS O=FE_OFN366_n_logic0 I=FE_OFN362_n_logic0
XFE_OFC363_n_logic0 INV1S $PINS O=FE_OFN365_n_logic0 I=FE_OFN362_n_logic0
XFE_OFC362_n_logic0 BUF1 $PINS O=FE_OFN364_n_logic0 I=n_logic0
XFE_OFC361_n_logic0 BUF1 $PINS O=FE_OFN363_n_logic0 I=n_logic0
XFE_OFC360_n_logic0 INV1S $PINS O=FE_OFN362_n_logic0 I=n_logic0
XLK_in LK $PINS clk=i_clk_p_i rst_n=i_reset_n_i a[7]=i_data_a_i[7]
+ a[6]=i_data_a_i[6] a[5]=i_data_a_i[5] a[4]=i_data_a_i[4] a[3]=i_data_a_i[3]
+ a[2]=i_data_a_i[2] a[1]=i_data_a_i[1] a[0]=i_data_a_i[0] b[7]=i_data_b_i[7]
+ b[6]=i_data_b_i[6] b[5]=i_data_b_i[5] b[4]=i_data_b_i[4] b[3]=i_data_b_i[3]
+ b[2]=i_data_b_i[2] b[1]=i_data_b_i[1] b[0]=i_data_b_i[0] valid=i_valid_o
+ Vout[11]=i_data_o[11] Vout[10]=i_data_o[10] Vout[9]=i_data_o[9]
+ Vout[8]=i_data_o[8] Vout[7]=i_data_o[7] Vout[6]=i_data_o[6] Vout[5]=i_data_o[5]
+ Vout[4]=i_data_o[4] Vout[3]=i_data_o[3] Vout[2]=i_data_o[2] Vout[1]=i_data_o[1]
+ Vout[0]=i_data_o[0]
Xipad_n_logic0 TIE0 $PINS O=n_logic0
Xipad_n_logic1 TIE1 $PINS O=n_logic1
Xipad_clk_p_i XMD $PINS O=i_clk_p_i I=clk PU=FE_OFN384_n_logic0
+ PD=FE_OFN384_n_logic0 SMT=FE_OFN384_n_logic0
Xipad_reset_n_i XMD $PINS O=i_reset_n_i I=rst_n PU=FE_OFN384_n_logic0
+ PD=FE_OFN384_n_logic0 SMT=FE_OFN384_n_logic0
Xipad_data_a_i_0 XMD $PINS O=i_data_a_i[0] I=a[0] PU=FE_OFN381_n_logic0
+ PD=FE_OFN381_n_logic0 SMT=FE_OFN381_n_logic0
Xipad_data_a_i_1 XMD $PINS O=i_data_a_i[1] I=a[1] PU=FE_OFN381_n_logic0
+ PD=FE_OFN381_n_logic0 SMT=FE_OFN381_n_logic0
Xipad_data_a_i_2 XMD $PINS O=i_data_a_i[2] I=a[2] PU=FE_OFN379_n_logic0
+ PD=FE_OFN379_n_logic0 SMT=FE_OFN379_n_logic0
Xipad_data_a_i_3 XMD $PINS O=i_data_a_i[3] I=a[3] PU=FE_OFN379_n_logic0
+ PD=FE_OFN379_n_logic0 SMT=FE_OFN377_n_logic0
Xipad_data_a_i_4 XMD $PINS O=i_data_a_i[4] I=a[4] PU=FE_OFN377_n_logic0
+ PD=FE_OFN377_n_logic0 SMT=FE_OFN377_n_logic0
Xipad_data_a_i_5 XMD $PINS O=i_data_a_i[5] I=a[5] PU=FE_OFN383_n_logic0
+ PD=FE_OFN383_n_logic0 SMT=FE_OFN383_n_logic0
Xipad_data_a_i_6 XMD $PINS O=i_data_a_i[6] I=a[6] PU=FE_OFN383_n_logic0
+ PD=FE_OFN382_n_logic0 SMT=FE_OFN383_n_logic0
Xipad_data_a_i_7 XMD $PINS O=i_data_a_i[7] I=a[7] PU=FE_OFN382_n_logic0
+ PD=FE_OFN382_n_logic0 SMT=FE_OFN382_n_logic0
Xipad_data_b_i_0 XMD $PINS O=i_data_b_i[0] I=b[0] PU=FE_OFN380_n_logic0
+ PD=FE_OFN380_n_logic0 SMT=FE_OFN382_n_logic0
Xipad_data_b_i_1 XMD $PINS O=i_data_b_i[1] I=b[1] PU=FE_OFN380_n_logic0
+ PD=FE_OFN380_n_logic0 SMT=FE_OFN380_n_logic0
Xipad_data_b_i_2 XMD $PINS O=i_data_b_i[2] I=b[2] PU=FE_OFN378_n_logic0
+ PD=FE_OFN378_n_logic0 SMT=FE_OFN378_n_logic0
Xipad_data_b_i_3 XMD $PINS O=i_data_b_i[3] I=b[3] PU=FE_OFN378_n_logic0
+ PD=FE_OFN376_n_logic0 SMT=FE_OFN378_n_logic0
Xipad_data_b_i_4 XMD $PINS O=i_data_b_i[4] I=b[4] PU=FE_OFN376_n_logic0
+ PD=FE_OFN376_n_logic0 SMT=FE_OFN376_n_logic0
Xipad_data_b_i_5 XMD $PINS O=i_data_b_i[5] I=b[5] PU=FE_OFN374_n_logic0
+ PD=FE_OFN374_n_logic0 SMT=FE_OFN376_n_logic0
Xipad_data_b_i_6 XMD $PINS O=i_data_b_i[6] I=b[6] PU=FE_OFN374_n_logic0
+ PD=FE_OFN374_n_logic0 SMT=FE_OFN374_n_logic0
Xipad_data_b_i_7 XMD $PINS O=i_data_b_i[7] I=b[7] PU=FE_OFN372_n_logic0
+ PD=FE_OFN372_n_logic0 SMT=FE_OFN372_n_logic0
Xipad_data_o_0 YA2GSD $PINS O=Vout[0] I=i_data_o[0] E=FE_OFN386_n_logic1
+ E2=FE_OFN370_n_logic0 E4=FE_OFN370_n_logic0 E8=FE_OFN370_n_logic0
+ SR=FE_OFN368_n_logic0
Xipad_data_o_1 YA2GSD $PINS O=Vout[1] I=i_data_o[1] E=FE_OFN386_n_logic1
+ E2=FE_OFN368_n_logic0 E4=FE_OFN368_n_logic0 E8=FE_OFN368_n_logic0
+ SR=FE_OFN368_n_logic0
Xipad_data_o_2 YA2GSD $PINS O=Vout[2] I=i_data_o[2] E=FE_OFN386_n_logic1
+ E2=FE_OFN366_n_logic0 E4=FE_OFN366_n_logic0 E8=FE_OFN366_n_logic0
+ SR=FE_OFN366_n_logic0
Xipad_data_o_3 YA2GSD $PINS O=Vout[3] I=i_data_o[3] E=FE_OFN386_n_logic1
+ E2=FE_OFN365_n_logic0 E4=FE_OFN365_n_logic0 E8=FE_OFN365_n_logic0
+ SR=FE_OFN365_n_logic0
Xipad_data_o_4 YA2GSD $PINS O=Vout[4] I=i_data_o[4] E=FE_OFN386_n_logic1
+ E2=FE_OFN363_n_logic0 E4=FE_OFN363_n_logic0 E8=FE_OFN363_n_logic0
+ SR=FE_OFN363_n_logic0
Xipad_data_o_5 YA2GSD $PINS O=Vout[5] I=i_data_o[5] E=FE_OFN385_n_logic1
+ E2=n_logic0 E4=n_logic0 E8=n_logic0 SR=FE_OFN364_n_logic0
Xipad_data_o_6 YA2GSD $PINS O=Vout[6] I=i_data_o[6] E=FE_OFN385_n_logic1
+ E2=FE_OFN364_n_logic0 E4=FE_OFN364_n_logic0 E8=FE_OFN364_n_logic0
+ SR=FE_OFN367_n_logic0
Xipad_data_o_7 YA2GSD $PINS O=Vout[7] I=i_data_o[7] E=FE_OFN385_n_logic1
+ E2=FE_OFN367_n_logic0 E4=FE_OFN367_n_logic0 E8=FE_OFN367_n_logic0
+ SR=FE_OFN369_n_logic0
Xipad_data_o_8 YA2GSD $PINS O=Vout[8] I=i_data_o[8] E=FE_OFN385_n_logic1
+ E2=FE_OFN369_n_logic0 E4=FE_OFN369_n_logic0 E8=FE_OFN369_n_logic0
+ SR=FE_OFN371_n_logic0
Xipad_data_o_9 YA2GSD $PINS O=Vout[9] I=i_data_o[9] E=FE_OFN385_n_logic1
+ E2=FE_OFN371_n_logic0 E4=FE_OFN371_n_logic0 E8=FE_OFN371_n_logic0
+ SR=FE_OFN373_n_logic0
Xipad_data_o_10 YA2GSD $PINS O=Vout[10] I=i_data_o[10] E=n_logic1
+ E2=FE_OFN373_n_logic0 E4=FE_OFN373_n_logic0 E8=FE_OFN373_n_logic0
+ SR=FE_OFN375_n_logic0
Xipad_data_o_11 YA2GSD $PINS O=Vout[11] I=i_data_o[11] E=n_logic1
+ E2=FE_OFN375_n_logic0 E4=FE_OFN375_n_logic0 E8=FE_OFN375_n_logic0
+ SR=FE_OFN377_n_logic0
Xipad_valid_o YA2GSD $PINS O=valid I=i_valid_o E=FE_OFN386_n_logic1
+ E2=FE_OFN372_n_logic0 E4=FE_OFN370_n_logic0 E8=FE_OFN372_n_logic0
+ SR=FE_OFN370_n_logic0
.ENDS
